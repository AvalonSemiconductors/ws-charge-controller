* NGSPICE file created from opamp_smol.ext - technology: gf180mcuD

.subckt opamp_smol_f VDD VSS MINUS PLUS OUT
X0 VDD a_4672_2093# a_4672_2093# VDD pfet_06v0 ad=1.76p pd=8.88u as=1.76p ps=8.88u w=4u l=1.1u
X1 VDD a_4672_2093# a_5357_1365# VDD pfet_06v0 ad=3.52p pd=16.88u as=3.52p ps=16.88u w=8u l=1.1u
X2 a_6533_1057# a_5357_1057# VSS VSS.t0 nfet_06v0 ad=1.32p pd=6.88u as=1.32p ps=6.88u w=3u l=1.4u
X3 a_4672_2093# VSS VSS.t2 ppolyf_u_1k_6p0 r_width=1u r_length=11u
X4 VDD a_4672_2093# OUT VDD pfet_06v0 ad=3.52p pd=16.88u as=3.52p ps=16.88u w=8u l=1.1u
X5 a_5357_1365# MINUS a_5357_1057# VDD pfet_06v0 ad=1.76p pd=8.88u as=1.76p ps=8.88u w=4u l=1.1u
X6 OUT a_6533_1057# VSS VSS.t3 nfet_06v0 ad=3.52p pd=16.88u as=3.52p ps=16.88u w=8u l=1.4u
X7 a_5357_1365# PLUS a_6533_1057# VDD pfet_06v0 ad=1.76p pd=8.88u as=1.76p ps=8.88u w=4u l=1.1u
X8 OUT a_6533_1057# cap_mim_2f0_m4m5_noshield c_width=5u c_length=5u
X9 a_5357_1057# a_5357_1057# VSS VSS.t0 nfet_06v0 ad=1.32p pd=6.88u as=1.32p ps=6.88u w=3u l=1.4u
R0 VSS.n8 VSS 1165.71
R1 VSS.n4 VSS.t3 500.503
R2 VSS VSS.t3 500.229
R3 VSS.n7 VSS.n6 440.301
R4 VSS.n0 VSS.t0 349.329
R5 VSS.t0 VSS.n8 255.758
R6 VSS.n7 VSS 105.778
R7 VSS.n8 VSS.t2 93.5706
R8 VSS.n4 VSS.n3 81.6238
R9 VSS.n5 VSS.n1 81.5886
R10 VSS.n6 VSS.n2 56.8341
R11 VSS VSS.n7 47.4449
R12 VSS VSS.n5 47.4449
R13 VSS.n5 VSS 47.4449
R14 VSS VSS.n2 46.1362
R15 VSS.n6 VSS 41.8061
R16 VSS.n3 VSS.n2 37.3691
R17 VSS VSS.n3 36.4168
R18 VSS VSS.n4 1.89702
R19 VSS VSS.n1 1.84673
R20 VSS.t2 VSS 1.43835
R21 VSS VSS.n1 0.936947
R22 VSS.n0 VSS 1.15606
R23 VSS VSS.n0 1.15606
C0 a_5357_1057# a_4672_2093# 0.03677f
C1 a_5357_1057# VDD 0.59606f
C2 MINUS a_5357_1365# 0.09876f
C3 PLUS a_5357_1057# 0.05935f
C4 MINUS a_4672_2093# 0.04028f
C5 MINUS VDD 0.6829f
C6 a_5357_1365# a_6533_1057# 0.14661f
C7 a_6533_1057# OUT 1.52091f
C8 a_6533_1057# a_4672_2093# 0.07644f
C9 a_6533_1057# VDD 0.8489f
C10 a_5357_1365# OUT 0.00868f
C11 a_5357_1365# a_4672_2093# 0.86973f
C12 a_5357_1365# VDD 2.89805f
C13 MINUS PLUS 0.30776f
C14 OUT a_4672_2093# 1.03656f
C15 VDD OUT 1.64756f
C16 VDD a_4672_2093# 6.12815f
C17 PLUS a_6533_1057# 0.13005f
C18 MINUS a_5357_1057# 0.09206f
C19 a_5357_1365# PLUS 0.33863f
C20 a_5357_1057# a_6533_1057# 0.13955f
C21 PLUS OUT 0.0039f
C22 PLUS a_4672_2093# 0.06074f
C23 PLUS VDD 0.8019f
C24 a_5357_1365# a_5357_1057# 0.13302f
C25 PLUS VSS 0.20379f
C26 MINUS VSS 0.10964f
C27 OUT VSS 2.45735f
C28 VDD VSS 26.1882f
C29 a_6533_1057# VSS 3.34593f
C30 a_5357_1057# VSS 1.90234f
C31 a_5357_1365# VSS 0.07377f
C32 a_4672_2093# VSS 1.12151f
.ends
