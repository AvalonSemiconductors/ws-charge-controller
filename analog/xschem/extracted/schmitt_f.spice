* NGSPICE file created from schmitt.ext - technology: gf180mcuD

.subckt schmitt_f VDD VSS A Y
X0 VSS Y a_1956_1601# VDD pfet_06v0 ad=0.88p pd=4.88u as=0.88p ps=4.88u w=2u l=0.55u
X1 VDD Y a_1180_230# VSS.t0 nfet_06v0 ad=0.88p pd=4.88u as=0.88p ps=4.88u w=2u l=0.7u
X2 a_1180_230# A VSS VSS.t1 nfet_06v0 ad=1.76p pd=8.88u as=1.76p ps=8.88u w=4u l=0.7u
X3 a_1150_1601# A VDD VDD pfet_06v0 ad=1.76p pd=8.88u as=1.76p ps=8.88u w=4u l=0.55u
X4 Y A a_1180_230# VSS.t2 nfet_06v0 ad=1.76p pd=8.88u as=1.76p ps=8.88u w=4u l=0.7u
X5 Y A a_1150_1601# VDD pfet_06v0 ad=1.76p pd=8.88u as=1.76p ps=8.88u w=4u l=0.55u
R0 VSS.t1 VSS.t2 1261.12
R1 VSS.n3 VSS.t0 631.306
R2 VSS.n0 VSS.t1 631.034
R3 VSS.t2 VSS 630.562
R4 VSS VSS.t0 630.562
R5 VSS.n4 VSS.n1 119.171
R6 VSS.n2 VSS.n1 87.2823
R7 VSS.n4 VSS.n3 85.9449
R8 VSS.n3 VSS.n2 85.9449
R9 VSS VSS.n2 53.6672
R10 VSS.n0 VSS.n1 34.9159
R11 VSS VSS.n4 14.7783
R12 VSS.n3 VSS 2.12465
R13 VSS VSS.n0 1.40498
C0 a_1956_1601# A 0.04753f
C1 a_1150_1601# Y 0.26549f
C2 a_1956_1601# VDD 0.48278f
C3 VDD A 0.84511f
C4 a_1956_1601# Y 0.17528f
C5 a_1150_1601# a_1956_1601# 0.13792f
C6 a_1180_230# A 0.21716f
C7 Y A 0.34552f
C8 a_1180_230# VDD 0.10737f
C9 Y VDD 1.32383f
C10 a_1150_1601# A 0.13547f
C11 a_1150_1601# VDD 0.67803f
C12 a_1180_230# Y 0.32f
C13 Y VSS 1.28897f
C14 A VSS 1.10772f
C15 VDD VSS 10.6589f
C16 a_1180_230# VSS 1.17137f
C17 a_1956_1601# VSS 0.30245f
C18 a_1150_1601# VSS 0
.ends
