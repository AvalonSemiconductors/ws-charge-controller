* NGSPICE file created from adjref_f.ext - technology: gf180mcuD

.subckt adjref_f VDD VSS R K
X0 a_8938_3211# VSS VSS.t10 ppolyf_u_1k_6p0 r_width=1u r_length=11u
D0 a_2682_714# VSS.t18 diode_pd2nw_06v0 pj=12u area=5p
X1 a_1480_2431# a_1528_1286# a_1560_714# VSS.t0 nfet_06v0 ad=4.4p pd=20.88u as=4.4p ps=20.88u w=10u l=2.5u
X2 a_1560_714# a_2682_714# VSS ppolyf_u_1k_6p0 r_width=1u r_length=5u
X3 VDD a_8938_3211# a_9623_2483# VDD pfet_06v0 ad=3.52p pd=16.88u as=3.52p ps=16.88u w=8u l=1.1u
X4 a_9623_2175# a_9623_2175# VSS VSS.t2 nfet_06v0 ad=1.32p pd=6.88u as=1.32p ps=6.88u w=3u l=1.4u
X5 VDD a_1480_2431# a_1480_2431# VDD pfet_06v0 ad=4.4p pd=20.88u as=4.4p ps=20.88u w=10u l=5u
X6 VDD a_1480_2431# x2.VREF VDD pfet_06v0 ad=4.4p pd=20.88u as=4.4p ps=20.88u w=10u l=5u
X7 a_1528_1286# a_1528_1286# a_3948_1198# VSS.t1 nfet_06v0 ad=4.4p pd=20.88u as=4.4p ps=20.88u w=10u l=2.5u
X8 x1.OUT a_10799_2175# VSS VSS nfet_06v0 ad=3.52p pd=16.88u as=3.52p ps=16.88u w=8u l=1.4u
X9 a_10799_2175# a_9623_2175# VSS VSS.t3 nfet_06v0 ad=1.32p pd=6.88u as=1.32p ps=6.88u w=3u l=1.4u
X10 K x1.OUT VSS VSS.t4 nfet_06v0 ad=1.04p pd=4.52u as=1.76p ps=8.88u w=4u l=0.7u
D1 a_3948_1198# VSS diode_pd2nw_06v0 pj=12u area=5p
D2 VSS.t6 x1.OUT diode_nd2ps_06v0 pj=8u area=4p
X11 VDD a_1480_2431# a_1528_1286# VDD pfet_06v0 ad=4.4p pd=20.88u as=4.4p ps=20.88u w=10u l=5u
D3 a_6312_1606# VSS.t8 diode_pd2nw_06v0 pj=12u area=5p
X12 x1.OUT a_10799_2175# cap_mim_2f0_m4m5_noshield c_width=5u c_length=5u
X13 VDD a_8938_3211# a_8938_3211# VDD pfet_06v0 ad=1.76p pd=8.88u as=1.76p ps=8.88u w=4u l=1.1u
X14 a_6312_1606# x2.VREF VSS.t15 ppolyf_u_1k_6p0 r_width=1u r_length=5u
X15 VSS x1.OUT K VSS.t5 nfet_06v0 ad=1.76p pd=8.88u as=1.04p ps=4.52u w=4u l=0.7u
X16 a_9623_2483# R a_10799_2175# VDD pfet_06v0 ad=1.76p pd=8.88u as=1.76p ps=8.88u w=4u l=1.1u
D4 R x1.OUT diode_pd2nw_06v0 pj=1.8u area=0.2025p
X17 a_9623_2483# x2.VREF a_9623_2175# VDD pfet_06v0 ad=1.76p pd=8.88u as=1.76p ps=8.88u w=4u l=1.1u
X18 VDD a_8938_3211# x1.OUT VDD pfet_06v0 ad=3.52p pd=16.88u as=3.52p ps=16.88u w=8u l=1.1u
R0 VSS.n4 VSS.n2 12344
R1 VSS.n37 VSS.n2 11823.7
R2 VSS.n37 VSS.n36 11009.3
R3 VSS.n30 VSS.n29 9985.58
R4 VSS.n5 VSS.n37 4152.78
R5 VSS.n38 VSS.n5 4152.78
R6 VSS.n2 VSS 4152.78
R7 VSS.n38 VSS 4152.78
R8 VSS.n29 VSS.n28 2648.15
R9 VSS.n8 VSS.t3 2515.9
R10 VSS.n36 VSS.n12 1546.33
R11 VSS.n28 VSS 1229.94
R12 VSS.n30 VSS.t10 1059.4
R13 VSS.n28 VSS.n10 1008.62
R14 VSS.n4 VSS.n3 1.75642
R15 VSS.t0 VSS 595.42
R16 VSS.n9 VSS.t2 588.941
R17 VSS.t0 VSS 1.6657
R18 VSS.t2 VSS.t3 472.791
R19 VSS.n3 VSS.n12 287.291
R20 VSS.n25 VSS.t4 279.382
R21 VSS.n10 VSS.n11 1.21465
R22 VSS.t6 VSS.t5 200.806
R23 VSS.t15 VSS.n20 200.083
R24 VSS.n35 VSS.n4 186.279
R25 VSS.n34 VSS.n33 178.112
R26 VSS.n4 VSS.n1 169.587
R27 VSS VSS.n38 165.107
R28 VSS.n36 VSS 157.612
R29 VSS.n35 VSS.n34 152.445
R30 VSS.n20 VSS.n16 147.879
R31 VSS VSS.n27 146.713
R32 VSS.n27 VSS.t5 144.056
R33 VSS VSS.n21 131.833
R34 VSS.n14 VSS.n15 129.624
R35 VSS.t1 VSS.t15 123.106
R36 VSS.n31 VSS.n22 120.945
R37 VSS VSS.n15 116.59
R38 VSS.n11 VSS.t3 80.9217
R39 VSS.t0 VSS.n18 115.501
R40 VSS.n20 VSS.n18 115.501
R41 VSS.n21 VSS 92.5561
R42 VSS.n6 VSS.n24 88.5513
R43 VSS.n40 VSS.n18 79.7227
R44 VSS.n33 VSS 77.5838
R45 VSS VSS.n0 66.6949
R46 VSS.t6 VSS.t4 65.4807
R47 VSS.n24 VSS.n23 63.9727
R48 VSS.t10 VSS.n12 57.7861
R49 VSS VSS.n6 83.0067
R50 VSS.n14 VSS.n16 53.1767
R51 VSS VSS.n21 50.9449
R52 VSS VSS.n23 213.798
R53 VSS VSS.n13 47.4449
R54 VSS.n10 VSS.n13 47.4449
R55 VSS.n7 VSS.n13 81.5886
R56 VSS.n8 VSS.n7 0.936947
R57 VSS VSS.n1 42.5838
R58 VSS.n10 VSS.n6 41.8061
R59 VSS.n36 VSS.n14 39.1048
R60 VSS.n36 VSS.t1 37.6565
R61 VSS.t0 VSS.n41 37.4797
R62 VSS VSS.n35 33.8338
R63 VSS VSS.n1 33.8338
R64 VSS.n41 VSS 33.8338
R65 VSS.n34 VSS.n5 33.8338
R66 VSS.n39 VSS.n5 33.8338
R67 VSS.n17 VSS 47.6635
R68 VSS VSS.n0 30.7227
R69 VSS.n40 VSS.n39 28.7297
R70 VSS.n24 VSS.n22 28.4866
R71 VSS.n31 VSS.n23 28.4866
R72 VSS.n41 VSS.n40 28.438
R73 VSS.n26 VSS.n0 27.2227
R74 VSS.n25 VSS.n17 1.40689
R75 VSS.n32 VSS.n16 22.5691
R76 VSS.n39 VSS 14.5838
R77 VSS.n1 VSS.n32 12.8824
R78 VSS VSS.n25 10.9139
R79 VSS.n32 VSS.n15 2.6005
R80 VSS.n32 VSS 2.65078
R81 VSS VSS.n5 2.6005
R82 VSS.n26 VSS 1.98663
R83 VSS.t8 VSS 1.77283
R84 VSS VSS.n9 1.7444
R85 VSS.n3 VSS 1.70711
R86 VSS.n9 VSS.n7 0.936947
R87 VSS VSS.n19 1.65572
R88 VSS.n20 VSS 1.62738
R89 VSS.t18 VSS 1.51887
R90 VSS.n8 VSS 1.48083
R91 VSS.n20 VSS.n19 1.2654
R92 VSS.n17 VSS 1.21935
R93 VSS.n33 VSS 1.16717
R94 VSS.n11 VSS 1.13776
R95 VSS VSS.t6 1.06649
R96 VSS.t0 VSS.n19 1.04874
R97 VSS.n31 VSS.n30 1.0405
R98 VSS VSS.n31 1.0405
R99 VSS.n29 VSS.n22 1.0405
R100 VSS VSS.n22 1.0405
R101 VSS.n27 VSS.n26 1.0405
R102 VSS VSS.n14 1.03868
C0 a_2682_714# a_1528_1286# 0.0341f
C1 a_2682_714# a_1480_2431# 0.00342f
C2 a_6312_1606# a_1528_1286# 0.04671f
C3 x1.OUT a_8938_3211# 1.03953f
C4 a_10799_2175# K 0.01572f
C5 x1.OUT a_9623_2483# 0.01368f
C6 a_3948_1198# a_1560_714# 0
C7 a_6312_1606# a_1480_2431# 0.00755f
C8 VDD a_1560_714# 0.00175f
C9 a_3948_1198# a_2682_714# 0.01245f
C10 x2.VREF a_8938_3211# 0.07645f
C11 a_2682_714# VDD 0.00387f
C12 x2.VREF a_9623_2483# 0.09876f
C13 a_3948_1198# a_6312_1606# 0.03516f
C14 a_9623_2175# a_10799_2175# 0.10299f
C15 R a_1480_2431# 0.06981f
C16 a_6312_1606# VDD 0.01091f
C17 a_9623_2175# R 0.26628f
C18 a_8938_3211# a_9623_2483# 0.86973f
C19 a_10799_2175# VDD 0.8634f
C20 R VDD 1.35494f
C21 a_1480_2431# a_1528_1286# 0.86805f
C22 x2.VREF a_6312_1606# 0.00957f
C23 x1.OUT a_10799_2175# 1.73099f
C24 VDD K 0.01178f
C25 x1.OUT R 0.33626f
C26 a_3948_1198# a_1528_1286# 0.49277f
C27 VDD a_1528_1286# 1.4445f
C28 a_3948_1198# a_1480_2431# 0.00182f
C29 x2.VREF R 0.31799f
C30 a_1480_2431# VDD 10.3708f
C31 x1.OUT K 0.45173f
C32 a_9623_2175# VDD 0.58667f
C33 a_8938_3211# a_10799_2175# 0.07588f
C34 a_2682_714# a_1560_714# 0.01906f
C35 a_9623_2483# a_10799_2175# 0.14661f
C36 a_8938_3211# R 0.18962f
C37 a_9623_2483# R 0.34044f
C38 a_3948_1198# VDD 0.00129f
C39 a_9623_2175# x1.OUT 0.04672f
C40 x2.VREF a_1528_1286# 0
C41 x2.VREF a_1480_2431# 0.44258f
C42 a_9623_2175# x2.VREF 0.09306f
C43 x1.OUT VDD 1.7912f
C44 a_8938_3211# a_1480_2431# 0.00532f
C45 a_9623_2483# a_1480_2431# 0
C46 a_9623_2175# a_8938_3211# 0.03669f
C47 a_9623_2175# a_9623_2483# 0.13302f
C48 x2.VREF VDD 2.61093f
C49 a_1560_714# a_1528_1286# 0.33125f
C50 a_8938_3211# VDD 6.18811f
C51 a_9623_2483# VDD 2.89802f
C52 a_1480_2431# a_1560_714# 0.16355f
C53 R a_10799_2175# 0.20933f
C54 K VSS 0.74958f
C55 R VSS 0.69117f
C56 VDD VSS 73.2947f
C57 a_2682_714# VSS 2.04714f
C58 a_3948_1198# VSS 2.6103f
C59 a_6312_1606# VSS 2.3627f
C60 a_1560_714# VSS 1.60014f
C61 a_10799_2175# VSS 3.19187f
C62 a_9623_2175# VSS 1.89156f
C63 a_9623_2483# VSS 0.06455f
C64 a_8938_3211# VSS 0.934f
C65 x2.VREF VSS 1.03732f
C66 a_1528_1286# VSS 3.21582f
C67 a_1480_2431# VSS 1.54893f
C68 x1.OUT VSS 7.86859f
.ends
