* NGSPICE file created from flattened.ext - technology: gf180mcuD

.subckt simple_dac_f VDD VSS D0 D1 D2 OUT
X0 VDD a_5272_1288# FEEDBACK VDD pfet_06v0 ad=4.16p pd=16.52u as=4.16p ps=16.52u w=16u l=1.1u
X1 a_5272_1288# FEEDBACK cap_mim_2f0_m4m5_noshield c_width=5u c_length=5u
X2 FEEDBACK a_5272_1288# VDD VDD pfet_06v0 ad=4.16p pd=16.52u as=7.04p ps=32.88u w=16u l=1.1u
X3 a_5272_1288# a_4096_1967# VSS VSS.t1 nfet_06v0 ad=1.32p pd=6.88u as=1.32p ps=6.88u w=3u l=1.4u
X4 D1 a_927_1108# VSS.t0 ppolyf_u_1k_6p0 r_width=1u r_length=20u
X5 FEEDBACK OUT rm1 r_width=0.6u r_length=5u
X6 D2 R2ROUT VSS.t6 ppolyf_u_1k_6p0 r_width=1u r_length=20u
X7 a_n1195_420# VSS VSS ppolyf_u_1k_6p0 r_width=1u r_length=20u
X8 D0 a_n1195_420# VSS.t12 ppolyf_u_1k_6p0 r_width=1u r_length=20u
X9 VDD FEEDBACK a_4096_1967# VDD pfet_06v0 ad=1.76p pd=8.88u as=1.76p ps=8.88u w=4u l=1.1u
X10 FEEDBACK a_5272_1288# VSS VSS.t5 nfet_06v0 ad=4.16p pd=16.52u as=7.04p ps=32.88u w=16u l=1.4u
X11 VDD R2ROUT a_5272_1288# VDD pfet_06v0 ad=1.76p pd=8.88u as=1.76p ps=8.88u w=4u l=1.1u
X12 a_n1195_420# a_927_1108# VSS.t7 ppolyf_u_1k_6p0 r_width=1u r_length=10u
X13 a_4096_1967# a_4096_1967# VSS VSS.t1 nfet_06v0 ad=1.32p pd=6.88u as=1.32p ps=6.88u w=3u l=1.4u
X14 VDD a_5272_1288# FEEDBACK VDD pfet_06v0 ad=7.04p pd=32.88u as=4.16p ps=16.52u w=16u l=1.1u
X15 a_927_1108# R2ROUT VSS ppolyf_u_1k_6p0 r_width=1u r_length=10u
X16 VSS.t2 a_5272_1288# FEEDBACK VSS.t1 nfet_06v0 ad=7.04p pd=32.88u as=4.16p ps=16.52u w=16u l=1.4u
X17 FEEDBACK a_5272_1288# VSS VSS.t3 nfet_06v0 ad=4.16p pd=16.52u as=4.16p ps=16.52u w=16u l=1.4u
X18 FEEDBACK a_5272_1288# VDD VDD pfet_06v0 ad=4.16p pd=16.52u as=4.16p ps=16.52u w=16u l=1.1u
X19 VSS a_5272_1288# FEEDBACK VSS.t4 nfet_06v0 ad=4.16p pd=16.52u as=4.16p ps=16.52u w=16u l=1.4u
R0 VSS.n15 VSS.t2 11869.8
R1 VSS VSS.n4 21.717
R2 VSS.n8 VSS.n14 219.917
R3 VSS.n5 VSS.n4 231.393
R4 VSS.n3 VSS 0.598787
R5 VSS VSS.n6 149.287
R6 VSS.t5 VSS.t4 142.841
R7 VSS.n15 VSS.n5 139.558
R8 VSS VSS.t5 125.13
R9 VSS.n17 VSS.t1 124.987
R10 VSS.t2 VSS.t1 124.987
R11 VSS.n8 VSS.n7 1.3763
R12 VSS.t12 VSS.n7 61.6676
R13 VSS VSS.t0 63.0181
R14 VSS VSS.t6 124.653
R15 VSS.n5 VSS.t6 124.653
R16 VSS.n15 VSS.t3 101.552
R17 VSS.t2 VSS.n6 91.3784
R18 VSS.n2 VSS.n10 79.3338
R19 VSS.n13 VSS.n10 73.8894
R20 VSS.n3 VSS.t7 0.191927
R21 VSS.n6 VSS.n11 58.7569
R22 VSS.n12 VSS.n9 58.3338
R23 VSS.n13 VSS.n12 47.4449
R24 VSS.n12 VSS.n1 47.4449
R25 VSS.n2 VSS.n9 47.4449
R26 VSS.n16 VSS.n9 47.4449
R27 VSS.n1 VSS.n11 43.9449
R28 VSS.n16 VSS.n11 43.9449
R29 VSS.n14 VSS 84.2219
R30 VSS.t4 VSS.n15 41.2904
R31 VSS.n4 VSS.n10 12.0666
R32 VSS.n14 VSS.n3 71.6694
R33 VSS.n17 VSS.t3 17.8556
R34 VSS.n7 VSS 1.37508
R35 VSS.n5 VSS 1.4017
R36 VSS.n1 VSS.t2 0.867167
R37 VSS.n0 VSS 0.748514
R38 VSS VSS.t2 0.57631
R39 VSS VSS.n0 0.796092
R40 VSS.n2 VSS.n17 0.578278
R41 VSS VSS.n2 0.578278
R42 VSS.n17 VSS.n16 0.578278
R43 VSS.n16 VSS 0.578278
R44 VSS.n13 VSS.t2 0.578278
R45 VSS.n0 VSS.n13 0.578278
R46 VSS VSS.n1 0.692161
R47 VSS.n8 VSS.t7 2.6057
R48 VSS VSS.t7 1.05428
C0 OUT FEEDBACK 0.00148f
C1 R2ROUT VDD 1.52623f
C2 FEEDBACK VDD 5.42808f
C3 a_4096_1967# a_5272_1288# 0.18536f
C4 R2ROUT a_4096_1967# 0.0108f
C5 FEEDBACK a_4096_1967# 0.27337f
C6 m1_11184_1625# FEEDBACK 0.03349f
C7 VDD a_4096_1967# 0.50424f
C8 R2ROUT a_5272_1288# 0.28628f
C9 FEEDBACK a_5272_1288# 6.18472f
C10 m1_11184_1625# OUT 0.01086f
C11 R2ROUT FEEDBACK 0.20857f
C12 VDD a_5272_1288# 5.80299f
C13 OUT VSS 0.45547f
C14 D2 VSS 0.48961f
C15 D1 VSS 0.4874f
C16 D0 VSS 0.48968f
C17 VDD VSS 49.88165f
C18 FEEDBACK VSS 0.87955f
C19 a_927_1108# VSS 1.35292f
C20 a_n1195_420# VSS 1.51791f
.ends
