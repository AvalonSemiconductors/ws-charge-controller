* NGSPICE file created from flattened.ext - technology: gf180mcuD

.subckt opamp_medium_f VDD VSS MINUS PLUS OUT
X0 OUT a_6533_1057# VSS VSS.t5 nfet_06v0 ad=4.16p pd=16.52u as=4.16p ps=16.52u w=16u l=1.4u
X1 OUT a_6533_1057# VSS VSS.t7 nfet_06v0 ad=4.16p pd=16.52u as=7.04p ps=32.88u w=16u l=1.4u
X2 OUT a_4672_2093# VDD VDD pfet_06v0 ad=4.16p pd=16.52u as=4.16p ps=16.52u w=16u l=1.1u
X3 VDD a_4672_2093# a_4672_2093# VDD pfet_06v0 ad=1.76p pd=8.88u as=1.76p ps=8.88u w=4u l=1.1u
X4 VDD a_4672_2093# a_5357_1365# VDD pfet_06v0 ad=3.52p pd=16.88u as=3.52p ps=16.88u w=8u l=1.1u
X5 VSS a_6533_1057# OUT VSS.t6 nfet_06v0 ad=4.16p pd=16.52u as=4.16p ps=16.52u w=16u l=1.4u
X6 a_6533_1057# a_5357_1057# VSS VSS.t0 nfet_06v0 ad=1.32p pd=6.88u as=1.32p ps=6.88u w=3u l=1.4u
X7 VDD a_4672_2093# OUT VDD pfet_06v0 ad=7.04p pd=32.88u as=4.16p ps=16.52u w=16u l=1.1u
X8 VDD a_4672_2093# OUT VDD pfet_06v0 ad=4.16p pd=16.52u as=4.16p ps=16.52u w=16u l=1.1u
X9 a_4672_2093# VSS VSS.t2 ppolyf_u_1k_6p0 r_width=1u r_length=11u
X10 a_5357_1365# MINUS a_5357_1057# VDD pfet_06v0 ad=1.76p pd=8.88u as=1.76p ps=8.88u w=4u l=1.1u
X11 OUT a_4672_2093# VDD VDD pfet_06v0 ad=4.16p pd=16.52u as=7.04p ps=32.88u w=16u l=1.1u
X12 VSS.t4 a_6533_1057# OUT VSS.t3 nfet_06v0 ad=7.04p pd=32.88u as=4.16p ps=16.52u w=16u l=1.4u
X13 a_5357_1365# PLUS a_6533_1057# VDD pfet_06v0 ad=1.76p pd=8.88u as=1.76p ps=8.88u w=4u l=1.1u
X14 a_6533_1057# OUT cap_mim_2f0_m4m5_noshield c_width=5u c_length=5u
X15 a_5357_1057# a_5357_1057# VSS VSS.t0 nfet_06v0 ad=1.32p pd=6.88u as=1.32p ps=6.88u w=3u l=1.4u
R0 VSS.n3 VSS 346.014
R1 VSS.t7 VSS.t6 177.148
R2 VSS VSS.t7 155.149
R3 VSS.t0 VSS.n0 155.005
R4 VSS VSS.t3 135.629
R5 VSS.t2 VSS.t5 124.556
R6 VSS.n2 VSS.t4 128.155
R7 VSS VSS.n1 73.1116
R8 VSS.t6 VSS.t2 52.591
R9 VSS.n0 VSS.n4 41.8061
R10 VSS.n4 VSS.n1 35.348
R11 VSS.n4 VSS.n3 20.5537
R12 VSS VSS.t4 19.5204
R13 VSS.t3 VSS.t0 19.3759
R14 VSS.n3 VSS.n2 7.08484
R15 VSS.n2 VSS.n1 6.57881
R16 VSS.n0 VSS.t5 2.76842
R17 VSS VSS.n0 1.77462
R18 VSS.t4 VSS 1.01735
C0 OUT a_5357_1365# 0.00116f
C1 a_4672_2093# VDD 9.69664f
C2 OUT PLUS 0.00332f
C3 a_5357_1365# a_4672_2093# 0.87704f
C4 a_5357_1057# a_6533_1057# 0.19212f
C5 a_4672_2093# PLUS 0.06293f
C6 MINUS a_5357_1057# 0.09206f
C7 a_6533_1057# VDD 1.29718f
C8 OUT a_4672_2093# 2.40116f
C9 a_5357_1057# VDD 0.60503f
C10 MINUS VDD 0.68817f
C11 a_5357_1365# a_6533_1057# 0.13602f
C12 a_5357_1365# a_5357_1057# 0.13302f
C13 PLUS a_6533_1057# 0.10026f
C14 a_5357_1365# MINUS 0.09876f
C15 PLUS a_5357_1057# 0.05935f
C16 MINUS PLUS 0.30776f
C17 a_5357_1365# VDD 2.90546f
C18 OUT a_6533_1057# 3.21072f
C19 PLUS VDD 0.83489f
C20 OUT a_5357_1057# 0.00262f
C21 a_5357_1365# PLUS 0.33863f
C22 a_4672_2093# a_6533_1057# 0.1225f
C23 a_4672_2093# a_5357_1057# 0.03677f
C24 OUT VDD 4.00089f
C25 MINUS a_4672_2093# 0.04028f
C26 PLUS VSS 0.19605f
C27 MINUS VSS 0.1107f
C28 OUT VSS 4.55094f
C29 VDD VSS 40.3857f
C30 a_6533_1057# VSS 7.99123f
C31 a_5357_1057# VSS 1.91377f
C32 a_5357_1365# VSS 0.07103f
C33 a_4672_2093# VSS 1.24062f
.ends
