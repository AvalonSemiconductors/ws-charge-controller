* NGSPICE file created from comparator.ext - technology: gf180mcuD

.subckt schmitt VDD VSS A Y a_1956_1601# a_1180_230# a_1150_1601#
X0 VSS Y a_1956_1601# VDD pfet_06v0 ad=0.88p pd=4.88u as=0.88p ps=4.88u w=2u l=0.55u
X1 VDD Y a_1180_230# VSS.t2 nfet_06v0 ad=0.88p pd=4.88u as=0.88p ps=4.88u w=2u l=0.7u
X2 a_1180_230# A VSS VSS.t0 nfet_06v0 ad=1.76p pd=8.88u as=1.76p ps=8.88u w=4u l=0.7u
X3 a_1150_1601# A VDD VDD pfet_06v0 ad=1.76p pd=8.88u as=1.76p ps=8.88u w=4u l=0.55u
X4 Y A a_1180_230# VSS.t1 nfet_06v0 ad=1.76p pd=8.88u as=1.76p ps=8.88u w=4u l=0.7u
X5 Y A a_1150_1601# VDD pfet_06v0 ad=1.76p pd=8.88u as=1.76p ps=8.88u w=4u l=0.55u
R0 VSS.t0 VSS.t1 1261.12
R1 VSS.n3 VSS.t2 631.306
R2 VSS.n0 VSS.t0 631.034
R3 VSS.t1 VSS 630.562
R4 VSS VSS.t2 630.562
R5 VSS.n4 VSS.n1 119.171
R6 VSS.n2 VSS.n1 87.2823
R7 VSS.n4 VSS.n3 85.9449
R8 VSS.n3 VSS.n2 85.9449
R9 VSS VSS.n2 53.6672
R10 VSS.n0 VSS.n1 34.9159
R11 VSS VSS.n4 14.7783
R12 VSS.n3 VSS 2.12465
R13 VSS VSS.n0 1.40498
C0 a_1150_1601# Y 0.26549f
C1 A Y 0.34552f
C2 a_1150_1601# VDD 0.67803f
C3 VDD A 0.84511f
C4 VDD Y 1.32383f
C5 a_1150_1601# a_1956_1601# 0.13792f
C6 A a_1180_230# 0.21716f
C7 A a_1956_1601# 0.04753f
C8 Y a_1180_230# 0.32f
C9 Y a_1956_1601# 0.17528f
C10 VDD a_1180_230# 0.10737f
C11 VDD a_1956_1601# 0.48278f
C12 a_1150_1601# A 0.13547f
C13 Y VSS 1.28897f
C14 A VSS 1.10772f
C15 VDD VSS 10.6589f
C16 a_1180_230# VSS 1.17137f
C17 a_1956_1601# VSS 0.30245f
C18 a_1150_1601# VSS 0
.ends

.subckt comparator_f VDD VSS MINUS PLUS OUT
Xschmitt_0 VDD VSS schmitt_0/A schmitt_0/Y schmitt_0/a_1956_1601# schmitt_0/a_1180_230#
+ schmitt_0/a_1150_1601# schmitt
X0 OUT schmitt_0/Y VDD VDD pfet_06v0 ad=2.08p pd=8.52u as=2.08p ps=8.52u w=8u l=0.55u
X1 OUT schmitt_0/Y VSS.t3 VSS.t5 nfet_06v0 ad=2.08p pd=8.52u as=3.52p ps=16.88u w=8u l=0.7u
X2 VDD a_2337_1747# schmitt_0/A VDD pfet_06v0 ad=1.32p pd=6.88u as=1.32p ps=6.88u w=3u l=1.1u
X3 OUT schmitt_0/Y VSS.t3 VSS.t2 nfet_06v0 ad=3.52p pd=16.88u as=2.08p ps=8.52u w=8u l=0.7u
X4 schmitt_0/A a_2337_1747# VSS VSS nfet_06v0 ad=1.32p pd=6.88u as=1.32p ps=6.88u w=3u l=1.4u
X5 VDD MINUS a_1269_1467# VDD pfet_06v0 ad=1.32p pd=6.88u as=1.32p ps=6.88u w=3u l=1.1u
X6 a_1269_1467# a_1269_1467# VSS VSS.t6 nfet_06v0 ad=1.32p pd=6.88u as=1.32p ps=6.88u w=3u l=1.4u
X7 VDD PLUS a_2337_1747# VDD pfet_06v0 ad=1.32p pd=6.88u as=1.32p ps=6.88u w=3u l=1.1u
X8 VSS.t3 schmitt_0/Y OUT VSS.t4 nfet_06v0 ad=2.08p pd=8.52u as=2.08p ps=8.52u w=8u l=0.7u
X9 a_2337_1747# a_1269_1467# VSS VSS nfet_06v0 ad=1.32p pd=6.88u as=1.32p ps=6.88u w=3u l=1.4u
X10 VDD schmitt_0/Y OUT VDD pfet_06v0 ad=3.52p pd=16.88u as=2.08p ps=8.52u w=8u l=0.55u
X11 VDD schmitt_0/Y OUT VDD pfet_06v0 ad=2.08p pd=8.52u as=3.52p ps=16.88u w=8u l=0.55u
R0 VSS.n6 VSS.n9 2522.25
R1 VSS.n5 VSS 0.387794
R2 VSS.n14 VSS.n9 1261.12
R3 VSS.n6 VSS 1253.93
R4 VSS.t2 VSS.t4 346.894
R5 VSS.n13 VSS.t4 288.606
R6 VSS.n14 VSS.n13 161.196
R7 VSS.t5 VSS.t3 378.717
R8 VSS.n11 VSS.n10 107.334
R9 VSS VSS.n10 105.389
R10 VSS VSS.n3 0.1872
R11 VSS.n15 VSS.n12 85.9449
R12 VSS.n16 VSS.n15 85.9449
R13 VSS.n16 VSS.n10 83.6116
R14 VSS.n11 VSS.n3 97.7195
R15 VSS.n17 VSS.n1 58.3338
R16 VSS.n4 VSS.n7 81.7082
R17 VSS.n13 VSS.t5 58.2901
R18 VSS.n9 VSS.n12 53.6672
R19 VSS.n12 VSS.n11 51.7227
R20 VSS.t6 VSS.n7 47.4449
R21 VSS VSS.n7 47.4449
R22 VSS VSS.n17 47.4449
R23 VSS.n17 VSS 47.4449
R24 VSS.n2 VSS.n4 0.697789
R25 VSS.n2 VSS.n1 47.4449
R26 VSS.n8 VSS.n1 47.4449
R27 VSS.n9 VSS.n16 14.7783
R28 VSS.t3 VSS 6.92401
R29 VSS.t3 VSS.t2 379.596
R30 VSS.t3 VSS 1.51142
R31 VSS.n5 VSS.n4 1.08361
R32 VSS.t3 VSS 1.11574
R33 VSS.t3 VSS.n9 1.26878
R34 VSS.n3 VSS.n8 0.959845
R35 VSS.t6 VSS.n5 0.385105
R36 VSS.n2 VSS.n0 0.446537
R37 VSS.n0 VSS 0.347005
R38 VSS VSS.n6 0.970951
R39 VSS.t3 VSS 0.873352
R40 VSS.t3 VSS 0.848647
R41 VSS.t3 VSS 0.748728
R42 VSS.n15 VSS.n14 0.743357
R43 VSS.n15 VSS.t3 0.743357
R44 VSS.n8 VSS.n0 1.00227
C0 PLUS MINUS 0.09614f
C1 a_2337_1747# MINUS 0.0011f
C2 VDD MINUS 0.58583f
C3 schmitt_0/Y a_2337_1747# 0.00767f
C4 PLUS a_2337_1747# 0.097f
C5 schmitt_0/Y VDD 1.77309f
C6 schmitt_0/Y schmitt_0/a_1180_230# 0.00212f
C7 schmitt_0/Y OUT 1.18222f
C8 PLUS VDD 1.03805f
C9 a_2337_1747# VDD 1.2635f
C10 schmitt_0/a_1180_230# a_2337_1747# 0.00302f
C11 schmitt_0/A schmitt_0/Y 0.00224f
C12 OUT VDD 3.06305f
C13 schmitt_0/a_1180_230# OUT 0
C14 schmitt_0/A a_2337_1747# 0.24126f
C15 schmitt_0/a_1150_1601# schmitt_0/Y 0
C16 schmitt_0/A VDD 0.63793f
C17 schmitt_0/a_1150_1601# a_2337_1747# 0.00245f
C18 schmitt_0/A schmitt_0/a_1180_230# 0
C19 a_1269_1467# MINUS 0.07419f
C20 schmitt_0/a_1956_1601# schmitt_0/Y 0.01532f
C21 schmitt_0/a_1150_1601# VDD 0
C22 schmitt_0/a_1956_1601# a_2337_1747# 0
C23 PLUS a_1269_1467# 0.02805f
C24 schmitt_0/a_1956_1601# VDD 0.01086f
C25 a_1269_1467# a_2337_1747# 0.1636f
C26 schmitt_0/a_1956_1601# OUT 0
C27 schmitt_0/a_1150_1601# schmitt_0/A 0
C28 a_1269_1467# VDD 0.58237f
C29 OUT VSS 3.05217f
C30 PLUS VSS 0.19632f
C31 MINUS VSS 0.05553f
C32 a_2337_1747# VSS 1.47003f
C33 a_1269_1467# VSS 1.92594f
C34 schmitt_0/Y VSS 1.96298f
C35 schmitt_0/A VSS 0.51221f
C36 VDD VSS 23.06413f
C37 schmitt_0/a_1180_230# VSS 0.02845f
.ends
