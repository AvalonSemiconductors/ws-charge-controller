* NGSPICE file created from flattened.ext - technology: gf180mcuD

.subckt refgens_f VDD VSS S0 S1 OUT
X0 a_7101_10059# a_7101_10059# a_9521_9971# VSS.t5 nfet_06v0 ad=4.4p pd=20.88u as=4.4p ps=20.88u w=10u l=2.5u
X1 VDD a_4555_5130# VSS.t75 ppolyf_u_1k r_width=1u r_length=2u
X2 VDD S1 S1N VDD pfet_06v0 ad=0.44p pd=2.88u as=0.44p ps=2.88u w=1u l=0.55u
X3 a_25077_2267# S0 VSS.t21 VSS.t20 nfet_06v0 ad=1.96p pd=3.96u as=0.88p ps=4.88u w=2u l=0.7u
X4 VSS.t43 x2.x1.OUT OUT2 VSS.t42 nfet_06v0 ad=1.76p pd=8.88u as=1.04p ps=4.52u w=4u l=0.7u
X5 VSS.t84 x4.x1.OUT OUT4 VSS.t83 nfet_06v0 ad=1.76p pd=8.88u as=1.04p ps=4.52u w=4u l=0.7u
X6 VDD a_14509_3352# a_14509_3352# VDD pfet_06v0 ad=1.76p pd=8.88u as=1.76p ps=8.88u w=4u l=1.1u
X7 a_21927_13110# OUT1 VSS.t134 ppolyf_u_1k r_width=1u r_length=2u
D0 a_15754_7245# VSS.t140 diode_pd2nw_06v0 pj=12u area=5p
X8 OUT3 EN3 OUT VDD pfet_06v0 ad=1.76p pd=8.88u as=1.76p ps=8.88u w=4u l=0.55u
X9 x3.R a_20869_1020# VSS.t116 ppolyf_u_1k r_width=1u r_length=9.98u
D1 a_15752_n1387# VSS.t100 diode_pd2nw_06v0 pj=12u area=5p
X10 VSS.t17 S1 S1N VSS.t16 nfet_06v0 ad=0.44p pd=2.88u as=0.44p ps=2.88u w=1u l=0.7u
X11 VSS.t54 EN4 a_24585_991# VSS.t91 nfet_06v0 ad=0.44p pd=2.88u as=0.44p ps=2.88u w=1u l=0.7u
X12 VDD a_14509_3352# a_15194_2624# VDD pfet_06v0 ad=3.52p pd=16.88u as=3.52p ps=16.88u w=8u l=1.1u
D2 x3.R x3.x1.OUT diode_pd2nw_06v0 pj=1.8u area=0.2025p
D3 x2.R x2.x1.OUT diode_pd2nw_06v0 pj=1.8u area=0.2025p
X13 a_18128_n1387# a_15708_n1887# a_13332_n3532# VSS.t23 nfet_06v0 ad=4.4p pd=20.88u as=4.4p ps=20.88u w=10u l=2.5u
D4 a_8255_9487# VSS.t77 diode_pd2nw_06v0 pj=12u area=5p
D5 a_9521_9971# VSS.t36 diode_pd2nw_06v0 pj=12u area=5p
X14 EN4 S0 VDD VDD pfet_06v0 ad=0.88p pd=4.88u as=0.88p ps=4.88u w=2u l=0.55u
X15 EN3 S0N a_25077_4539# VSS.t0 nfet_06v0 ad=0.88p pd=4.88u as=1.96p ps=3.96u w=2u l=0.7u
X16 x1.R a_21927_8968# VSS.t3 ppolyf_u_1k r_width=1u r_length=10u
X17 VDD S0 S0N VDD pfet_06v0 ad=0.44p pd=2.88u as=0.44p ps=2.88u w=1u l=0.55u
X18 a_21973_4138# VDD VSS.t115 ppolyf_u_1k r_width=1u r_length=2u
X19 x4.x2.VREF a_13332_n3532# VDD VDD pfet_06v0 ad=4.4p pd=20.88u as=4.4p ps=20.88u w=10u l=5u
D6 VSS.t79 x4.x1.OUT diode_nd2ps_06v0 pj=8u area=4p
D7 x1.R x1.x1.OUT diode_pd2nw_06v0 pj=1.8u area=0.2025p
X20 a_10118_n1734# x4.x2.VREF a_9894_n3312# VDD pfet_06v0 ad=1.76p pd=8.88u as=1.76p ps=8.88u w=4u l=1.1u
X21 EN1 S0N VDD VDD pfet_06v0 ad=0.88p pd=4.88u as=0.88p ps=4.88u w=2u l=0.55u
X22 VSS.t62 EN1 a_24585_7807# VSS.t9 nfet_06v0 ad=0.44p pd=2.88u as=0.44p ps=2.88u w=1u l=0.7u
X23 VDD a_7051_2572# a_7051_2572# VDD pfet_06v0 ad=4.4p pd=20.88u as=4.4p ps=20.88u w=10u l=5u
X24 VSS.t31 a_10120_6898# a_7828_6025# VSS.t30 nfet_06v0 ad=1.32p pd=6.88u as=1.32p ps=6.88u w=3u l=1.4u
X25 VDD EN3 a_24585_3263# VDD pfet_06v0 ad=0.44p pd=2.88u as=0.44p ps=2.88u w=1u l=0.55u
X26 x2.x1.OUT a_7828_5100# VDD VDD pfet_06v0 ad=3.52p pd=16.88u as=3.52p ps=16.88u w=8u l=1.1u
X27 VDD a_7053_11204# a_7101_10059# VDD pfet_06v0 ad=4.4p pd=20.88u as=4.4p ps=20.88u w=10u l=5u
X28 a_14509_3352# VSS.t86 VSS.t95 ppolyf_u_1k_6p0 r_width=1u r_length=11u
X29 a_15196_10948# a_15196_10948# VSS.t126 VSS.t125 nfet_06v0 ad=1.32p pd=6.88u as=1.32p ps=6.88u w=3u l=1.4u
X30 a_18130_7245# a_15710_6745# a_13334_5100# VSS.t6 nfet_06v0 ad=4.4p pd=20.88u as=4.4p ps=20.88u w=10u l=2.5u
X31 OUT4 EN4 OUT VDD pfet_06v0 ad=1.76p pd=8.88u as=1.76p ps=8.88u w=4u l=0.55u
X32 x2.x1.OUT a_7828_6025# cap_mim_2f0_m4m5_noshield c_width=5u c_length=5u
D8 a_14300_n787# VSS.t73 diode_pd2nw_06v0 pj=12u area=5p
X33 EN4 S1 a_25077_2267# VSS.t20 nfet_06v0 ad=0.88p pd=4.88u as=1.96p ps=3.96u w=2u l=0.7u
D9 a_11885_10379# VSS.t113 diode_pd2nw_06v0 pj=12u area=5p
X34 VSS.t90 a_21927_8968# VSS.t89 ppolyf_u_1k r_width=1u r_length=10u
X35 a_16370_2316# a_15194_2316# VSS.t59 VSS.t58 nfet_06v0 ad=1.32p pd=6.88u as=1.32p ps=6.88u w=3u l=1.4u
X36 OUT1 EN1 OUT VDD pfet_06v0 ad=1.76p pd=8.88u as=1.76p ps=8.88u w=4u l=0.55u
X37 VDD S1 EN4 VDD pfet_06v0 ad=0.88p pd=4.88u as=0.88p ps=4.88u w=2u l=0.55u
X38 VSS.t122 x3.x1.OUT OUT3 VSS.t121 nfet_06v0 ad=1.76p pd=8.88u as=1.04p ps=4.52u w=4u l=0.7u
X39 a_21973_4138# OUT3 VSS.t87 ppolyf_u_1k r_width=1u r_length=2u
D10 a_17436_n787# VSS.t24 diode_pd2nw_06v0 pj=12u area=5p
X40 a_7828_6025# x2.R a_9896_5320# VDD pfet_06v0 ad=1.76p pd=8.88u as=1.76p ps=8.88u w=4u l=1.1u
X41 a_15196_11256# x1.R a_16372_10948# VDD pfet_06v0 ad=1.76p pd=8.88u as=1.76p ps=8.88u w=4u l=1.1u
X42 VSS.t49 x1.x1.OUT OUT1 VSS.t48 nfet_06v0 ad=1.76p pd=8.88u as=1.04p ps=4.52u w=4u l=0.7u
X43 VSS.t22 S0 S0N VSS.t16 nfet_06v0 ad=0.44p pd=2.88u as=0.44p ps=2.88u w=1u l=0.7u
X44 a_17436_n787# a_18128_n1387# VSS.t63 ppolyf_u_1k_6p0 r_width=1u r_length=5u
X45 OUT4 a_4509_n3543# VSS.t92 ppolyf_u_1k r_width=1u r_length=2u
X46 OUT2 a_24585_5535# OUT VSS.t34 nfet_06v0 ad=1.76p pd=8.88u as=1.76p ps=8.88u w=4u l=0.7u
X47 a_10120_6898# x2.x2.VREF a_9896_5320# VDD pfet_06v0 ad=1.76p pd=8.88u as=1.76p ps=8.88u w=4u l=1.1u
X48 a_25077_9083# S0N VSS.t106 VSS.t0 nfet_06v0 ad=1.96p pd=3.96u as=0.88p ps=4.88u w=2u l=0.7u
X49 VDD EN4 a_24585_991# VDD pfet_06v0 ad=0.44p pd=2.88u as=0.44p ps=2.88u w=1u l=0.55u
X50 OUT VSS.t135 cap_mim_2f0_m4m5_noshield c_width=10u c_length=10u
X51 a_5613_259# x4.R VSS.t139 ppolyf_u_1k r_width=1u r_length=18.4u
X52 x2.x2.VREF a_13334_5100# VDD VDD pfet_06v0 ad=4.4p pd=20.88u as=4.4p ps=20.88u w=10u l=5u
X53 x4.x1.OUT a_7826_n3532# VDD VDD pfet_06v0 ad=3.52p pd=16.88u as=3.52p ps=16.88u w=8u l=1.1u
X54 OUT4 x4.x1.OUT VSS.t82 VSS.t81 nfet_06v0 ad=1.04p pd=4.52u as=1.76p ps=8.88u w=4u l=0.7u
X55 VDD a_7051_2572# a_7099_1427# VDD pfet_06v0 ad=4.4p pd=20.88u as=4.4p ps=20.88u w=10u l=5u
X56 a_15754_7245# a_15710_6745# a_15710_6745# VSS.t6 nfet_06v0 ad=4.4p pd=20.88u as=4.4p ps=20.88u w=10u l=2.5u
X57 VSS.t72 a_7826_n3532# VSS.t71 ppolyf_u_1k_6p0 r_width=1u r_length=11u
X58 a_15708_n1887# a_13332_n3532# VDD VDD pfet_06v0 ad=4.4p pd=20.88u as=4.4p ps=20.88u w=10u l=5u
D11 x4.R x4.x1.OUT diode_pd2nw_06v0 pj=1.8u area=0.2025p
X59 a_11883_1747# x3.x2.VREF VSS.t137 ppolyf_u_1k_6p0 r_width=1u r_length=5u
X60 a_14511_11984# VSS.t118 VSS.t117 ppolyf_u_1k_6p0 r_width=1u r_length=11u
X61 VDD EN1 a_24585_7807# VDD pfet_06v0 ad=0.44p pd=2.88u as=0.44p ps=2.88u w=1u l=0.55u
X62 a_4509_259# x4.R VSS.t105 ppolyf_u_1k r_width=1u r_length=10u
X63 VDD a_14511_11984# a_14511_11984# VDD pfet_06v0 ad=1.76p pd=8.88u as=1.76p ps=8.88u w=4u l=1.1u
X64 a_17438_7845# a_18130_7245# VSS.t66 ppolyf_u_1k_6p0 r_width=1u r_length=5u
X65 OUT1 a_20823_8968# VSS.t55 ppolyf_u_1k r_width=1u r_length=20.1u
X66 a_7133_9487# a_8255_9487# VSS.t104 ppolyf_u_1k_6p0 r_width=1u r_length=5u
X67 VDD a_14511_11984# x1.x1.OUT VDD pfet_06v0 ad=3.52p pd=16.88u as=3.52p ps=16.88u w=8u l=1.1u
X68 a_7826_n3532# a_7826_n3532# VDD VDD pfet_06v0 ad=1.76p pd=8.88u as=1.76p ps=8.88u w=4u l=1.1u
X69 VDD a_14509_3352# x3.x1.OUT VDD pfet_06v0 ad=3.52p pd=16.88u as=3.52p ps=16.88u w=8u l=1.1u
X70 VSS.t110 a_7828_6025# x2.x1.OUT VSS.t109 nfet_06v0 ad=3.52p pd=16.88u as=3.52p ps=16.88u w=8u l=1.4u
D12 a_8253_855# VSS.t98 diode_pd2nw_06v0 pj=12u area=5p
X71 EN2 S1N VDD VDD pfet_06v0 ad=0.88p pd=4.88u as=0.88p ps=4.88u w=2u l=0.55u
X72 VSS.t10 EN2 a_24585_5535# VSS.t9 nfet_06v0 ad=0.44p pd=2.88u as=0.44p ps=2.88u w=1u l=0.7u
X73 VDD a_7053_11204# x1.x2.VREF VDD pfet_06v0 ad=4.4p pd=20.88u as=4.4p ps=20.88u w=10u l=5u
X74 x1.R a_20823_8968# VSS.t76 ppolyf_u_1k r_width=1u r_length=20.1u
X75 EN1 S1N a_25077_9083# VSS.t0 nfet_06v0 ad=0.88p pd=4.88u as=1.96p ps=3.96u w=2u l=0.7u
X76 a_9896_5320# a_7828_5100# VDD VDD pfet_06v0 ad=3.52p pd=16.88u as=3.52p ps=16.88u w=8u l=1.1u
X77 a_5659_8494# x2.R VSS.t50 ppolyf_u_1k r_width=1u r_length=16.21u
D13 a_9519_1339# VSS.t93 diode_pd2nw_06v0 pj=12u area=5p
X78 a_7131_855# a_8253_855# VSS.t138 ppolyf_u_1k_6p0 r_width=1u r_length=5u
X79 VDD S1N EN1 VDD pfet_06v0 ad=0.88p pd=4.88u as=0.88p ps=4.88u w=2u l=0.55u
X80 a_15194_2624# x3.x2.VREF a_15194_2316# VDD pfet_06v0 ad=1.76p pd=8.88u as=1.76p ps=8.88u w=4u l=1.1u
X81 a_13334_5100# a_13334_5100# VDD VDD pfet_06v0 ad=4.4p pd=20.88u as=4.4p ps=20.88u w=10u l=5u
X82 a_4555_8494# VSS.t27 VSS.t26 ppolyf_u_1k r_width=1u r_length=10u
X83 OUT2 EN2 OUT VDD pfet_06v0 ad=1.76p pd=8.88u as=1.76p ps=8.88u w=4u l=0.55u
X84 a_21927_13110# VDD VSS.t35 ppolyf_u_1k r_width=1u r_length=2u
X85 a_11885_10379# x1.x2.VREF VSS.t29 ppolyf_u_1k_6p0 r_width=1u r_length=5u
X86 a_9894_n3312# a_7826_n3532# VDD VDD pfet_06v0 ad=3.52p pd=16.88u as=3.52p ps=16.88u w=8u l=1.1u
X87 a_15752_n1387# a_15708_n1887# a_15708_n1887# VSS.t23 nfet_06v0 ad=4.4p pd=20.88u as=4.4p ps=20.88u w=10u l=2.5u
D14 VSS.t123 x3.x1.OUT diode_nd2ps_06v0 pj=8u area=4p
X88 a_15194_2624# x3.R a_16370_2316# VDD pfet_06v0 ad=1.76p pd=8.88u as=1.76p ps=8.88u w=4u l=1.1u
X89 VSS.t108 a_7826_n2607# x4.x1.OUT VSS.t107 nfet_06v0 ad=3.52p pd=16.88u as=3.52p ps=16.88u w=8u l=1.4u
X90 OUT3 a_24585_3263# OUT VSS.t133 nfet_06v0 ad=1.76p pd=8.88u as=1.76p ps=8.88u w=4u l=0.7u
X91 VSS.t54 a_21973_1020# VSS.t53 ppolyf_u_1k r_width=1u r_length=10u
X92 OUT3 x3.x1.OUT VSS.t120 VSS.t119 nfet_06v0 ad=1.04p pd=4.52u as=1.76p ps=8.88u w=4u l=0.7u
X93 a_7053_11204# a_7101_10059# a_7133_9487# VSS.t4 nfet_06v0 ad=4.4p pd=20.88u as=4.4p ps=20.88u w=10u l=2.5u
X94 OUT2 x2.x1.OUT VSS.t41 VSS.t40 nfet_06v0 ad=1.04p pd=4.52u as=1.76p ps=8.88u w=4u l=0.7u
X95 VSS.t33 a_10120_6898# a_10120_6898# VSS.t32 nfet_06v0 ad=1.32p pd=6.88u as=1.32p ps=6.88u w=3u l=1.4u
X96 EN3 S1 VDD VDD pfet_06v0 ad=0.88p pd=4.88u as=0.88p ps=4.88u w=2u l=0.55u
X97 a_7051_2572# a_7099_1427# a_7131_855# VSS.t102 nfet_06v0 ad=4.4p pd=20.88u as=4.4p ps=20.88u w=10u l=2.5u
X98 a_25077_6811# S1N VSS.t1 VSS.t0 nfet_06v0 ad=1.96p pd=3.96u as=0.88p ps=4.88u w=2u l=0.7u
D15 a_11883_1747# VSS.t96 diode_pd2nw_06v0 pj=12u area=5p
X99 VDD S0 EN2 VDD pfet_06v0 ad=0.88p pd=4.88u as=0.88p ps=4.88u w=2u l=0.55u
X100 a_5659_8494# OUT2 VSS.t51 ppolyf_u_1k r_width=1u r_length=16u
X101 a_7826_n2607# x4.R a_9894_n3312# VDD pfet_06v0 ad=1.76p pd=8.88u as=1.76p ps=8.88u w=4u l=1.1u
X102 EN2 S0 a_25077_6811# VSS.t0 nfet_06v0 ad=0.88p pd=4.88u as=1.96p ps=3.96u w=2u l=0.7u
X103 a_4555_8494# x2.R VSS.t28 ppolyf_u_1k r_width=1u r_length=10u
D16 VSS.t44 x1.x1.OUT diode_nd2ps_06v0 pj=8u area=4p
X104 x3.x1.OUT a_16370_2316# cap_mim_2f0_m4m5_noshield c_width=5u c_length=5u
X105 a_15196_11256# x1.x2.VREF a_15196_10948# VDD pfet_06v0 ad=1.76p pd=8.88u as=1.76p ps=8.88u w=4u l=1.1u
X106 a_13332_n3532# a_13332_n3532# VDD VDD pfet_06v0 ad=4.4p pd=20.88u as=4.4p ps=20.88u w=10u l=5u
X107 x4.x2.VREF a_14300_n787# VSS.t88 ppolyf_u_1k_6p0 r_width=1u r_length=5u
X108 a_4509_259# VSS.t8 VSS.t7 ppolyf_u_1k r_width=1u r_length=10u
X109 VSS.t12 a_10118_n1734# a_10118_n1734# VSS.t11 nfet_06v0 ad=1.32p pd=6.88u as=1.32p ps=6.88u w=3u l=1.4u
D17 VSS.t38 x2.x1.OUT diode_nd2ps_06v0 pj=8u area=4p
X110 x3.R a_21973_1020# VSS.t2 ppolyf_u_1k r_width=1u r_length=10u
X111 a_25077_4539# S1 VSS.t19 VSS.t18 nfet_06v0 ad=1.96p pd=3.96u as=0.88p ps=4.88u w=2u l=0.7u
X112 VDD EN2 a_24585_5535# VDD pfet_06v0 ad=0.44p pd=2.88u as=0.44p ps=2.88u w=1u l=0.55u
X113 a_15710_6745# a_13334_5100# VDD VDD pfet_06v0 ad=4.4p pd=20.88u as=4.4p ps=20.88u w=10u l=5u
X114 VDD a_14511_11984# a_15196_11256# VDD pfet_06v0 ad=3.52p pd=16.88u as=3.52p ps=16.88u w=8u l=1.1u
X115 OUT2 a_4555_5130# VSS.t70 ppolyf_u_1k r_width=1u r_length=2u
X116 VDD S0N EN3 VDD pfet_06v0 ad=0.88p pd=4.88u as=0.88p ps=4.88u w=2u l=0.55u
X117 a_16372_10948# a_15196_10948# VSS.t128 VSS.t127 nfet_06v0 ad=1.32p pd=6.88u as=1.32p ps=6.88u w=3u l=1.4u
X118 VSS.t61 a_7828_5100# VSS.t60 ppolyf_u_1k_6p0 r_width=1u r_length=11u
X119 a_7828_5100# a_7828_5100# VDD VDD pfet_06v0 ad=1.76p pd=8.88u as=1.76p ps=8.88u w=4u l=1.1u
X120 OUT1 x1.x1.OUT VSS.t47 VSS.t46 nfet_06v0 ad=1.04p pd=4.52u as=1.76p ps=8.88u w=4u l=0.7u
X121 x1.x1.OUT a_16372_10948# VSS.t68 VSS.t67 nfet_06v0 ad=3.52p pd=16.88u as=3.52p ps=16.88u w=8u l=1.4u
X122 x4.x1.OUT a_7826_n2607# cap_mim_2f0_m4m5_noshield c_width=5u c_length=5u
X123 OUT1 a_24585_7807# OUT VSS.t34 nfet_06v0 ad=1.76p pd=8.88u as=1.76p ps=8.88u w=4u l=0.7u
X124 x1.x1.OUT a_16372_10948# cap_mim_2f0_m4m5_noshield c_width=5u c_length=5u
X125 x3.x1.OUT a_16370_2316# VSS.t86 VSS.t85 nfet_06v0 ad=3.52p pd=16.88u as=3.52p ps=16.88u w=8u l=1.4u
X126 VDD a_7051_2572# x3.x2.VREF VDD pfet_06v0 ad=4.4p pd=20.88u as=4.4p ps=20.88u w=10u l=5u
X127 VSS.t130 EN3 a_24585_3263# VSS.t129 nfet_06v0 ad=0.44p pd=2.88u as=0.44p ps=2.88u w=1u l=0.7u
X128 VDD a_7053_11204# a_7053_11204# VDD pfet_06v0 ad=4.4p pd=20.88u as=4.4p ps=20.88u w=10u l=5u
X129 VSS.t14 a_10118_n1734# a_7826_n2607# VSS.t13 nfet_06v0 ad=1.32p pd=6.88u as=1.32p ps=6.88u w=3u l=1.4u
X130 VDD a_4509_n3543# VSS.t65 ppolyf_u_1k r_width=1u r_length=2u
D18 a_14302_7845# VSS.t131 diode_pd2nw_06v0 pj=12u area=5p
X131 OUT3 a_20869_1020# VSS.t64 ppolyf_u_1k r_width=1u r_length=9.98u
X132 a_7099_1427# a_7099_1427# a_9519_1339# VSS.t103 nfet_06v0 ad=4.4p pd=20.88u as=4.4p ps=20.88u w=10u l=2.5u
X133 x2.x2.VREF a_14302_7845# VSS.t69 ppolyf_u_1k_6p0 r_width=1u r_length=5u
X134 a_15194_2316# a_15194_2316# VSS.t57 VSS.t56 nfet_06v0 ad=1.32p pd=6.88u as=1.32p ps=6.88u w=3u l=1.4u
X135 OUT4 a_24585_991# OUT VSS.t15 nfet_06v0 ad=1.76p pd=8.88u as=1.76p ps=8.88u w=4u l=0.7u
D19 a_17438_7845# VSS.t111 diode_pd2nw_06v0 pj=12u area=5p
X136 a_5613_259# OUT4 VSS.t52 ppolyf_u_1k r_width=1u r_length=18.4u
R0 VSS.n392 VSS.n391 2.37068e+06
R1 VSS.n392 VSS.n249 443083
R2 VSS.n393 VSS.n392 246959
R3 VSS.n391 VSS.n250 145167
R4 VSS.n250 VSS.n249 145167
R5 VSS.n375 VSS.t52 82702.6
R6 VSS.t87 VSS.t51 47870.3
R7 VSS.n487 VSS.t134 37876.5
R8 VSS.n618 VSS.n615 5414.59
R9 VSS.n455 VSS.n454 5410.44
R10 VSS.n598 VSS.n597 5410.44
R11 VSS.n566 VSS.n217 4703.69
R12 VSS.n647 VSS.n646 4703.69
R13 VSS.n612 VSS.n84 4685.11
R14 VSS.n457 VSS.n456 4683.35
R15 VSS.n186 VSS.n164 4683.35
R16 VSS.n509 VSS.n222 4654.56
R17 VSS.n562 VSS.n561 4628.46
R18 VSS.n429 VSS.n427 4311.46
R19 VSS.n454 VSS.n209 4152.78
R20 VSS.n509 VSS.n221 4152.78
R21 VSS.n562 VSS.n221 4152.78
R22 VSS.n457 VSS.n209 4152.78
R23 VSS.n619 VSS.n618 4152.78
R24 VSS.n186 VSS.n168 4152.78
R25 VSS.n597 VSS.n168 4152.78
R26 VSS.n619 VSS.n612 4152.78
R27 VSS.n393 VSS.t129 2997.14
R28 VSS.n429 VSS.n223 2611.31
R29 VSS.n447 VSS.t127 2515.9
R30 VSS.n355 VSS.t58 2515.9
R31 VSS.n473 VSS.n429 2405.99
R32 VSS.n585 VSS.n584 2405.99
R33 VSS.t107 VSS.n147 2403.25
R34 VSS.n456 VSS.n455 2366.56
R35 VSS.n561 VSS.n222 2366.56
R36 VSS.n598 VSS.n164 2366.56
R37 VSS.n615 VSS.n84 2366.56
R38 VSS.n567 VSS.t109 2351.84
R39 VSS.n585 VSS.n85 2351.84
R40 VSS.t107 VSS.n127 2351.84
R41 VSS.n455 VSS.n453 2179.12
R42 VSS.n599 VSS.n598 2179.12
R43 VSS.n615 VSS.n614 2174.97
R44 VSS.n671 VSS.n106 1912.69
R45 VSS.n442 VSS.n441 1901.02
R46 VSS.n349 VSS.n167 1901.02
R47 VSS.n147 VSS.n144 1841.76
R48 VSS.n453 VSS.n441 1755.75
R49 VSS.n614 VSS.n613 1755.75
R50 VSS.n599 VSS.n167 1755.75
R51 VSS.t13 VSS.n684 1395.21
R52 VSS.t52 VSS.t139 1301.89
R53 VSS.n613 VSS.t107 1244.1
R54 VSS.n441 VSS.n429 1241.36
R55 VSS.n585 VSS.n167 1241.36
R56 VSS.n686 VSS.t71 1145.59
R57 VSS.n685 VSS.t13 1116.54
R58 VSS.n409 VSS.t109 1024.87
R59 VSS.n421 VSS.n420 988.644
R60 VSS.n685 VSS.n86 988.644
R61 VSS.t51 VSS.t50 976.062
R62 VSS.n474 VSS.t67 921.016
R63 VSS.n581 VSS.t85 921.016
R64 VSS.t67 VSS.n473 920.742
R65 VSS.n584 VSS.t85 920.742
R66 VSS.n456 VSS.n216 919.317
R67 VSS.n602 VSS.n164 919.317
R68 VSS.n691 VSS.n84 917.566
R69 VSS.n670 VSS.t92 884.434
R70 VSS.n224 VSS.n222 864.907
R71 VSS.n561 VSS.n560 819.933
R72 VSS.n411 VSS.t109 816.885
R73 VSS.n393 VSS.t9 810.827
R74 VSS.t115 VSS.n248 806.312
R75 VSS.n690 VSS.n689 801.995
R76 VSS.n613 VSS.t71 755.428
R77 VSS.t91 VSS.n248 751.568
R78 VSS.n393 VSS.t35 750.23
R79 VSS.n568 VSS.n216 740.707
R80 VSS.n603 VSS.n602 740.707
R81 VSS.n691 VSS.n690 740.707
R82 VSS.n422 VSS.n223 716.659
R83 VSS.n224 VSS.t109 698.197
R84 VSS.n308 VSS.t18 686.072
R85 VSS.n560 VSS.n223 661.893
R86 VSS.t92 VSS.t65 650.943
R87 VSS.n567 VSS.n566 635.364
R88 VSS.n647 VSS.n85 635.364
R89 VSS.n646 VSS.n127 635.364
R90 VSS.n444 VSS.t125 588.941
R91 VSS.n353 VSS.t56 588.941
R92 VSS.n95 VSS.t11 588.941
R93 VSS.t70 VSS.n106 583.515
R94 VSS.t30 VSS.n419 554.596
R95 VSS.n427 VSS.t32 525.759
R96 VSS.t75 VSS.t70 488.031
R97 VSS.n268 VSS.t87 488.031
R98 VSS.n268 VSS.t115 488.031
R99 VSS.n569 VSS.t117 483.298
R100 VSS.n604 VSS.t95 483.298
R101 VSS.t125 VSS.t127 472.791
R102 VSS.t56 VSS.t58 472.791
R103 VSS.t11 VSS.n86 471.041
R104 VSS.n408 VSS.t60 455.562
R105 VSS.n420 VSS.t30 444.007
R106 VSS.n421 VSS.t32 420.921
R107 VSS.n419 VSS.n409 418.945
R108 VSS.n670 VSS.t139 417.454
R109 VSS.t134 VSS.n486 411.658
R110 VSS.n486 VSS.t35 411.658
R111 VSS.t50 VSS.n106 392.546
R112 VSS.n223 VSS.n217 375.897
R113 VSS.t133 VSS.t18 353.646
R114 VSS.n672 VSS.n65 344.67
R115 VSS.n548 VSS.n61 344.67
R116 VSS.n315 VSS.t133 332.428
R117 VSS.t117 VSS.n568 318.697
R118 VSS.t95 VSS.n603 318.697
R119 VSS.n61 VSS.n487 310.327
R120 VSS.t60 VSS.t109 300.406
R121 VSS.n660 VSS.n659 299.057
R122 VSS.n537 VSS.n536 299.057
R123 VSS.n396 VSS.n395 299.057
R124 VSS.n380 VSS.n261 299.057
R125 VSS.n65 VSS.n671 282.229
R126 VSS.n686 VSS.n685 278.098
R127 VSS.n479 VSS.n400 274.557
R128 VSS.n479 VSS.n399 274.557
R129 VSS.n442 VSS.t127 273.947
R130 VSS.n349 VSS.t58 273.947
R131 VSS.n568 VSS.n567 270.223
R132 VSS.n603 VSS.n127 270.223
R133 VSS.n690 VSS.n85 270.223
R134 VSS.n38 VSS.n104 258.029
R135 VSS.n38 VSS.n105 258.029
R136 VSS.n672 VSS.n103 257.877
R137 VSS.n628 VSS.t102 254.756
R138 VSS.n575 VSS.n208 254.756
R139 VSS.t4 VSS.n496 254.756
R140 VSS.n200 VSS.n195 254.756
R141 VSS.t102 VSS.t138 243.517
R142 VSS.n575 VSS.t66 243.517
R143 VSS.t4 VSS.t104 243.517
R144 VSS.t63 VSS.n200 243.517
R145 VSS.t89 VSS.n393 240.618
R146 VSS.n547 VSS.n546 234.695
R147 VSS.n549 VSS.n548 230.404
R148 VSS.n482 VSS.n246 220.889
R149 VSS.n547 VSS.n488 214.923
R150 VSS.n401 VSS.n399 210.195
R151 VSS.n663 VSS.n656 204.362
R152 VSS.t53 VSS.n248 202.073
R153 VSS.t69 VSS.n428 200.083
R154 VSS.n518 VSS.t29 200.083
R155 VSS.n157 VSS.t137 200.083
R156 VSS.n586 VSS.t88 200.083
R157 VSS.n308 VSS.n250 199.81
R158 VSS.n315 VSS.t129 198.042
R159 VSS.n520 VSS.n495 195.222
R160 VSS.n627 VSS.n151 195.222
R161 VSS.n203 VSS.n201 195.222
R162 VSS.n576 VSS.n206 195.222
R163 VSS.n110 VSS.n105 194.056
R164 VSS.n565 VSS.n564 186.279
R165 VSS.n645 VSS.n129 186.279
R166 VSS.n648 VSS.n125 186.279
R167 VSS.n440 VSS.n439 186.279
R168 VSS.n405 VSS.n225 185.012
R169 VSS.n87 VSS.n83 185.012
R170 VSS.n451 VSS.n215 185.001
R171 VSS.n165 VSS.n163 185.001
R172 VSS.n540 VSS.n526 183.07
R173 VSS.n503 VSS.n219 178.112
R174 VSS.n616 VSS.n142 178.112
R175 VSS.n202 VSS.n169 178.112
R176 VSS.n438 VSS.n437 178.112
R177 VSS.n378 VSS.n377 176.167
R178 VSS.n546 VSS.n545 172.764
R179 VSS.t105 VSS.t7 172.334
R180 VSS.t7 VSS.n107 172.334
R181 VSS.t26 VSS.t28 172.334
R182 VSS.n539 VSS.t26 172.334
R183 VSS.n390 VSS.t20 171.94
R184 VSS.n645 VSS.n128 169.587
R185 VSS.n565 VSS.n218 169.587
R186 VSS.n648 VSS.n126 169.587
R187 VSS.n439 VSS.n211 169.587
R188 VSS.n480 VSS.n247 166.689
R189 VSS.n1 VSS.n209 165.107
R190 VSS.n515 VSS.n221 165.107
R191 VSS.n620 VSS.n619 165.107
R192 VSS.n593 VSS.n168 165.107
R193 VSS.n678 VSS.t83 159.846
R194 VSS.n470 VSS.t46 159.846
R195 VSS.n554 VSS.t42 159.846
R196 VSS.t119 VSS.n199 159.846
R197 VSS.n474 VSS.n404 154.389
R198 VSS.n413 VSS.n411 154.389
R199 VSS.n145 VSS.n144 154.389
R200 VSS.n581 VSS.n197 154.389
R201 VSS.n564 VSS.n219 152.445
R202 VSS.n616 VSS.n129 152.445
R203 VSS.n169 VSS.n125 152.445
R204 VSS.n440 VSS.n438 152.445
R205 VSS.n586 VSS.n190 147.945
R206 VSS.n428 VSS.n212 147.945
R207 VSS.n518 VSS.n498 147.879
R208 VSS.n158 VSS.n157 147.879
R209 VSS.n589 VSS.n588 144.137
R210 VSS.n660 VSS.n109 143.5
R211 VSS.n536 VSS.n528 143.5
R212 VSS.n397 VSS.n396 143.5
R213 VSS.n271 VSS.n261 143.5
R214 VSS.t16 VSS.n281 137.769
R215 VSS.n376 VSS.n375 136.931
R216 VSS.t55 VSS.n480 132.029
R217 VSS.n67 VSS.t55 132.029
R218 VSS.t76 VSS.n67 132.029
R219 VSS.n481 VSS.t76 132.029
R220 VSS.n481 VSS.t3 132.029
R221 VSS.n53 VSS.t3 132.029
R222 VSS.n53 VSS.t89 132.029
R223 VSS.n111 VSS.n100 131.833
R224 VSS.n465 VSS.n403 131.833
R225 VSS.n550 VSS.n231 131.833
R226 VSS.n580 VSS.n198 131.833
R227 VSS.n2 VSS.n210 132.113
R228 VSS.n514 VSS.n512 129.624
R229 VSS.n611 VSS.n156 129.624
R230 VSS.n592 VSS.n189 129.624
R231 VSS.n377 VSS.n263 126.105
R232 VSS.n502 VSS.n495 124.251
R233 VSS.n151 VSS.n150 124.251
R234 VSS.n578 VSS.n201 124.251
R235 VSS.n436 VSS.n206 124.251
R236 VSS.n340 VSS.n30 124.056
R237 VSS.t6 VSS.t69 123.106
R238 VSS.t29 VSS.t5 123.106
R239 VSS.t137 VSS.t103 123.106
R240 VSS.t88 VSS.t23 123.106
R241 VSS.n379 VSS.n262 122.501
R242 VSS.n272 VSS.n262 122.501
R243 VSS.n376 VSS.t64 122.308
R244 VSS.t64 VSS.n51 122.308
R245 VSS.n51 VSS.t116 122.308
R246 VSS.t116 VSS.n265 122.308
R247 VSS.n265 VSS.t2 122.308
R248 VSS.t2 VSS.n54 122.308
R249 VSS.n54 VSS.t53 122.308
R250 VSS.n5 VSS.n1 1.05744
R251 VSS.n559 VSS.n13 1.0231
R252 VSS.n692 VSS.n82 120.945
R253 VSS.n601 VSS.n600 120.945
R254 VSS.n689 VSS.n86 117.323
R255 VSS.n1 VSS.n2 2.48999
R256 VSS.n515 VSS.n514 116.59
R257 VSS.n620 VSS.n611 116.59
R258 VSS.n593 VSS.n592 116.59
R259 VSS.n569 VSS.t127 115.572
R260 VSS.n604 VSS.t58 115.572
R261 VSS.n520 VSS.n519 115.501
R262 VSS.n519 VSS.n518 115.501
R263 VSS.n521 VSS.n495 115.501
R264 VSS.n151 VSS.n148 115.501
R265 VSS.n627 VSS.n149 115.501
R266 VSS.n157 VSS.n149 115.501
R267 VSS.n586 VSS.n194 115.501
R268 VSS.n203 VSS.n194 115.501
R269 VSS.n360 VSS.n201 115.501
R270 VSS.n428 VSS.n207 115.501
R271 VSS.n576 VSS.n207 115.501
R272 VSS.n574 VSS.n206 115.501
R273 VSS.t79 VSS.t81 114.891
R274 VSS.t44 VSS.t48 114.891
R275 VSS.t40 VSS.t38 114.891
R276 VSS.t123 VSS.t121 114.891
R277 VSS.n50 VSS.n263 112.195
R278 VSS.n52 VSS.n241 112.001
R279 VSS.n275 VSS.n274 112.001
R280 VSS.n661 VSS.n55 111.903
R281 VSS.n535 VSS.n56 111.903
R282 VSS.n420 VSS.n408 110.59
R283 VSS.n422 VSS.n421 104.84
R284 VSS.n291 VSS.n279 101.889
R285 VSS.n305 VSS.n286 101.889
R286 VSS.n314 VSS.n252 101.889
R287 VSS.n260 VSS.n256 101.889
R288 VSS.n472 VSS.n430 96.0561
R289 VSS.n583 VSS.n196 96.0561
R290 VSS.t0 VSS.t34 95.6731
R291 VSS.n474 VSS.n403 92.5561
R292 VSS.n411 VSS.n231 92.5561
R293 VSS.n412 VSS.n230 92.5561
R294 VSS.n144 VSS.n100 92.5561
R295 VSS.n146 VSS.n99 92.5561
R296 VSS.n581 VSS.n580 92.5561
R297 VSS.t34 VSS.n290 89.9328
R298 VSS.n527 VSS.n489 89.8338
R299 VSS.n398 VSS.n245 89.8338
R300 VSS.n662 VSS.n657 89.8338
R301 VSS.t15 VSS.t20 88.6288
R302 VSS.n450 VSS.n449 88.5513
R303 VSS.n416 VSS.n414 88.5513
R304 VSS.n92 VSS.n91 88.5513
R305 VSS.n351 VSS.n166 88.5513
R306 VSS.n674 VSS.n103 83.67
R307 VSS.n463 VSS.n247 83.67
R308 VSS.n549 VSS.n239 83.67
R309 VSS.n374 VSS.n373 83.67
R310 VSS.n385 VSS.t15 83.3111
R311 VSS.t81 VSS.n674 82.4213
R312 VSS.n463 VSS.t48 82.4213
R313 VSS.n239 VSS.t40 82.4213
R314 VSS.n373 VSS.t121 82.4213
R315 VSS.n311 VSS.n257 81.8616
R316 VSS.n296 VSS.n294 81.8616
R317 VSS.n345 VSS.n278 81.8616
R318 VSS.n519 VSS.n497 79.7227
R319 VSS.n154 VSS.n149 79.7227
R320 VSS.n361 VSS.n194 79.7227
R321 VSS.n572 VSS.n207 79.7227
R322 VSS.n343 VSS.n342 78.4588
R323 VSS.n258 VSS.n251 78.4588
R324 VSS.n309 VSS.n307 78.4588
R325 VSS.n323 VSS.n322 78.4588
R326 VSS.n503 VSS.n502 77.5838
R327 VSS.n150 VSS.n142 77.5838
R328 VSS.n578 VSS.n202 77.5838
R329 VSS.n437 VSS.n436 77.5838
R330 VSS.n386 VSS.n256 72.7227
R331 VSS.n312 VSS.n311 72.7227
R332 VSS.n317 VSS.n294 72.7227
R333 VSS.n346 VSS.n345 72.7227
R334 VSS.n332 VSS.n284 72.7227
R335 VSS.n332 VSS.n285 72.7227
R336 VSS.n330 VSS.n285 72.7227
R337 VSS.n330 VSS.n284 72.7227
R338 VSS.n444 VSS.n215 72.2631
R339 VSS.n353 VSS.n163 72.2631
R340 VSS.n426 VSS.n405 72.1995
R341 VSS.n95 VSS.n87 72.1995
R342 VSS.n472 VSS.n404 68.8806
R343 VSS.n413 VSS.n412 68.8806
R344 VSS.n146 VSS.n145 68.8806
R345 VSS.n583 VSS.n197 68.8806
R346 VSS.n14 VSS.n13 0.589596
R347 VSS.n10 VSS.n508 68.2505
R348 VSS.n507 VSS.n499 68.2505
R349 VSS.n501 VSS.n506 68.2505
R350 VSS.n13 VSS.n17 0.393058
R351 VSS.n641 VSS.n132 68.2505
R352 VSS.n643 VSS.n642 68.2505
R353 VSS.n632 VSS.n631 68.2505
R354 VSS.n635 VSS.n634 68.2505
R355 VSS.n639 VSS.n136 68.2505
R356 VSS.n138 VSS.n139 68.2505
R357 VSS.n367 VSS.n357 68.2505
R358 VSS.t86 VSS.n22 0.589596
R359 VSS.n182 VSS.n171 68.2505
R360 VSS.n184 VSS.n181 68.2505
R361 VSS.n178 VSS.n124 68.2505
R362 VSS.n177 VSS.n174 68.2505
R363 VSS.n78 VSS.n435 68.2505
R364 VSS.n434 VSS.n431 68.2505
R365 VSS.n628 VSS.t107 67.4357
R366 VSS.n429 VSS.n208 67.4357
R367 VSS.n496 VSS.t109 67.4357
R368 VSS.n585 VSS.n195 67.4357
R369 VSS.n111 VSS.n102 66.6949
R370 VSS.n466 VSS.n465 66.6949
R371 VSS.n550 VSS.n237 66.6949
R372 VSS.n347 VSS.n198 66.6949
R373 VSS.n39 VSS.t72 65.475
R374 VSS.n14 VSS.n508 64.2543
R375 VSS.n506 VSS.n500 64.2445
R376 VSS.n507 VSS.t77 64.2445
R377 VSS.n643 VSS.n131 64.2445
R378 VSS.n139 VSS.n137 64.2445
R379 VSS.n639 VSS.t93 64.2445
R380 VSS.n634 VSS.n633 64.2445
R381 VSS.n631 VSS.t98 64.2445
R382 VSS.t96 VSS.n641 64.2445
R383 VSS.n22 VSS.n357 64.2543
R384 VSS.n184 VSS.n183 64.2445
R385 VSS.t100 VSS.n171 64.2445
R386 VSS.t73 VSS.n124 64.2445
R387 VSS.n175 VSS.n174 64.2445
R388 VSS.n435 VSS.t111 64.2445
R389 VSS.n432 VSS.n431 64.2445
R390 VSS.n451 VSS.n450 63.9727
R391 VSS.n414 VSS.n225 63.9727
R392 VSS.n91 VSS.n83 63.9727
R393 VSS.n166 VSS.n165 63.9727
R394 VSS.n540 VSS.n527 62.3199
R395 VSS.n670 VSS.n107 61.8161
R396 VSS.n445 VSS.n214 58.3338
R397 VSS.n407 VSS.n406 58.3338
R398 VSS.n93 VSS.n88 58.3338
R399 VSS.n354 VSS.n162 58.3338
R400 VSS.n464 VSS.n459 57.9449
R401 VSS.n471 VSS.n459 57.9449
R402 VSS.n235 VSS.n232 57.9449
R403 VSS.n553 VSS.n232 57.9449
R404 VSS.n372 VSS.n369 57.9449
R405 VSS.n369 VSS.n57 57.9449
R406 VSS.n673 VSS.n101 57.9449
R407 VSS.n677 VSS.n101 57.9449
R408 VSS.n449 VSS.n448 56.8341
R409 VSS.n417 VSS.n416 56.8341
R410 VSS.n94 VSS.n92 56.8341
R411 VSS.n352 VSS.n351 56.8341
R412 VSS.n345 VSS.n344 56.0005
R413 VSS.n294 VSS.n293 56.0005
R414 VSS.n311 VSS.n301 56.0005
R415 VSS.n259 VSS.n256 56.0005
R416 VSS.n281 VSS.n249 54.0555
R417 VSS.n379 VSS.n378 53.6672
R418 VSS.n380 VSS.n379 53.6672
R419 VSS.n659 VSS.n656 53.6672
R420 VSS.n656 VSS.n104 53.6672
R421 VSS.n657 VSS.n109 53.6672
R422 VSS.n657 VSS.n105 53.6672
R423 VSS.n537 VSS.n526 53.6672
R424 VSS.n528 VSS.n489 53.6672
R425 VSS.n546 VSS.n489 53.6672
R426 VSS.n400 VSS.n246 53.6672
R427 VSS.n395 VSS.n246 53.6672
R428 VSS.n399 VSS.n398 53.6672
R429 VSS.n398 VSS.n397 53.6672
R430 VSS.n274 VSS.n261 53.6672
R431 VSS.n290 VSS.t9 53.5772
R432 VSS.n6 VSS.n498 53.1767
R433 VSS.n159 VSS.n158 53.1767
R434 VSS.n191 VSS.n190 53.1111
R435 VSS.n7 VSS.n212 53.1111
R436 VSS.n526 VSS.n488 52.3777
R437 VSS.n309 VSS.n306 51.7227
R438 VSS.n316 VSS.n297 51.6255
R439 VSS.n680 VSS.n100 50.9449
R440 VSS.n468 VSS.n403 50.9449
R441 VSS.n556 VSS.n231 50.9449
R442 VSS.n580 VSS.n77 50.9449
R443 VSS.n274 VSS.n273 50.1672
R444 VSS.n273 VSS.n271 50.1672
R445 VSS.n391 VSS.n390 50.0755
R446 VSS.t91 VSS.n385 49.6324
R447 VSS.n570 VSS.n215 48.8582
R448 VSS.n605 VSS.n163 48.8582
R449 VSS.n423 VSS.n405 48.8472
R450 VSS.n688 VSS.n87 48.8472
R451 VSS.t16 VSS.t0 47.8368
R452 VSS.n445 VSS.n444 47.4449
R453 VSS.n447 VSS.n445 47.4449
R454 VSS.n570 VSS.n214 47.4449
R455 VSS.n443 VSS.n214 47.4449
R456 VSS.n415 VSS.n407 47.4449
R457 VSS.n423 VSS.n407 47.4449
R458 VSS.n418 VSS.n406 47.4449
R459 VSS.n426 VSS.n406 47.4449
R460 VSS.n684 VSS.n93 47.4449
R461 VSS.n95 VSS.n93 47.4449
R462 VSS.n687 VSS.n88 47.4449
R463 VSS.n688 VSS.n88 47.4449
R464 VSS.n354 VSS.n353 47.4449
R465 VSS.n355 VSS.n354 47.4449
R466 VSS.n605 VSS.n162 47.4449
R467 VSS.n350 VSS.n162 47.4449
R468 VSS.n448 VSS.n447 46.1362
R469 VSS.n418 VSS.n417 46.1362
R470 VSS.n684 VSS.n94 46.1362
R471 VSS.n355 VSS.n352 46.1362
R472 VSS.n344 VSS.n343 44.7227
R473 VSS.n322 VSS.n293 44.7227
R474 VSS.n307 VSS.n301 44.7227
R475 VSS.n259 VSS.n258 44.7227
R476 VSS.n11 VSS.n220 42.5838
R477 VSS.n621 VSS.n153 42.5838
R478 VSS.n594 VSS.n188 42.5838
R479 VSS.n1 VSS.n3 0.478536
R480 VSS.n375 VSS.n374 41.8353
R481 VSS.n449 VSS.n443 41.8061
R482 VSS.n416 VSS.n415 41.8061
R483 VSS.n687 VSS.n92 41.8061
R484 VSS.n351 VSS.n350 41.8061
R485 VSS.n653 VSS.n652 41.0742
R486 VSS.n663 VSS.n662 41.0283
R487 VSS.n676 VSS.n99 40.2505
R488 VSS.n233 VSS.n230 40.2505
R489 VSS.n429 VSS.n210 39.1048
R490 VSS.n512 VSS.t109 39.1048
R491 VSS.n156 VSS.t107 39.1048
R492 VSS.n585 VSS.n189 39.1048
R493 VSS.n429 VSS.t6 37.6565
R494 VSS.t5 VSS.t109 37.6565
R495 VSS.t103 VSS.t107 37.6565
R496 VSS.t23 VSS.n585 37.6565
R497 VSS.n521 VSS.n494 37.4797
R498 VSS.n148 VSS.n141 37.4797
R499 VSS.n362 VSS.n360 37.4797
R500 VSS.n574 VSS.n573 37.4797
R501 VSS.t79 VSS.t83 37.4645
R502 VSS.t46 VSS.t44 37.4645
R503 VSS.t38 VSS.t42 37.4645
R504 VSS.t123 VSS.t119 37.4645
R505 VSS.n458 VSS.n430 36.7505
R506 VSS.n348 VSS.n196 36.7505
R507 VSS.n661 VSS.n108 34.6116
R508 VSS.n535 VSS.n534 34.6116
R509 VSS.n484 VSS.n241 34.6116
R510 VSS.n274 VSS.n270 34.6116
R511 VSS.n564 VSS.n563 33.8338
R512 VSS.n563 VSS.n220 33.8338
R513 VSS.n504 VSS.n494 33.8338
R514 VSS.n510 VSS.n219 33.8338
R515 VSS.n511 VSS.n510 33.8338
R516 VSS.n135 VSS.n129 33.8338
R517 VSS.n153 VSS.n135 33.8338
R518 VSS.n617 VSS.n616 33.8338
R519 VSS.n617 VSS.n155 33.8338
R520 VSS.n629 VSS.n141 33.8338
R521 VSS.n363 VSS.n362 33.8338
R522 VSS.n188 VSS.n187 33.8338
R523 VSS.n187 VSS.n125 33.8338
R524 VSS.n596 VSS.n170 33.8338
R525 VSS.n596 VSS.n169 33.8338
R526 VSS.n573 VSS.n46 33.8338
R527 VSS.n572 VSS.n1 38.7417
R528 VSS.n438 VSS.n0 33.8338
R529 VSS.n3 VSS.n211 19.3724
R530 VSS.n4 VSS.n440 33.8338
R531 VSS.n539 VSS.n106 33.7181
R532 VSS.n64 VSS.n120 32.6185
R533 VSS.n675 VSS.n102 30.7227
R534 VSS.n676 VSS.n675 30.7227
R535 VSS.n467 VSS.n458 30.7227
R536 VSS.n467 VSS.n466 30.7227
R537 VSS.n238 VSS.n237 30.7227
R538 VSS.n238 VSS.n233 30.7227
R539 VSS.n368 VSS.n348 30.7227
R540 VSS.n368 VSS.n347 30.7227
R541 VSS.n511 VSS.n497 28.7297
R542 VSS.n155 VSS.n154 28.7297
R543 VSS.n361 VSS.n170 28.7297
R544 VSS.n329 VSS.n291 28.5838
R545 VSS.n305 VSS.n287 28.5838
R546 VSS.n300 VSS.n252 28.5838
R547 VSS.n452 VSS.n451 28.4866
R548 VSS.n5 VSS.n450 28.4866
R549 VSS.n414 VSS.n16 28.4866
R550 VSS.n559 VSS.n225 28.4866
R551 VSS.n91 VSS.n82 28.4866
R552 VSS.n692 VSS.n83 28.4866
R553 VSS.n600 VSS.n166 28.4866
R554 VSS.n601 VSS.n165 28.4866
R555 VSS.n497 VSS.n494 28.438
R556 VSS.n154 VSS.n141 28.438
R557 VSS.n362 VSS.n361 28.438
R558 VSS.n573 VSS.n572 28.438
R559 VSS.n331 VSS.n285 28.0005
R560 VSS.n331 VSS.n284 28.0005
R561 VSS.n466 VSS.n464 27.2227
R562 VSS.n471 VSS.n458 27.2227
R563 VSS.n237 VSS.n235 27.2227
R564 VSS.n553 VSS.n233 27.2227
R565 VSS.n372 VSS.n347 27.2227
R566 VSS.n348 VSS.n57 27.2227
R567 VSS.n673 VSS.n102 27.2227
R568 VSS.n677 VSS.n676 27.2227
R569 VSS.n318 VSS.n278 25.7644
R570 VSS.n297 VSS.n296 25.7644
R571 VSS.n382 VSS.n257 25.7644
R572 VSS.t72 VSS.n90 25.7463
R573 VSS.n482 VSS.n245 24.5005
R574 VSS.n388 VSS.n252 22.8477
R575 VSS.n306 VSS.n305 22.8477
R576 VSS.n325 VSS.n291 22.8477
R577 VSS.n591 VSS.n190 22.5762
R578 VSS.n571 VSS.n212 22.5762
R579 VSS.n513 VSS.n498 22.5691
R580 VSS.n610 VSS.n158 22.5691
R581 VSS.n321 VSS.n320 19.0561
R582 VSS.n316 VSS.n298 19.0561
R583 VSS.n383 VSS.n255 19.0561
R584 VSS.n288 VSS.n277 19.0561
R585 VSS.n448 VSS.n404 14.9197
R586 VSS.n417 VSS.n413 14.9197
R587 VSS.n145 VSS.n94 14.9197
R588 VSS.n352 VSS.n197 14.9197
R589 VSS.n11 VSS.n511 14.5838
R590 VSS.n621 VSS.n155 14.5838
R591 VSS.n594 VSS.n170 14.5838
R592 VSS.n680 VSS.n99 14.3894
R593 VSS.n556 VSS.n230 14.3894
R594 VSS.n679 VSS.t138 14.3617
R595 VSS.n469 VSS.t66 14.3617
R596 VSS.n555 VSS.t104 14.3617
R597 VSS.n579 VSS.t63 14.3617
R598 VSS.n652 VSS.n651 13.478
R599 VSS.n513 VSS.n218 12.1533
R600 VSS.n610 VSS.n128 12.1533
R601 VSS.n591 VSS.n126 12.1533
R602 VSS.n571 VSS.n211 12.1533
R603 VSS.n536 VSS.n535 12.1514
R604 VSS.n535 VSS.n527 12.1514
R605 VSS.n468 VSS.n430 10.8894
R606 VSS.n77 VSS.n196 10.8894
R607 VSS.n329 VSS.n278 9.13939
R608 VSS.n296 VSS.n287 9.13939
R609 VSS.n300 VSS.n257 9.13939
R610 VSS.n386 VSS.n255 9.13939
R611 VSS.n312 VSS.n298 9.13939
R612 VSS.n321 VSS.n317 9.13939
R613 VSS.n346 VSS.n277 9.13939
R614 VSS.n343 VSS.n277 8.55606
R615 VSS.n322 VSS.n321 8.55606
R616 VSS.n307 VSS.n298 8.55606
R617 VSS.n258 VSS.n255 8.55606
R618 VSS.n666 VSS.n115 8.26599
R619 VSS.n400 VSS.n66 6.80606
R620 VSS.n116 VSS.n104 6.80606
R621 VSS.n378 VSS.n49 6.70883
R622 VSS.n659 VSS.n658 6.51439
R623 VSS.n668 VSS.n109 6.51439
R624 VSS.n538 VSS.n537 6.51439
R625 VSS.n531 VSS.n528 6.51439
R626 VSS.n395 VSS.n394 6.51439
R627 VSS.n397 VSS.n240 6.51439
R628 VSS.n381 VSS.n380 6.51439
R629 VSS.n271 VSS.n267 6.51439
R630 VSS.n679 VSS.n678 6.2445
R631 VSS.n470 VSS.n469 6.2445
R632 VSS.n555 VSS.n554 6.2445
R633 VSS.n579 VSS.n199 6.2445
R634 VSS.n655 VSS.n115 6.2105
R635 VSS.n655 VSS.n654 6.2105
R636 VSS.n544 VSS.n543 6.16805
R637 VSS.n654 VSS.n653 5.38925
R638 VSS.n654 VSS.n116 5.36289
R639 VSS.n35 VSS.n66 5.36289
R640 VSS.n24 VSS.n49 5.36093
R641 VSS.n668 VSS.n667 5.35702
R642 VSS.n538 VSS.n524 5.35702
R643 VSS.n533 VSS.n531 5.35702
R644 VSS.n658 VSS.n115 5.35702
R645 VSS.n333 VSS.n240 5.35702
R646 VSS.n394 VSS.n35 5.35702
R647 VSS.n24 VSS.n381 5.35702
R648 VSS.n35 VSS.n267 5.35702
R649 VSS.n661 VSS.n660 5.11161
R650 VSS.n662 VSS.n661 5.11161
R651 VSS.n67 VSS.n66 5.08087
R652 VSS.n116 VSS.n65 5.07114
R653 VSS.n61 VSS.n544 5.05637
R654 VSS.n623 VSS.n118 5.01115
R655 VSS.n658 VSS.t105 4.98824
R656 VSS.t28 VSS.n538 4.98824
R657 VSS.n394 VSS.n53 4.98809
R658 VSS.n381 VSS.n54 4.98809
R659 VSS.n51 VSS.n49 4.98683
R660 VSS.n669 VSS.n668 4.63554
R661 VSS.n531 VSS.n529 4.63554
R662 VSS.n269 VSS.n267 4.63554
R663 VSS.n485 VSS.n240 4.63554
R664 VSS.t12 VSS.n89 4.5142
R665 VSS.n606 VSS.t57 4.5142
R666 VSS.n650 VSS.n63 4.50592
R667 VSS.n483 VSS.n35 4.47115
R668 VSS.n402 VSS.n401 4.37149
R669 VSS.n651 VSS.n120 4.163
R670 VSS.n664 VSS.n655 4.13854
R671 VSS.n113 VSS.n110 4.05496
R672 VSS.n606 VSS.n140 3.93574
R673 VSS.n542 VSS.n541 3.71007
R674 VSS.n545 VSS.n490 3.64321
R675 VSS.n272 VSS.n263 3.60498
R676 VSS.n245 VSS.n241 3.52605
R677 VSS.n396 VSS.n241 3.52605
R678 VSS.n683 VSS.n682 3.3645
R679 VSS.t14 VSS.n90 3.17398
R680 VSS.n42 VSS.n260 1.10004
R681 VSS.n44 VSS.n97 2.78854
R682 VSS.n558 VSS.n228 2.74354
R683 VSS.n544 VSS.n488 2.6255
R684 VSS.n592 VSS.n591 2.6005
R685 VSS.n591 VSS.n590 2.6005
R686 VSS.n571 VSS.n2 0.056506
R687 VSS.n514 VSS.n513 2.6005
R688 VSS.n611 VSS.n610 2.6005
R689 VSS.n610 VSS.n609 2.6005
R690 VSS.n477 VSS.n402 2.58849
R691 VSS.n50 VSS.n75 2.50043
R692 VSS.n242 VSS.n52 2.49651
R693 VSS.n28 VSS.n275 2.49651
R694 VSS.t8 VSS.n55 2.49456
R695 VSS.t27 VSS.n56 2.49456
R696 VSS.n266 VSS.n24 2.49115
R697 VSS.n73 VSS.n266 2.49115
R698 VSS.n523 VSS.n522 2.42702
R699 VSS.n624 VSS.n623 2.32485
R700 VSS.n624 VSS.n622 2.32485
R701 VSS.n649 VSS.n124 2.29134
R702 VSS.n644 VSS.n643 2.29134
R703 VSS.n358 VSS.n37 2.27985
R704 VSS.n34 VSS.n205 2.27985
R705 VSS.n588 VSS.n89 2.23079
R706 VSS.n694 VSS.n13 2.22373
R707 VSS.n365 VSS.n358 2.1468
R708 VSS.n522 VSS.n493 2.14485
R709 VSS.n435 VSS.n433 2.1005
R710 VSS.n508 VSS.n17 2.1005
R711 VSS.t36 VSS.n14 1.05376
R712 VSS.n13 VSS.n507 2.1005
R713 VSS.n506 VSS.n505 2.1005
R714 VSS.t86 VSS.n171 2.1005
R715 VSS.n364 VSS.n357 2.1005
R716 VSS.n641 VSS.n640 2.1005
R717 VSS.n640 VSS.n639 2.1005
R718 VSS.n634 VSS.n630 2.1005
R719 VSS.n631 VSS.n119 2.1005
R720 VSS.n139 VSS.n119 2.1005
R721 VSS.n185 VSS.n174 2.1005
R722 VSS.n185 VSS.n184 2.1005
R723 VSS.n48 VSS.n431 2.1005
R724 VSS.t86 VSS.n582 1.97647
R725 VSS.n143 VSS.t108 1.97545
R726 VSS.n410 VSS.t110 1.97545
R727 VSS.n683 VSS.n96 1.9525
R728 VSS.n622 VSS.n140 1.9492
R729 VSS.n34 VSS.n577 1.93833
R730 VSS.n425 VSS.n226 1.91007
R731 VSS.t12 VSS.t14 1.91007
R732 VSS.t57 VSS.t59 1.91007
R733 VSS.n356 VSS.n161 1.91007
R734 VSS.n446 VSS.n213 1.91007
R735 VSS.n532 VSS.n525 1.8592
R736 VSS.n243 VSS.n244 1.8592
R737 VSS.n665 VSS.n114 1.8592
R738 VSS.n601 VSS.n121 1.81114
R739 VSS.n393 VSS.n248 1.76873
R740 VSS.n475 VSS.t68 1.75819
R741 VSS.n608 VSS.n607 1.71313
R742 VSS.n36 VSS.n35 1.68931
R743 VSS.n80 VSS.n79 1.65572
R744 VSS.n517 VSS.n516 1.65572
R745 VSS.n359 VSS.n193 1.65572
R746 VSS.n625 VSS.n624 1.65572
R747 VSS.t86 VSS.n356 1.52463
R748 VSS.t8 VSS.n108 1.46531
R749 VSS.n534 VSS.t27 1.46531
R750 VSS.n484 VSS.n242 1.46531
R751 VSS.n28 VSS.n270 1.46531
R752 VSS.n523 VSS.n491 1.44778
R753 VSS.n651 VSS.n43 1.44446
R754 VSS.t72 VSS.n101 1.43723
R755 VSS.n516 VSS.n13 1.42911
R756 VSS.n530 VSS.n524 1.38526
R757 VSS.n651 VSS.n650 1.37869
R758 VSS.t86 VSS.n43 1.4109
R759 VSS.n650 VSS.n82 1.35198
R760 VSS.n312 VSS.t129 1.3005
R761 VSS.t130 VSS.n312 1.3005
R762 VSS.n386 VSS.t91 1.3005
R763 VSS.t54 VSS.n386 1.3005
R764 VSS.t16 VSS.n330 1.3005
R765 VSS.n330 VSS.n283 1.3005
R766 VSS.t16 VSS.n331 1.3005
R767 VSS.n331 VSS.t17 1.3005
R768 VSS.n332 VSS.t16 1.3005
R769 VSS.t22 VSS.n332 1.3005
R770 VSS.n317 VSS.t9 1.3005
R771 VSS.n317 VSS.t10 1.3005
R772 VSS.n346 VSS.t9 1.3005
R773 VSS.t62 VSS.n346 1.3005
R774 VSS.n677 VSS.n97 1.29841
R775 VSS.n541 VSS.n525 1.28007
R776 VSS.n37 VSS.n204 1.25382
R777 VSS.n359 VSS.n26 1.21354
R778 VSS.n35 VSS.n20 0.138156
R779 VSS.t68 VSS.n21 0.135578
R780 VSS.n504 VSS.n503 1.16717
R781 VSS.n629 VSS.n142 1.16717
R782 VSS.n363 VSS.n202 1.16717
R783 VSS.n437 VSS.n46 1.16717
R784 VSS.n344 VSS.n279 1.16717
R785 VSS.n293 VSS.n286 1.16717
R786 VSS.n314 VSS.n301 1.16717
R787 VSS.n72 VSS.n259 1.16717
R788 VSS.n626 VSS.n118 1.16097
R789 VSS.n39 VSS.n44 1.15485
R790 VSS.n607 VSS.n161 1.14577
R791 VSS.n81 VSS.n226 1.11977
R792 VSS.n693 VSS.n692 1.10231
R793 VSS.n42 VSS.n41 0.225897
R794 VSS.t96 VSS.n131 1.07971
R795 VSS.n633 VSS.t98 1.07971
R796 VSS.n1 VSS.t131 0.371866
R797 VSS.n500 VSS.t77 1.07971
R798 VSS.t111 VSS.n432 1.07971
R799 VSS.n22 VSS.t24 1.05376
R800 VSS.n183 VSS.t100 1.07971
R801 VSS.n175 VSS.t73 1.07971
R802 VSS.n137 VSS.t93 1.07971
R803 VSS.n588 VSS.n96 1.0665
R804 VSS.n552 VSS.n232 1.05937
R805 VSS.n589 VSS.n587 1.04874
R806 VSS.n587 VSS.n193 1.04874
R807 VSS.n204 VSS.n193 1.04874
R808 VSS.n12 VSS.n79 1.04874
R809 VSS.n577 VSS.n79 1.04874
R810 VSS.n517 VSS.n491 1.04874
R811 VSS.n15 VSS.n517 1.04874
R812 VSS.n626 VSS.n625 1.04874
R813 VSS.n625 VSS.n152 1.04874
R814 VSS.n608 VSS.n152 1.04874
R815 VSS.n675 VSS.t79 1.0405
R816 VSS.n675 VSS.n44 1.0405
R817 VSS.n678 VSS.n677 1.0405
R818 VSS.t79 VSS.n101 1.0405
R819 VSS.n674 VSS.n673 1.0405
R820 VSS.n673 VSS.n39 1.0405
R821 VSS.n316 VSS.n315 1.0405
R822 VSS.n309 VSS.n308 1.0405
R823 VSS.n310 VSS.n309 1.0405
R824 VSS.n383 VSS.t54 1.0405
R825 VSS.n254 VSS.n251 1.0405
R826 VSS.n388 VSS.n387 1.0405
R827 VSS.n297 VSS.n290 1.0405
R828 VSS.n297 VSS.t10 1.0405
R829 VSS.n306 VSS.n281 1.0405
R830 VSS.n306 VSS.n304 1.0405
R831 VSS.n318 VSS.t62 1.0405
R832 VSS.n320 VSS.t62 1.0405
R833 VSS.n323 VSS.n292 1.0405
R834 VSS.n326 VSS.n325 1.0405
R835 VSS.t62 VSS.n30 1.0405
R836 VSS.n342 VSS.n280 1.0405
R837 VSS.n340 VSS.n339 1.0405
R838 VSS.t44 VSS.n459 1.0405
R839 VSS.n461 VSS.n459 1.0405
R840 VSS.n471 VSS.n470 1.0405
R841 VSS.t68 VSS.n471 1.0405
R842 VSS.n464 VSS.n463 1.0405
R843 VSS.n464 VSS.n462 1.0405
R844 VSS.t44 VSS.n467 1.0405
R845 VSS.n467 VSS.n18 1.0405
R846 VSS.n453 VSS.n5 1.0405
R847 VSS.n452 VSS.n216 1.0405
R848 VSS.n452 VSS.n1 1.02313
R849 VSS.n560 VSS.n559 1.0405
R850 VSS.n16 VSS.n224 1.0405
R851 VSS.t38 VSS.n238 1.0405
R852 VSS.n238 VSS.n228 1.0405
R853 VSS.n554 VSS.n553 1.0405
R854 VSS.n553 VSS.n71 1.0405
R855 VSS.t38 VSS.n232 1.0405
R856 VSS.n239 VSS.n235 1.0405
R857 VSS.n551 VSS.n235 1.0405
R858 VSS.n692 VSS.n691 1.0405
R859 VSS.n614 VSS.n82 1.0405
R860 VSS.n600 VSS.n599 1.0405
R861 VSS.n600 VSS.t86 1.0405
R862 VSS.n369 VSS.t123 1.0405
R863 VSS.n370 VSS.n369 1.0405
R864 VSS.n57 VSS.n199 1.0405
R865 VSS.t86 VSS.n57 1.0405
R866 VSS.n373 VSS.n372 1.0405
R867 VSS.n372 VSS.n371 1.0405
R868 VSS.t123 VSS.n368 1.0405
R869 VSS.n602 VSS.n601 1.0405
R870 VSS.n28 VSS.n73 1.03757
R871 VSS.t62 VSS.n60 0.0859664
R872 VSS.n33 VSS.n295 0.0643952
R873 VSS.t135 VSS.n42 0.598506
R874 VSS.n313 VSS.n40 0.0643952
R875 VSS.n338 VSS.n282 1.03043
R876 VSS.t126 VSS.t128 1.02629
R877 VSS.t33 VSS.t31 1.02629
R878 VSS.t90 VSS.n333 1.0156
R879 VSS.n389 VSS.n251 1.00079
R880 VSS.n325 VSS.n324 1.00079
R881 VSS.n342 VSS.n341 1.00079
R882 VSS.n341 VSS.n340 1.00079
R883 VSS.n389 VSS.n388 1.00079
R884 VSS.n324 VSS.n323 1.00079
R885 VSS.n384 VSS.n382 1.00072
R886 VSS.n319 VSS.n318 1.00072
R887 VSS.n289 VSS.n30 1.00072
R888 VSS.n320 VSS.n319 1.00072
R889 VSS.n384 VSS.n383 1.00072
R890 VSS.n289 VSS.n288 1.00072
R891 VSS.n590 VSS.n589 0.9905
R892 VSS.n13 VSS.n12 1.60826
R893 VSS.n13 VSS.n15 1.61935
R894 VSS.n609 VSS.n608 0.9905
R895 VSS VSS.n694 0.9257
R896 VSS.n425 VSS.n424 0.910283
R897 VSS.n8 VSS.n213 0.910283
R898 VSS.n632 VSS.n122 0.906844
R899 VSS.n63 VSS.n62 0.87556
R900 VSS.n64 VSS.n130 0.87556
R901 VSS.n629 VSS.n628 0.867167
R902 VSS.n630 VSS.n629 0.867167
R903 VSS.n46 VSS.n208 0.867167
R904 VSS.n48 VSS.n46 0.867167
R905 VSS.n454 VSS.n0 0.867167
R906 VSS.n1 VSS.n0 0.595972
R907 VSS.n4 VSS.n457 0.867167
R908 VSS.n3 VSS.n4 0.380412
R909 VSS.n566 VSS.n565 0.867167
R910 VSS.n565 VSS.n13 0.867167
R911 VSS.n439 VSS.n217 0.867167
R912 VSS.n439 VSS.n13 0.867167
R913 VSS.n563 VSS.n562 0.867167
R914 VSS.n563 VSS.n17 0.867167
R915 VSS.n510 VSS.n509 0.867167
R916 VSS.n510 VSS.n13 0.867167
R917 VSS.n504 VSS.n496 0.867167
R918 VSS.n505 VSS.n504 0.867167
R919 VSS.n597 VSS.n596 0.867167
R920 VSS.n596 VSS.t86 0.867167
R921 VSS.n648 VSS.n647 0.867167
R922 VSS.n649 VSS.n648 0.867167
R923 VSS.n618 VSS.n617 0.867167
R924 VSS.n617 VSS.n119 0.867167
R925 VSS.n646 VSS.n645 0.867167
R926 VSS.n645 VSS.n644 0.867167
R927 VSS.n187 VSS.n186 0.867167
R928 VSS.n187 VSS.n185 0.867167
R929 VSS.n363 VSS.n195 0.867167
R930 VSS.n364 VSS.n363 0.867167
R931 VSS.n612 VSS.n135 0.867167
R932 VSS.n640 VSS.n135 0.867167
R933 VSS.n665 VSS.n664 0.851587
R934 VSS.n123 VSS.n89 0.848345
R935 VSS.n36 VSS 0.812525
R936 VSS.n59 VSS.n228 0.844585
R937 VSS.n236 VSS.n229 0.788102
R938 VSS.n477 VSS.n476 0.787682
R939 VSS.n112 VSS.n98 0.784334
R940 VSS.n47 VSS.n205 0.782971
R941 VSS.n74 VSS.n76 0.778287
R942 VSS.n23 VSS.n31 0.130326
R943 VSS.n460 VSS.n18 0.772032
R944 VSS.t68 VSS.n20 0.403418
R945 VSS.n220 VSS.n218 0.729667
R946 VSS.n153 VSS.n128 0.729667
R947 VSS.n188 VSS.n126 0.729667
R948 VSS.n530 VSS.n533 0.725703
R949 VSS.n653 VSS.n117 0.723312
R950 VSS.n13 VSS.n16 1.06105
R951 VSS.n80 VSS.n1 0.691544
R952 VSS.t54 VSS.n28 0.687571
R953 VSS.t118 VSS.n21 0.384738
R954 VSS.n669 VSS.n108 0.663078
R955 VSS.n534 VSS.n529 0.663078
R956 VSS.n485 VSS.n484 0.663078
R957 VSS.n270 VSS.n269 0.663078
R958 VSS.n667 VSS.n666 0.646316
R959 VSS.n490 VSS.n236 0.638584
R960 VSS.t61 VSS.n81 0.634109
R961 VSS.n671 VSS.n670 0.6249
R962 VSS.n487 VSS.n106 0.6249
R963 VSS.n402 VSS.n244 0.599054
R964 VSS.n333 VSS.n244 0.599054
R965 VSS.n113 VSS.n112 0.596019
R966 VSS.n543 VSS.n234 0.591929
R967 VSS.n143 VSS.n98 0.587532
R968 VSS.n410 VSS.n229 0.587532
R969 VSS.n582 VSS.n76 0.586952
R970 VSS.n476 VSS.n475 0.586952
R971 VSS.n75 VSS.n74 0.584073
R972 VSS.n96 VSS.n95 0.578278
R973 VSS.n684 VSS.n683 0.578278
R974 VSS.n443 VSS.n442 0.578278
R975 VSS.n443 VSS.t128 0.578278
R976 VSS.n447 VSS.n446 0.578278
R977 VSS.n444 VSS.n213 0.578278
R978 VSS.n570 VSS.n569 0.578278
R979 VSS.t126 VSS.n570 0.578278
R980 VSS.n427 VSS.n426 0.578278
R981 VSS.n426 VSS.n425 0.578278
R982 VSS.n419 VSS.n418 0.578278
R983 VSS.n418 VSS.n226 0.578278
R984 VSS.n423 VSS.n422 0.578278
R985 VSS.t33 VSS.n423 0.578278
R986 VSS.n415 VSS.n408 0.578278
R987 VSS.n415 VSS.t31 0.578278
R988 VSS.n689 VSS.n688 0.578278
R989 VSS.n688 VSS.t12 0.578278
R990 VSS.n687 VSS.n686 0.578278
R991 VSS.t14 VSS.n687 0.578278
R992 VSS.n350 VSS.n349 0.578278
R993 VSS.n350 VSS.t59 0.578278
R994 VSS.n356 VSS.n355 0.578278
R995 VSS.n605 VSS.n604 0.578278
R996 VSS.t57 VSS.n605 0.578278
R997 VSS.n353 VSS.n161 0.578278
R998 VSS.n434 VSS.n19 0.573227
R999 VSS.n80 VSS.n78 0.573227
R1000 VSS.n501 VSS.n9 0.573227
R1001 VSS.n499 VSS.n227 0.573227
R1002 VSS.n177 VSS.n176 0.573227
R1003 VSS.n181 VSS.n25 0.573227
R1004 VSS.n179 VSS.n178 0.573227
R1005 VSS.n182 VSS.n172 0.573227
R1006 VSS.n367 VSS.n366 0.573227
R1007 VSS.n136 VSS.n122 0.573227
R1008 VSS.n642 VSS.n121 0.573227
R1009 VSS.n133 VSS.n132 0.573227
R1010 VSS.n636 VSS.n635 0.573227
R1011 VSS.n138 VSS.n638 0.573227
R1012 VSS.n62 VSS.n649 0.568693
R1013 VSS.n644 VSS.n130 0.568693
R1014 VSS.t31 VSS.t61 0.551545
R1015 VSS.n433 VSS.n19 0.53932
R1016 VSS.n336 VSS.n283 0.5305
R1017 VSS.n339 VSS.n280 0.526654
R1018 VSS.n387 VSS.n254 0.526654
R1019 VSS.n310 VSS.n304 0.526654
R1020 VSS.n326 VSS.n292 0.526654
R1021 VSS.n243 VSS.n483 0.518978
R1022 VSS.n653 VSS.n118 0.515192
R1023 VSS.n630 VSS.n117 0.50901
R1024 VSS.n368 VSS.n23 1.29499
R1025 VSS.t68 VSS.n18 0.505283
R1026 VSS.n681 VSS.t84 0.502582
R1027 VSS.n557 VSS.t43 0.502582
R1028 VSS.t22 VSS.n282 0.501763
R1029 VSS.n433 VSS.n1 0.496952
R1030 VSS.n327 VSS.n276 0.484155
R1031 VSS.n303 VSS.n295 0.484155
R1032 VSS.n313 VSS.n253 0.484155
R1033 VSS.n374 VSS.n198 0.473227
R1034 VSS.t122 VSS.n198 0.473227
R1035 VSS.n680 VSS.n679 0.473227
R1036 VSS.t84 VSS.n680 0.473227
R1037 VSS.n111 VSS.n103 0.473227
R1038 VSS.t82 VSS.n111 0.473227
R1039 VSS.t133 VSS.n300 0.473227
R1040 VSS.n300 VSS.n299 0.473227
R1041 VSS.t133 VSS.n314 0.473227
R1042 VSS.n314 VSS.n313 0.473227
R1043 VSS.n72 VSS.n41 0.473227
R1044 VSS.t34 VSS.n287 0.473227
R1045 VSS.n302 VSS.n287 0.473227
R1046 VSS.t34 VSS.n286 0.473227
R1047 VSS.n295 VSS.n286 0.473227
R1048 VSS.t34 VSS.n329 0.473227
R1049 VSS.n329 VSS.n328 0.473227
R1050 VSS.t34 VSS.n279 0.473227
R1051 VSS.n279 VSS.n276 0.473227
R1052 VSS.n469 VSS.n468 0.473227
R1053 VSS.n465 VSS.n247 0.473227
R1054 VSS.n465 VSS.t49 0.473227
R1055 VSS.n556 VSS.n555 0.473227
R1056 VSS.t43 VSS.n556 0.473227
R1057 VSS.n550 VSS.n549 0.473227
R1058 VSS.t41 VSS.n550 0.473227
R1059 VSS.n77 VSS.n579 0.473227
R1060 VSS.t15 VSS.n72 0.470934
R1061 VSS.n8 VSS.t126 0.468397
R1062 VSS.n424 VSS.t33 0.468397
R1063 VSS.n328 VSS.n327 0.465754
R1064 VSS.n303 VSS.n302 0.465754
R1065 VSS.n299 VSS.n253 0.465754
R1066 VSS.t118 VSS.t128 0.425354
R1067 VSS.n133 VSS.n130 0.407103
R1068 VSS.t17 VSS.n282 0.37366
R1069 VSS.n335 VSS.t17 0.37366
R1070 VSS.t68 VSS.n1 0.365794
R1071 VSS.n45 VSS.t47 0.0795007
R1072 VSS.n476 VSS.t47 0.361489
R1073 VSS.n234 VSS.n69 0.349786
R1074 VSS.n191 VSS.n189 0.347167
R1075 VSS.n192 VSS.n191 0.347167
R1076 VSS.n150 VSS.t138 0.347167
R1077 VSS.n150 VSS.n117 0.347167
R1078 VSS.n436 VSS.t66 0.347167
R1079 VSS.n436 VSS.n48 0.347167
R1080 VSS.n7 VSS.n210 0.347167
R1081 VSS.n13 VSS.n7 0.347167
R1082 VSS.n502 VSS.t104 0.347167
R1083 VSS.n502 VSS.n492 0.347167
R1084 VSS.n6 VSS.n512 0.347167
R1085 VSS.n13 VSS.n6 0.347167
R1086 VSS.n159 VSS.n156 0.347167
R1087 VSS.n160 VSS.n159 0.347167
R1088 VSS.t63 VSS.n578 0.347167
R1089 VSS.n13 VSS.n8 0.201298
R1090 VSS.n192 VSS.n89 0.337093
R1091 VSS.n606 VSS.n160 0.337093
R1092 VSS.n13 VSS.t61 0.169816
R1093 VSS.n339 VSS.n338 0.326897
R1094 VSS.n43 VSS.n63 0.324584
R1095 VSS.t86 VSS.n64 2.67931
R1096 VSS.n81 VSS.n558 0.301709
R1097 VSS.t84 VSS.n98 0.290894
R1098 VSS.t43 VSS.n229 0.290894
R1099 VSS.n650 VSS.t72 0.288581
R1100 VSS.n636 VSS.n630 0.287122
R1101 VSS.n694 VSS.n693 0.28175
R1102 VSS.n147 VSS.n146 0.274184
R1103 VSS.n146 VSS.t108 0.274184
R1104 VSS.n144 VSS.n143 0.274184
R1105 VSS.n475 VSS.n474 0.274184
R1106 VSS.n473 VSS.n472 0.274184
R1107 VSS.n472 VSS.t68 0.274184
R1108 VSS.n411 VSS.n410 0.274184
R1109 VSS.n412 VSS.n409 0.274184
R1110 VSS.n412 VSS.t110 0.274184
R1111 VSS.n582 VSS.n581 0.274184
R1112 VSS.n584 VSS.n583 0.274184
R1113 VSS.n583 VSS.t86 0.274184
R1114 VSS.n590 VSS.n192 0.263577
R1115 VSS.n609 VSS.n160 0.263577
R1116 VSS.n607 VSS.n606 0.263577
R1117 VSS.n365 VSS.n364 0.258236
R1118 VSS.n505 VSS.n493 0.257932
R1119 VSS.t86 VSS.n23 0.0856128
R1120 VSS.n682 VSS.n681 0.2565
R1121 VSS.n492 VSS.n70 0.255313
R1122 VSS.n578 VSS.t86 0.434426
R1123 VSS.n505 VSS.n70 0.254198
R1124 VSS.n364 VSS.t86 0.254198
R1125 VSS.n20 VSS.n29 0.19745
R1126 VSS.n651 VSS.n121 0.246032
R1127 VSS.n387 VSS.n253 0.245775
R1128 VSS.n304 VSS.n303 0.245775
R1129 VSS.n327 VSS.n326 0.245775
R1130 VSS.n254 VSS.t21 0.243569
R1131 VSS.t1 VSS.n292 0.243569
R1132 VSS.t19 VSS.n310 0.243569
R1133 VSS.n280 VSS.t106 0.243569
R1134 VSS.n13 VSS.n9 0.198849
R1135 VSS.n637 VSS.n636 0.238878
R1136 VSS.n638 VSS.n637 0.238878
R1137 VSS.n134 VSS.n133 0.238878
R1138 VSS.n334 VSS.t22 0.238797
R1139 VSS.n273 VSS.n272 0.235575
R1140 VSS.t82 VSS.n39 0.223735
R1141 VSS.n203 VSS.n200 0.217167
R1142 VSS.n204 VSS.n203 0.217167
R1143 VSS.n587 VSS.n586 0.217167
R1144 VSS.t102 VSS.n148 0.217167
R1145 VSS.n623 VSS.n148 0.217167
R1146 VSS.t102 VSS.n627 0.217167
R1147 VSS.n627 VSS.n626 0.217167
R1148 VSS.n576 VSS.n575 0.217167
R1149 VSS.n577 VSS.n576 0.217167
R1150 VSS.n575 VSS.n574 0.217167
R1151 VSS.n574 VSS.n205 0.217167
R1152 VSS.n428 VSS.n12 0.217167
R1153 VSS.n11 VSS.n515 0.217167
R1154 VSS.n521 VSS.t4 0.217167
R1155 VSS.n522 VSS.n521 0.217167
R1156 VSS.t4 VSS.n520 0.217167
R1157 VSS.n520 VSS.n491 0.217167
R1158 VSS.n518 VSS.n15 0.217167
R1159 VSS.n594 VSS.n593 0.217167
R1160 VSS.n595 VSS.n594 0.217167
R1161 VSS.n621 VSS.n620 0.217167
R1162 VSS.n622 VSS.n621 0.217167
R1163 VSS.n157 VSS.n152 0.217167
R1164 VSS.n360 VSS.n200 0.217167
R1165 VSS.n360 VSS.n358 0.217167
R1166 VSS.n180 VSS.n179 0.206816
R1167 VSS.n180 VSS.n172 0.206816
R1168 VSS.n35 VSS.n34 0.203247
R1169 VSS.n328 VSS.t62 0.202172
R1170 VSS.n302 VSS.t10 0.202172
R1171 VSS.n371 VSS.n370 0.201797
R1172 VSS.n462 VSS.n461 0.201797
R1173 VSS.n377 VSS.n376 0.2005
R1174 VSS.n377 VSS.n264 0.2005
R1175 VSS.n265 VSS.n262 0.2005
R1176 VSS.n266 VSS.n262 0.2005
R1177 VSS.n533 VSS.n532 0.197643
R1178 VSS.n532 VSS.n490 0.197643
R1179 VSS.n558 VSS.n557 0.195711
R1180 VSS.n62 VSS.n123 0.189927
R1181 VSS.n29 VSS.t49 0.189799
R1182 VSS.t27 VSS.n530 0.189747
R1183 VSS.n638 VSS.n140 0.186581
R1184 VSS.n47 VSS.n80 0.183658
R1185 VSS.n366 VSS.n26 0.183236
R1186 VSS.n516 VSS.n493 0.1805
R1187 VSS.n365 VSS.n359 0.178543
R1188 VSS.n682 VSS.n97 0.176552
R1189 VSS.t86 VSS.n24 0.176245
R1190 VSS.n513 VSS.n13 2.66423
R1191 VSS.t27 VSS.n525 0.170637
R1192 VSS.n176 VSS.n173 0.164212
R1193 VSS.n25 VSS.n173 0.164212
R1194 VSS.n179 VSS.n123 0.164184
R1195 VSS.n68 VSS.n234 0.163608
R1196 VSS.n460 VSS.n29 0.16288
R1197 VSS.n299 VSS.t54 0.149972
R1198 VSS.n264 VSS.n31 0.138173
R1199 VSS.t120 VSS.n77 0.504603
R1200 VSS.n260 VSS.t15 0.472831
R1201 VSS.t120 VSS.n76 0.435863
R1202 VSS.n468 VSS.n45 0.500549
R1203 VSS.n548 VSS.n547 0.133833
R1204 VSS.n547 VSS.n58 0.133833
R1205 VSS.n540 VSS.n539 0.133833
R1206 VSS.n541 VSS.n540 0.133833
R1207 VSS.n24 VSS.n37 0.127096
R1208 VSS.n667 VSS.n114 0.126272
R1209 VSS.n114 VSS.n113 0.126272
R1210 VSS.n479 VSS.n478 0.124233
R1211 VSS.t86 VSS.t120 0.171973
R1212 VSS.n110 VSS.n65 0.125238
R1213 VSS.n45 VSS.t68 0.0731514
R1214 VSS.n24 VSS.n36 0.121036
R1215 VSS.n335 VSS.n334 0.1199
R1216 VSS.n38 VSS.n672 0.118682
R1217 VSS.n663 VSS.n107 0.118682
R1218 VSS.n664 VSS.n663 0.118682
R1219 VSS.n551 VSS.n59 0.0317124
R1220 VSS.n176 VSS.n43 0.118064
R1221 VSS.n401 VSS.n67 0.116998
R1222 VSS.n461 VSS.t68 0.114842
R1223 VSS.n334 VSS.t62 0.114661
R1224 VSS.n480 VSS.n479 0.111138
R1225 VSS.n482 VSS.n481 0.111138
R1226 VSS.n483 VSS.n482 0.111138
R1227 VSS.n424 VSS.n13 0.182166
R1228 VSS.n370 VSS.t86 0.104316
R1229 VSS.t10 VSS.n32 0.0227458
R1230 VSS.t140 VSS.n1 0.501672
R1231 VSS.n13 VSS.n10 0.629196
R1232 VSS.n595 VSS.n172 0.101553
R1233 VSS.t10 VSS.n33 0.0859664
R1234 VSS.n40 VSS.t130 0.0859664
R1235 VSS.t21 VSS.t54 0.0996525
R1236 VSS.n60 VSS.t106 0.00706177
R1237 VSS.t41 VSS.n236 0.0966785
R1238 VSS.n338 VSS.n337 0.095398
R1239 VSS.n13 VSS.n11 0.239435
R1240 VSS.n338 VSS.n283 0.0905
R1241 VSS.n651 VSS.n122 0.0885851
R1242 VSS.n59 VSS.n58 0.0577379
R1243 VSS.n58 VSS.t41 0.0866541
R1244 VSS.n337 VSS.t62 0.0851
R1245 VSS.n336 VSS.n335 0.0803
R1246 VSS.t130 VSS.t54 0.0794085
R1247 VSS.n478 VSS.n477 0.0762412
R1248 VSS.n666 VSS.t8 0.0761986
R1249 VSS.n48 VSS.n47 0.0755
R1250 VSS.n60 VSS.n276 0.0643952
R1251 VSS.t1 VSS.n33 0.00706177
R1252 VSS.n40 VSS.t19 0.00706177
R1253 VSS.t21 VSS.n41 0.0744797
R1254 VSS.n523 VSS.n492 0.0732985
R1255 VSS.n288 VSS.t62 1.06113
R1256 VSS.t65 VSS.n669 0.071682
R1257 VSS.n529 VSS.t75 0.071682
R1258 VSS.n269 VSS.n268 0.071682
R1259 VSS.n486 VSS.n485 0.071682
R1260 VSS.n552 VSS.n551 0.0693118
R1261 VSS.t8 VSS.n665 0.0685548
R1262 VSS.t68 VSS.n19 0.0670445
R1263 VSS.n74 VSS.t122 0.0637862
R1264 VSS.n112 VSS.t82 0.059903
R1265 VSS.n140 VSS.n134 0.0527973
R1266 VSS.n382 VSS.t54 1.06507
R1267 VSS.n75 VSS.n35 0.0511543
R1268 VSS.n75 VSS.n73 0.05018
R1269 VSS.t130 VSS.n32 0.0178328
R1270 VSS.n242 VSS.n243 0.0469299
R1271 VSS.n71 VSS.n69 0.0453258
R1272 VSS.t90 VSS.n242 0.0449953
R1273 VSS.n543 VSS.n542 0.0426657
R1274 VSS.n640 VSS.n120 0.0423342
R1275 VSS.n640 VSS.n134 0.0423342
R1276 VSS.n652 VSS.n119 0.0423342
R1277 VSS.n637 VSS.n119 0.0423342
R1278 VSS.n185 VSS.n180 0.0423342
R1279 VSS.n185 VSS.n173 0.0423342
R1280 VSS.t86 VSS.n25 0.164179
R1281 VSS.n68 VSS.n552 0.0382289
R1282 VSS.n523 VSS.n69 0.0356871
R1283 VSS.n10 VSS.t36 0.0343415
R1284 VSS.n500 VSS.n499 0.0343415
R1285 VSS.t77 VSS.n501 0.0343415
R1286 VSS.t113 VSS.n13 0.441534
R1287 VSS.n642 VSS.t96 0.0343415
R1288 VSS.n132 VSS.n131 0.0343415
R1289 VSS.n633 VSS.n632 0.0343415
R1290 VSS.n635 VSS.t98 0.0343415
R1291 VSS.n137 VSS.n136 0.0343415
R1292 VSS.t93 VSS.n138 0.0343415
R1293 VSS.t24 VSS.n367 0.0343415
R1294 VSS.n183 VSS.n182 0.0343415
R1295 VSS.t100 VSS.n181 0.0343415
R1296 VSS.n178 VSS.n175 0.0343415
R1297 VSS.t73 VSS.n177 0.0343415
R1298 VSS.n78 VSS.n432 0.0343415
R1299 VSS.t111 VSS.n434 0.0343415
R1300 VSS.n478 VSS.t49 0.0306586
R1301 VSS.n681 VSS.t108 0.0299059
R1302 VSS.n557 VSS.t110 0.0299059
R1303 VSS.n9 VSS.n493 0.0296892
R1304 VSS.n366 VSS.n365 0.0293851
R1305 VSS.t122 VSS.n264 0.0289629
R1306 VSS.n71 VSS.n68 0.0265129
R1307 VSS.n337 VSS.n336 0.02585
R1308 VSS.n227 VSS.t61 0.025586
R1309 VSS.n334 VSS.t90 0.0255714
R1310 VSS.n558 VSS.n70 0.0249344
R1311 VSS.n542 VSS.n524 0.0245698
R1312 VSS.n71 VSS.n70 0.0226538
R1313 VSS.n558 VSS.n227 0.022043
R1314 VSS.n97 VSS.n90 0.0220217
R1315 VSS.t59 VSS.t86 0.973907
R1316 VSS.n693 VSS.n63 0.257612
R1317 VSS.t28 VSS.n56 0.217812
R1318 VSS.t105 VSS.n55 0.217812
R1319 VSS.n53 VSS.n52 0.217812
R1320 VSS.n275 VSS.n54 0.217812
R1321 VSS.n51 VSS.n50 0.21781
R1322 VSS.n39 VSS.n38 0.163151
R1323 VSS.n545 VSS.n61 0.141938
R1324 VSS.t135 VSS.n24 0.126633
R1325 VSS.n385 VSS.n384 0.0211397
R1326 VSS.n319 VSS.n290 0.0211397
R1327 VSS.n290 VSS.n289 0.0211397
R1328 VSS.n390 VSS.n389 0.0211033
R1329 VSS.n324 VSS.n281 0.0211033
R1330 VSS.n341 VSS.n281 0.0211033
R1331 VSS.n543 VSS.n523 0.0196424
R1332 VSS.n371 VSS.n31 0.0160639
R1333 VSS.n462 VSS.n460 0.0160639
R1334 VSS.n595 VSS.t86 0.105835
R1335 VSS.n27 VSS.t10 0.0615359
R1336 VSS.t10 VSS.t54 0.0858277
R1337 VSS.n48 VSS.t68 0.0844219
R1338 VSS.n35 VSS.n27 0.0195174
R1339 VSS.n316 VSS.n32 1.07589
R1340 VSS.t86 VSS.n26 0.275272
R1341 VSS.n27 VSS.t62 0.0509132
R1342 VSS.t54 VSS.t135 0.255319
R1343 VSS.n21 VSS.n446 1.60358
R1344 VSS.n13 VSS.n1 1.05007
C0 x3.x1.OUT a_15194_2316# 0.04672f
C1 a_7826_n3532# x4.R 0.34548f
C2 a_24585_7807# VDD 0.2709f
C3 x4.x2.VREF a_13332_n3532# 0.44258f
C4 a_8255_9487# a_7053_11204# 0.00342f
C5 OUT3 a_24585_5535# 0.00312f
C6 a_10118_n1734# a_7826_n3532# 0.03669f
C7 a_5659_8494# a_4555_8494# 0.00396f
C8 a_15196_11256# a_15196_10948# 0.13302f
C9 a_16370_2316# x3.x1.OUT 1.73099f
C10 x3.x1.OUT VDD 1.90779f
C11 a_17438_7845# a_13334_5100# 0.00342f
C12 a_13334_5100# x3.R 0.05923f
C13 S0N VDD 1.13376f
C14 a_9519_1339# a_11883_1747# 0.03516f
C15 a_8253_855# VDD 0.00997f
C16 a_15708_n1887# a_17436_n787# 0.0341f
C17 a_9896_5320# x2.x1.OUT 0.01363f
C18 a_21973_4138# OUT3 0.01814f
C19 OUT a_25077_2267# 0.01955f
C20 a_7828_5100# a_10120_6898# 0.03669f
C21 EN4 a_24585_3263# 0.00438f
C22 EN2 S1N 0.20331f
C23 a_15754_7245# a_14302_7845# 0.03516f
C24 a_11883_1747# x3.x2.VREF 0.00957f
C25 a_17436_n787# VDD 0.00387f
C26 EN1 S1N 0.71779f
C27 a_25077_9083# S0N 0.30358f
C28 a_7828_5100# VDD 6.26809f
C29 OUT a_24585_7807# 0.07844f
C30 x1.R a_7053_11204# 0.06981f
C31 a_16370_2316# a_15194_2316# 0.10299f
C32 a_15194_2316# VDD 0.58667f
C33 a_15196_11256# x1.x2.VREF 0.09876f
C34 a_15710_6745# a_14302_7845# 0.04671f
C35 a_7053_11204# a_7101_10059# 0.86805f
C36 a_14509_3352# a_13334_5100# 0.00103f
C37 a_15708_n1887# VDD 1.47006f
C38 a_10120_6898# VDD 0.64577f
C39 S0 EN2 0.62607f
C40 a_16372_10948# x1.R 0.21595f
C41 S0 EN4 0.19975f
C42 S1 a_24585_3263# 0.06936f
C43 OUT1 a_14511_11984# 0.0014f
C44 OUT4 OUT2 11.1522f
C45 S1 S1N 2.64487f
C46 OUT S0N 0.06117f
C47 S0 EN1 0.00197f
C48 a_16370_2316# VDD 1.01692f
C49 x2.R a_7828_5100# 0.34548f
C50 a_7051_2572# x3.R 0.06981f
C51 a_25077_2267# OUT3 0.00256f
C52 a_25077_6811# VDD 0
C53 a_18130_7245# a_13334_5100# 0.16355f
C54 a_25077_9083# VDD 0
C55 a_15196_11256# x1.x1.OUT 0.01368f
C56 x4.R VDD 4.98597f
C57 a_9894_n3312# a_7826_n3532# 0.86973f
C58 x2.R a_10120_6898# 0.26628f
C59 a_21927_13110# x1.R 0.0256f
C60 S1 S0 0.86879f
C61 EN3 S0N 0.62607f
C62 a_24585_5535# S1N 0.02109f
C63 a_7133_9487# VDD 0.00192f
C64 a_9519_1339# a_7099_1427# 0.49277f
C65 a_9896_5320# a_7828_6025# 0.14627f
C66 OUT2 x2.x1.OUT 0.48835f
C67 a_10118_n1734# VDD 0.64608f
C68 x2.R VDD 5.54807f
C69 a_11885_10379# a_7053_11204# 0.00755f
C70 a_15196_10948# VDD 0.58667f
C71 OUT3 x3.x1.OUT 0.48643f
C72 x3.x2.VREF a_7099_1427# 0
C73 a_14509_3352# a_7051_2572# 0.00532f
C74 OUT VDD 5.7384f
C75 OUT3 S0N 0.00484f
C76 x3.x2.VREF a_15194_2624# 0.09876f
C77 a_10118_n1734# x4.R 0.26628f
C78 OUT a_25077_6811# 0.01955f
C79 x4.x2.VREF a_7826_n3532# 0.07645f
C80 a_14509_3352# x3.R 0.35375f
C81 a_15752_n1387# x3.R 0
C82 x1.x2.VREF VDD 2.612f
C83 EN3 VDD 2.74248f
C84 a_24585_991# VDD 0.27025f
C85 S0N a_21927_8968# 0
C86 S0 a_21973_4138# 0
C87 a_4509_n3543# VDD 0.06351f
C88 a_8253_855# a_9519_1339# 0.01245f
C89 a_14511_11984# a_7053_11204# 0.00532f
C90 a_7826_n3532# x4.x1.OUT 1.03953f
C91 OUT4 a_13332_n3532# 0.30891f
C92 a_13332_n3532# OUT2 0
C93 a_18130_7245# a_17438_7845# 0.01906f
C94 a_9521_9971# VDD 0.12054f
C95 a_16370_2316# OUT3 0.01737f
C96 OUT3 VDD 1.20226f
C97 OUT2 EN2 0.29231f
C98 EN4 OUT4 0.30219f
C99 EN4 OUT2 0.07007f
C100 a_15754_7245# VDD 0.00129f
C101 OUT2 EN1 0.00932f
C102 x1.R a_15196_11256# 0.36057f
C103 a_4509_n3543# x4.R 0.02053f
C104 a_16372_10948# a_14511_11984# 0.07588f
C105 EN2 OUT1 0.00171f
C106 OUT2 a_7828_6025# 0.0205f
C107 EN1 OUT1 0.62718f
C108 x3.x2.VREF a_15194_2316# 0.09306f
C109 x1.x2.VREF a_15196_10948# 0.09306f
C110 a_9894_n3312# VDD 3.01552f
C111 a_24585_7807# S1N 0.06703f
C112 x1.x1.OUT VDD 1.94594f
C113 a_15710_6745# VDD 1.47017f
C114 OUT EN3 0.51715f
C115 a_7826_n3532# a_7826_n2607# 0.0757f
C116 a_14302_7845# a_13334_5100# 0.00755f
C117 a_9521_9971# a_7133_9487# 0
C118 OUT1 a_16372_10948# 0.0179f
C119 OUT a_24585_991# 0.1438f
C120 a_4555_5130# VDD 0.06418f
C121 x2.R a_9521_9971# 0
C122 a_9519_1339# VDD 0.12045f
C123 a_15708_n1887# a_14300_n787# 0.04671f
C124 S0 a_25077_2267# 0.30632f
C125 a_9894_n3312# x4.R 0.3942f
C126 a_11883_1747# a_7051_2572# 0.00755f
C127 a_7131_855# a_7099_1427# 0.33125f
C128 x3.x2.VREF VDD 2.612f
C129 S1 OUT1 0.05764f
C130 a_7828_6025# x2.x1.OUT 1.73099f
C131 OUT OUT3 1.62486f
C132 a_14300_n787# VDD 0.01091f
C133 S1N S0N 0.26331f
C134 S0 a_24585_7807# 0.04822f
C135 x4.R a_9519_1339# 0
C136 a_15752_n1387# a_13332_n3532# 0.00182f
C137 a_15708_n1887# x4.x2.VREF 0
C138 a_9894_n3312# a_10118_n1734# 0.13302f
C139 a_21927_13110# OUT1 0.0183f
C140 x2.x2.VREF a_14302_7845# 0.00957f
C141 a_8255_9487# VDD 0.00999f
C142 x1.x1.OUT a_15196_10948# 0.04672f
C143 x4.x2.VREF VDD 2.6132f
C144 OUT2 a_24585_5535# 0.2302f
C145 x2.R a_4555_5130# 0.0301f
C146 OUT3 EN3 0.42122f
C147 S0 S0N 3.45814f
C148 a_18128_n1387# a_15752_n1387# 0
C149 a_14302_7845# a_14511_11984# 0
C150 x4.x2.VREF x4.R 0.31874f
C151 x4.x1.OUT VDD 1.94221f
C152 a_24585_3263# VDD 0.27009f
C153 a_8255_9487# a_7133_9487# 0.01906f
C154 S1N VDD 1.08837f
C155 x4.x2.VREF a_10118_n1734# 0.09306f
C156 a_8253_855# a_7131_855# 0.01906f
C157 a_25077_6811# S1N 0.30837f
C158 EN2 EN1 0.03606f
C159 x4.R x4.x1.OUT 0.48832f
C160 x1.R VDD 5.20001f
C161 a_21973_4138# x3.R 0.00459f
C162 a_25077_9083# S1N 0.3227f
C163 a_18128_n1387# a_13332_n3532# 0.16355f
C164 a_7101_10059# VDD 1.61871f
C165 a_15196_11256# a_14511_11984# 0.86973f
C166 a_7099_1427# a_7051_2572# 0.86805f
C167 a_7826_n2607# VDD 0.99762f
C168 a_10118_n1734# x4.x1.OUT 0.04672f
C169 a_7828_5100# a_9896_5320# 0.86973f
C170 S0 VDD 2.52076f
C171 a_15754_7245# x1.x1.OUT 0.00661f
C172 a_15710_6745# a_15754_7245# 0.49277f
C173 S1 a_25077_4539# 0.30749f
C174 a_7051_2572# a_15194_2624# 0
C175 a_7826_n3532# OUT4 0.00232f
C176 a_7826_n3532# OUT2 0
C177 a_7828_5100# a_13334_5100# 0.00532f
C178 S0 a_25077_6811# 0.31791f
C179 S1 EN2 0.01619f
C180 S1 EN4 0.62921f
C181 OUT a_24585_3263# 0.14002f
C182 x4.R a_7826_n2607# 0.26609f
C183 OUT S1N 0.06423f
C184 S1 EN1 0.00871f
C185 a_7828_5100# a_11885_10379# 0
C186 a_7131_855# VDD 0.00192f
C187 a_9896_5320# a_10120_6898# 0.13302f
C188 a_7133_9487# a_7101_10059# 0.33125f
C189 x1.R a_15196_10948# 0.26628f
C190 a_9896_5320# VDD 3.01489f
C191 a_10118_n1734# a_7826_n2607# 0.10299f
C192 a_8255_9487# a_9521_9971# 0.01245f
C193 a_15194_2624# x3.R 0.39612f
C194 a_24585_7807# OUT1 0.2302f
C195 a_24585_5535# EN2 0.48411f
C196 a_13334_5100# VDD 10.4753f
C197 a_24585_3263# EN3 0.48411f
C198 a_7828_5100# x2.x2.VREF 0.07645f
C199 OUT S0 0.10825f
C200 EN3 S1N 0
C201 a_11885_10379# VDD 0.02525f
C202 a_8253_855# a_7051_2572# 0.00342f
C203 OUT2 S0N 0.00406f
C204 x1.R x1.x2.VREF 0.31825f
C205 a_9894_n3312# x4.x2.VREF 0.09876f
C206 a_24585_3263# OUT3 0.46666f
C207 a_7828_5100# a_7051_2572# 0.00103f
C208 x2.R a_9896_5320# 0.3942f
C209 S0N OUT1 0.0193f
C210 x2.x2.VREF a_10120_6898# 0.09306f
C211 x1.x2.VREF a_7101_10059# 0
C212 x3.x1.OUT x3.R 0.49006f
C213 a_14509_3352# a_15194_2624# 0.86973f
C214 x2.x2.VREF VDD 2.61325f
C215 a_7828_5100# OUT2 0.00141f
C216 S0 EN3 0
C217 S1 a_24585_5535# 0.05088f
C218 x2.R a_13334_5100# 0.06981f
C219 S0 a_24585_991# 0.02109f
C220 a_9894_n3312# x4.x1.OUT 0.01363f
C221 x4.x2.VREF a_14300_n787# 0.00957f
C222 a_15754_7245# x1.R 0
C223 a_9521_9971# a_7101_10059# 0.49277f
C224 a_9519_1339# x4.x1.OUT 0.00661f
C225 a_14511_11984# VDD 6.20843f
C226 a_7051_2572# VDD 10.7143f
C227 S0 OUT3 0.07612f
C228 a_15194_2316# x3.R 0.26628f
C229 OUT4 VDD 8.66651f
C230 a_7826_n3532# a_13332_n3532# 0.00532f
C231 x1.R x1.x1.OUT 0.36007f
C232 a_15196_11256# a_7053_11204# 0
C233 a_14509_3352# x3.x1.OUT 1.03953f
C234 OUT2 VDD 9.82039f
C235 a_15752_n1387# x3.x1.OUT 0.00661f
C236 a_7828_5100# x2.x1.OUT 1.03953f
C237 x2.R x2.x2.VREF 0.31819f
C238 a_20823_8968# VDD 0.02309f
C239 OUT1 VDD 3.28543f
C240 a_9894_n3312# a_7826_n2607# 0.14628f
C241 a_17438_7845# VDD 0.00387f
C242 EN4 a_25077_2267# 0.0044f
C243 a_5613_259# a_4509_259# 0.00396f
C244 a_11885_10379# x1.x2.VREF 0.00957f
C245 a_16372_10948# a_15196_11256# 0.14661f
C246 OUT4 x4.R 1.65932f
C247 x4.R OUT2 0
C248 a_16370_2316# x3.R 0.2648f
C249 VDD x3.R 4.724f
C250 S0 a_21927_8968# 0
C251 a_17436_n787# a_15752_n1387# 0.01245f
C252 x2.R a_7051_2572# 0.08135f
C253 a_10120_6898# x2.x1.OUT 0.04672f
C254 EN2 a_24585_7807# 0.00438f
C255 a_14509_3352# a_15194_2316# 0.03669f
C256 a_14511_11984# a_15196_10948# 0.03669f
C257 a_24585_7807# EN1 0.48411f
C258 x2.x1.OUT VDD 1.98739f
C259 x2.R OUT2 0.60257f
C260 a_15754_7245# a_13334_5100# 0.00182f
C261 a_9521_9971# a_11885_10379# 0.03516f
C262 a_9519_1339# a_7131_855# 0
C263 a_15708_n1887# a_15752_n1387# 0.49277f
C264 OUT OUT4 0.74093f
C265 a_25077_4539# S0N 0.31791f
C266 OUT OUT2 0.69694f
C267 a_8255_9487# a_7101_10059# 0.0341f
C268 S1 a_25077_2267# 0.31791f
C269 EN2 S0N 0.00151f
C270 OUT OUT1 0.56566f
C271 a_11883_1747# a_7099_1427# 0.04671f
C272 a_16370_2316# a_14509_3352# 0.07588f
C273 a_14509_3352# VDD 6.20724f
C274 a_15710_6745# a_13334_5100# 0.86805f
C275 a_7826_n3532# a_11883_1747# 0
C276 a_15752_n1387# VDD 0.00129f
C277 EN1 S0N 0.20095f
C278 a_14511_11984# x1.x2.VREF 0.07645f
C279 a_17436_n787# a_13332_n3532# 0.00342f
C280 x2.R x2.x1.OUT 0.48832f
C281 OUT4 EN3 0.00932f
C282 a_24585_991# OUT4 0.23031f
C283 OUT2 EN3 0.08837f
C284 a_7826_n2607# x4.x1.OUT 1.73099f
C285 a_18130_7245# VDD 0.02156f
C286 a_7828_5100# a_7828_6025# 0.0757f
C287 OUT4 a_4509_n3543# 0.02365f
C288 a_15708_n1887# a_13332_n3532# 0.86805f
C289 a_4509_n3543# OUT2 0
C290 S0 S1N 0.24858f
C291 S1 S0N 2.96657f
C292 a_18128_n1387# a_17436_n787# 0.01906f
C293 a_15710_6745# x2.x2.VREF 0
C294 a_25077_4539# VDD 0
C295 OUT2 OUT3 0.07329f
C296 a_13332_n3532# VDD 10.652f
C297 a_7053_11204# VDD 10.764f
C298 EN2 VDD 2.81565f
C299 a_10120_6898# a_7828_6025# 0.10299f
C300 EN4 VDD 2.74533f
C301 EN1 VDD 2.67915f
C302 a_14511_11984# x1.x1.OUT 1.03953f
C303 a_15708_n1887# a_18128_n1387# 0.33125f
C304 a_7828_6025# VDD 1.0501f
C305 a_25077_6811# EN2 0.0044f
C306 OUT3 x3.R 0.50852f
C307 x4.R a_13332_n3532# 0.06981f
C308 a_24585_5535# S0N 0.04827f
C309 a_17438_7845# a_15754_7245# 0.01245f
C310 a_16372_10948# VDD 1.02265f
C311 a_9519_1339# a_7051_2572# 0.00182f
C312 a_18128_n1387# VDD 0.02149f
C313 a_25077_9083# EN1 0.0044f
C314 a_9521_9971# x2.x1.OUT 0.00661f
C315 a_7133_9487# a_7053_11204# 0.16355f
C316 OUT1 x1.x1.OUT 0.4992f
C317 x3.x2.VREF a_7051_2572# 0.44258f
C318 OUT2 a_4555_5130# 0.01986f
C319 S1 VDD 2.26737f
C320 a_20823_8968# a_21927_8968# 0.00396f
C321 a_15710_6745# a_17438_7845# 0.0341f
C322 OUT a_25077_4539# 0.01955f
C323 x2.R a_7828_6025# 0.26608f
C324 OUT EN2 0.36705f
C325 a_20869_1020# VDD 0.0198f
C326 OUT EN4 0.38452f
C327 a_5613_259# OUT2 0
C328 a_21927_13110# VDD 0.0297f
C329 S1 a_25077_9083# 0
C330 OUT EN1 0.09713f
C331 a_11883_1747# VDD 0.02529f
C332 a_11885_10379# a_7101_10059# 0.04671f
C333 a_16372_10948# a_15196_10948# 0.10299f
C334 x3.x2.VREF x3.R 0.3182f
C335 x4.x2.VREF OUT4 0
C336 a_24585_5535# VDD 0.27009f
C337 a_25077_4539# EN3 0.0044f
C338 x1.x2.VREF a_7053_11204# 0.44258f
C339 EN3 EN2 0.03606f
C340 EN4 EN3 0.03606f
C341 a_24585_991# EN4 0.48411f
C342 OUT S1 0.13111f
C343 a_18130_7245# a_15754_7245# 0
C344 OUT4 x4.x1.OUT 0.48947f
C345 a_8253_855# a_7099_1427# 0.0341f
C346 a_15194_2624# x3.x1.OUT 0.01368f
C347 OUT2 x4.x1.OUT 0.00434f
C348 a_9896_5320# a_13334_5100# 0
C349 a_25077_4539# OUT3 0.0128f
C350 a_21973_4138# VDD 0.10229f
C351 a_14302_7845# VDD 0.01091f
C352 OUT2 S1N 0
C353 a_9521_9971# a_7053_11204# 0.00182f
C354 x1.R a_14511_11984# 0.22319f
C355 OUT3 EN2 0.00189f
C356 a_14509_3352# x3.x2.VREF 0.07645f
C357 a_4509_259# OUT2 0.00587f
C358 a_14300_n787# a_14509_3352# 0
C359 EN4 OUT3 0.00321f
C360 a_15752_n1387# a_14300_n787# 0.03516f
C361 S1N OUT1 0.00656f
C362 a_15710_6745# a_18130_7245# 0.33125f
C363 a_24585_7807# S0N 0.02111f
C364 S1 EN3 0.20854f
C365 OUT a_24585_5535# 0.12684f
C366 OUT1 x1.R 0.5147f
C367 a_9894_n3312# a_13332_n3532# 0
C368 a_15194_2624# a_15194_2316# 0.13302f
C369 OUT4 a_7826_n2607# 0.02532f
C370 a_7826_n2607# OUT2 0.00375f
C371 S0 OUT4 0
C372 a_9896_5320# x2.x2.VREF 0.09876f
C373 a_15196_11256# VDD 2.91371f
C374 S0 OUT1 0.33913f
C375 a_7131_855# a_7051_2572# 0.16355f
C376 a_7099_1427# VDD 1.61866f
C377 S1 OUT3 0.31974f
C378 x2.x2.VREF a_13334_5100# 0.44258f
C379 a_7826_n3532# VDD 6.26049f
C380 a_20869_1020# a_21973_1020# 0.00396f
C381 a_14300_n787# a_13332_n3532# 0.00755f
C382 a_16372_10948# x1.x1.OUT 1.73099f
C383 a_16370_2316# a_15194_2624# 0.14661f
C384 a_15194_2624# VDD 2.89848f
C385 EN3 a_24585_5535# 0.00438f
C386 S0 x3.R 0.01315f
C387 a_25077_2267# VDD 0
C388 OUT VSS 6.83584f
C389 S1 VSS 5.95106f
C390 S0 VSS 8.03375f
C391 VDD VSS 0.44015p
C392 a_9894_n3312# VSS 0.12871f
C393 a_13332_n3532# VSS 1.46157f
C394 a_15708_n1887# VSS 3.24826f
C395 x4.x2.VREF VSS 1.06585f
C396 a_7826_n2607# VSS 3.04702f
C397 a_10118_n1734# VSS 2.04529f
C398 a_18128_n1387# VSS 1.59879f
C399 a_17436_n787# VSS 2.0345f
C400 a_15752_n1387# VSS 2.60075f
C401 a_14300_n787# VSS 2.35713f
C402 a_7826_n3532# VSS 1.00295f
C403 a_24585_991# VSS 1.04452f
C404 a_25077_2267# VSS 0.21995f
C405 EN4 VSS 1.26226f
C406 a_24585_3263# VSS 0.88163f
C407 a_21973_1020# VSS 0.86882f
C408 a_20869_1020# VSS 0.92489f
C409 a_5613_259# VSS 0.88138f
C410 OUT4 VSS 6.3051f
C411 a_4509_n3543# VSS 0.83659f
C412 x4.R VSS 2.83069f
C413 a_4509_259# VSS 0.86129f
C414 a_8253_855# VSS 2.0345f
C415 a_9519_1339# VSS 2.65763f
C416 a_11883_1747# VSS 2.4518f
C417 a_7131_855# VSS 1.59987f
C418 a_16370_2316# VSS 2.98607f
C419 x3.R VSS 2.85206f
C420 a_15194_2316# VSS 1.89175f
C421 a_25077_4539# VSS 0.21995f
C422 OUT3 VSS 4.98536f
C423 a_21973_4138# VSS 0.85528f
C424 a_15194_2624# VSS 0.01323f
C425 a_14509_3352# VSS 0.92629f
C426 x3.x2.VREF VSS 1.04799f
C427 a_7099_1427# VSS 3.31876f
C428 a_7051_2572# VSS 1.73691f
C429 EN3 VSS 1.20187f
C430 a_24585_5535# VSS 0.93654f
C431 a_9896_5320# VSS 0.12921f
C432 a_25077_6811# VSS 0.21995f
C433 EN2 VSS 1.20427f
C434 a_13334_5100# VSS 1.55629f
C435 a_15710_6745# VSS 3.24824f
C436 x2.x2.VREF VSS 1.06657f
C437 a_7828_6025# VSS 3.00789f
C438 a_10120_6898# VSS 2.04528f
C439 a_18130_7245# VSS 1.59882f
C440 a_24585_7807# VSS 0.92753f
C441 a_17438_7845# VSS 2.0345f
C442 a_15754_7245# VSS 2.60075f
C443 a_14302_7845# VSS 2.35713f
C444 a_7828_5100# VSS 1.00153f
C445 a_25077_9083# VSS 0.21995f
C446 EN1 VSS 1.23936f
C447 S1N VSS 4.01382f
C448 S0N VSS 4.28016f
C449 a_21927_8968# VSS 0.86913f
C450 a_21927_13110# VSS 0.83251f
C451 a_20823_8968# VSS 0.91081f
C452 a_5659_8494# VSS 0.94015f
C453 OUT2 VSS 12.702f
C454 a_4555_5130# VSS 0.83415f
C455 x2.R VSS 2.81008f
C456 a_4555_8494# VSS 0.86129f
C457 a_8255_9487# VSS 2.0345f
C458 OUT1 VSS 6.21461f
C459 a_9521_9971# VSS 2.65802f
C460 a_11885_10379# VSS 2.45151f
C461 a_7133_9487# VSS 1.59987f
C462 a_16372_10948# VSS 3.02608f
C463 x1.R VSS 4.04977f
C464 a_15196_10948# VSS 1.89175f
C465 a_15196_11256# VSS 0.01323f
C466 a_14511_11984# VSS 0.92861f
C467 x1.x2.VREF VSS 1.04756f
C468 a_7101_10059# VSS 3.31925f
C469 a_7053_11204# VSS 1.7542f
C470 x4.x1.OUT VSS 7.63211f
C471 x3.x1.OUT VSS 7.57686f
C472 x2.x1.OUT VSS 7.59842f
C473 x1.x1.OUT VSS 7.62883f
.ends
