* NGSPICE file created from oscillator_f.ext - technology: gf180mcuD

.subckt oscillator_f VDD VSS OSC POR
X0 a_7325_4375# x2.schmitt_0.A VSS VSS.t17 nfet_06v0 ad=1.76p pd=8.88u as=1.76p ps=8.88u w=4u l=0.7u
X1 a_7295_5746# x2.schmitt_0.A VDD VDD.t15 pfet_06v0 ad=1.76p pd=8.88u as=1.76p ps=8.88u w=4u l=0.55u
X2 VDD x2.schmitt_0.Y x2.OUT VDD.t8 pfet_06v0 ad=3.52p pd=16.88u as=2.08p ps=8.52u w=8u l=0.55u
X3 VDD x2.MINUS a_4112_4873# VDD.t4 pfet_06v0 ad=1.32p pd=6.88u as=1.32p ps=6.88u w=3u l=1.1u
X4 VSS OSC x2.MINUS VSS.t15 nfet_06v0 ad=0.44p pd=2.88u as=0.44p ps=2.88u w=1u l=8u
X5 VDD a_5180_5153# x2.schmitt_0.A VDD.t11 pfet_06v0 ad=1.32p pd=6.88u as=1.32p ps=6.88u w=3u l=1.1u
X6 x2.schmitt_0.Y x2.schmitt_0.A a_7325_4375# VSS.t18 nfet_06v0 ad=1.76p pd=8.88u as=1.76p ps=8.88u w=4u l=0.7u
X7 VDD x2.schmitt_0.Y x2.OUT VDD.t8 pfet_06v0 ad=2.08p pd=8.52u as=3.52p ps=16.88u w=8u l=0.55u
X8 a_2695_3732# VSS VSS.t13 ppolyf_u_1k_6p0 r_width=1u r_length=10u
X9 a_5180_5153# a_4112_4873# VSS VSS.t9 nfet_06v0 ad=1.32p pd=6.88u as=1.32p ps=6.88u w=3u l=1.4u
X10 x2.schmitt_0.Y x2.schmitt_0.A a_7295_5746# VDD.t16 pfet_06v0 ad=1.76p pd=8.88u as=1.76p ps=8.88u w=4u l=0.55u
X11 OSC x2.OUT VSS VSS nfet_06v0 ad=3.52p pd=16.88u as=3.52p ps=16.88u w=8u l=0.7u
X12 a_14642_5900# a_14642_5900# VSS VSS.t4 nfet_06v0 ad=0.44p pd=2.88u as=0.44p ps=2.88u w=1u l=0.7u
X13 POR x1.A a_20080_5992# VDD.t3 pfet_06v0 ad=1.76p pd=8.88u as=1.76p ps=8.88u w=4u l=0.55u
X14 COMP a_2695_3732# VSS.t19 ppolyf_u_1k_6p0 r_width=2u r_length=2u
X15 a_2695_3732# OSC VSS.t16 VSS.t16 nfet_06v0 ad=3.52p pd=16.88u as=3.52p ps=16.88u w=8u l=0.7u
X16 VDD a_14642_5900# x1.A VDD.t5 pfet_06v0 ad=0.44p pd=2.88u as=0.44p ps=2.88u w=1u l=24u
X17 x1.A VSS cap_mim_2f0_m4m5_noshield c_width=20u c_length=20u
X18 a_4112_4873# a_4112_4873# VSS VSS.t9 nfet_06v0 ad=1.32p pd=6.88u as=1.32p ps=6.88u w=3u l=1.4u
X19 x2.schmitt_0.A a_5180_5153# VSS VSS.t9 nfet_06v0 ad=1.32p pd=6.88u as=1.32p ps=6.88u w=3u l=1.4u
X20 VDD.t13 POR a_20110_4621# VSS.t14 nfet_06v0 ad=0.88p pd=4.88u as=0.88p ps=4.88u w=2u l=0.7u
X21 x2.MINUS VSS cap_mim_2f0_m4m5_noshield c_width=20u c_length=20u
X22 x2.OUT x2.schmitt_0.Y VDD VDD.t8 pfet_06v0 ad=2.08p pd=8.52u as=2.08p ps=8.52u w=8u l=0.55u
X23 VDD x2.schmitt_0.Y a_7325_4375# VSS.t5 nfet_06v0 ad=0.88p pd=4.88u as=0.88p ps=4.88u w=2u l=0.7u
X24 a_20110_4621# x1.A VSS VSS.t1 nfet_06v0 ad=1.76p pd=8.88u as=1.76p ps=8.88u w=4u l=0.7u
X25 VSS POR a_20886_5992# VDD.t12 pfet_06v0 ad=0.88p pd=4.88u as=0.88p ps=4.88u w=2u l=0.55u
X26 x2.OUT x2.schmitt_0.Y VSS VSS.t8 nfet_06v0 ad=2.08p pd=8.52u as=3.52p ps=16.88u w=8u l=0.7u
X27 VDD OSC x2.MINUS VDD.t14 pfet_06v0 ad=0.44p pd=2.88u as=0.44p ps=2.88u w=1u l=4u
X28 VDD COMP VSS.t12 ppolyf_u_1k_6p0 r_width=1u r_length=7u
X29 VDD x2.OUT OSC VDD.t17 pfet_06v0 ad=3.52p pd=16.88u as=3.52p ps=16.88u w=8u l=0.55u
X30 x2.OUT x2.schmitt_0.Y VSS VSS.t6 nfet_06v0 ad=3.52p pd=16.88u as=2.08p ps=8.52u w=8u l=0.7u
D0 x1.A VDD.t0 diode_pd2nw_06v0 pj=1.8u area=0.2025p
X31 VDD COMP a_5180_5153# VDD.t6 pfet_06v0 ad=1.32p pd=6.88u as=1.32p ps=6.88u w=3u l=1.1u
X32 a_20080_5992# x1.A VDD VDD.t2 pfet_06v0 ad=1.76p pd=8.88u as=1.76p ps=8.88u w=4u l=0.55u
X33 VSS x2.schmitt_0.Y x2.OUT VSS.t7 nfet_06v0 ad=2.08p pd=8.52u as=2.08p ps=8.52u w=8u l=0.7u
X34 VSS x2.schmitt_0.Y a_8101_5746# VDD.t7 pfet_06v0 ad=0.88p pd=4.88u as=0.88p ps=4.88u w=2u l=0.55u
X35 POR x1.A a_20110_4621# VSS.t2 nfet_06v0 ad=1.76p pd=8.88u as=1.76p ps=8.88u w=4u l=0.7u
R0 VDD.n8 VDD.t5 3647.62
R1 VDD.n48 VDD.t5 3646.07
R2 VDD.t8 VDD.t17 2579.87
R3 VDD.n50 VDD.t17 1750.68
R4 VDD.n57 VDD.t8 1182.88
R5 VDD.t14 VDD.n8 838.63
R6 VDD.n50 VDD.t14 837.08
R7 VDD.t4 VDD.t6 750.769
R8 VDD.t6 VDD.t11 750.769
R9 VDD.n46 VDD.n7 448
R10 VDD.n37 VDD.n28 448
R11 VDD.n55 VDD.t11 409.522
R12 VDD.t3 VDD.t2 382.623
R13 VDD.t16 VDD.t15 382.623
R14 VDD.n43 VDD.t12 192.212
R15 VDD.n49 VDD.t2 191.311
R16 VDD.n42 VDD.t3 191.311
R17 VDD.t12 VDD.n42 191.311
R18 VDD.t15 VDD.n55 191.311
R19 VDD.n56 VDD.t16 191.311
R20 VDD.t7 VDD.n56 191.311
R21 VDD.n57 VDD.t7 191.311
R22 VDD.n49 VDD.n48 147.335
R23 VDD VDD.n0 118.691
R24 VDD.n28 VDD.n1 102.415
R25 VDD.n52 VDD.n7 98.0005
R26 VDD.n45 VDD.n36 96.6005
R27 VDD.n25 VDD.n23 96.6005
R28 VDD.n25 VDD 92.2255
R29 VDD.n2 VDD.n36 90.8524
R30 VDD.n54 VDD.n53 83.3005
R31 VDD.n54 VDD.n52 83.3005
R32 VDD VDD.n0 83.3005
R33 VDD VDD.n1 83.3005
R34 VDD.n53 VDD.n14 83.3005
R35 VDD.n61 VDD.n60 82.3905
R36 VDD.n5 VDD.n61 82.3905
R37 VDD.n43 VDD.n39 74.7255
R38 VDD.n44 VDD.n43 74.7255
R39 VDD.n4 VDD.n26 74.7255
R40 VDD.n4 VDD.n27 74.7255
R41 VDD.n39 VDD.n36 72.6255
R42 VDD.n26 VDD.n25 72.6255
R43 VDD.n61 VDD.n23 68.6005
R44 VDD.n44 VDD.n38 48.3005
R45 VDD.n3 VDD.n27 48.3005
R46 VDD.n24 VDD.n19 47.2505
R47 VDD.n17 VDD.n16 47.2505
R48 VDD.n45 VDD.n44 43.9255
R49 VDD.n27 VDD.n23 43.9255
R50 VDD.n17 VDD.n10 42.7005
R51 VDD.n18 VDD.n17 42.7005
R52 VDD.n24 VDD.n18 42.7005
R53 VDD.n60 VDD.n24 42.7005
R54 VDD.n6 VDD.n16 42.7005
R55 VDD.n62 VDD.n16 42.7005
R56 VDD.n62 VDD.n19 42.7005
R57 VDD.n5 VDD.n19 42.7005
R58 VDD.n46 VDD.n45 40.7755
R59 VDD.n35 VDD.n34 23.6255
R60 VDD.n32 VDD.n30 23.6255
R61 VDD.n61 VDD 23.6255
R62 VDD.n35 VDD.n29 21.944
R63 VDD.n33 VDD.n32 21.944
R64 VDD.n53 VDD.n0 15.2053
R65 VDD.n39 VDD.n38 13.3005
R66 VDD.n3 VDD.n26 13.3005
R67 VDD.n52 VDD.n51 8.72358
R68 VDD.n8 VDD.n7 8.72358
R69 VDD.n8 VDD.n28 8.72358
R70 VDD.n47 VDD.n46 8.72358
R71 VDD.n47 VDD.n37 8.72358
R72 VDD.n51 VDD.n1 6.48223
R73 VDD.n13 VDD.n35 3.1505
R74 VDD.n34 VDD.n11 3.1505
R75 VDD.n32 VDD.n31 3.1505
R76 VDD.n30 VDD.n12 3.1505
R77 VDD.n9 VDD 3.0814
R78 VDD.n33 VDD.t0 2.92674
R79 VDD.t0 VDD.n29 2.92674
R80 VDD VDD.n54 1.24813
R81 VDD.n51 VDD.n50 1.5755
R82 VDD.n51 VDD 1.5755
R83 VDD.n48 VDD.n47 1.5755
R84 VDD.n47 VDD 1.5755
R85 VDD.n14 VDD 0.778838
R86 VDD.n20 VDD 1.10789
R87 VDD VDD.n22 1.10789
R88 VDD.n58 VDD 1.33402
R89 VDD.n40 VDD.n41 1.10593
R90 VDD VDD.n15 1.01116
R91 VDD.n40 VDD 0.97072
R92 VDD.n9 VDD 0.947973
R93 VDD.n43 VDD.t13 0.9005
R94 VDD.n4 VDD.n57 0.9005
R95 VDD VDD.n4 0.9005
R96 VDD.n8 VDD 0.817888
R97 VDD VDD.n6 0.7005
R98 VDD.t6 VDD.n62 0.7005
R99 VDD.n62 VDD 0.7005
R100 VDD.n5 VDD.t11 0.7005
R101 VDD VDD.n5 0.7005
R102 VDD.n60 VDD.t11 0.7005
R103 VDD.n60 VDD.n59 0.7005
R104 VDD.t6 VDD.n18 0.7005
R105 VDD.n21 VDD.n18 0.7005
R106 VDD.n10 VDD.n15 0.7005
R107 VDD.t4 VDD.n10 0.697845
R108 VDD.n6 VDD.t4 0.693689
R109 VDD.t13 VDD.n40 0.678601
R110 VDD.n55 VDD 0.573227
R111 VDD.n56 VDD.n3 0.573227
R112 VDD.n2 VDD.n49 0.573227
R113 VDD VDD.n2 0.573227
R114 VDD.n42 VDD.n38 0.573227
R115 VDD.n41 VDD.n38 0.573227
R116 VDD.n31 VDD.n11 0.554196
R117 VDD.n31 VDD.n12 0.554196
R118 VDD.n13 VDD.n11 0.546069
R119 VDD.n13 VDD.n12 0.545166
R120 VDD.n20 VDD.n15 0.431088
R121 VDD.n21 VDD.n20 0.431088
R122 VDD.n22 VDD.n21 0.431088
R123 VDD.n59 VDD.n22 0.431088
R124 VDD.n59 VDD.n58 0.410794
R125 VDD.n2 VDD.n37 0.363962
R126 VDD.t8 VDD.n14 0.332637
R127 VDD.n54 VDD.t17 0.332079
R128 VDD VDD.n3 0.743149
R129 VDD.n41 VDD.n9 0.323326
R130 VDD.t13 VDD.n9 0.255865
R131 VDD.n30 VDD.n29 0.198881
R132 VDD.n34 VDD.n33 0.198881
R133 VDD.n13 VDD 11.0074
R134 VDD VDD.t17 1.32491
R135 VDD.t8 VDD 1.30109
R136 VDD.n58 VDD 1.10192
R137 VSS.n5 VSS 1.64774
R138 VSS.n30 VSS.n25 4368.81
R139 VSS VSS.n33 1533.59
R140 VSS VSS.n13 1440.81
R141 VSS VSS.t15 1360.22
R142 VSS.n33 VSS.t15 1358.94
R143 VSS.n30 VSS.n29 1035.17
R144 VSS.t18 VSS.t17 809.457
R145 VSS.t2 VSS.t1 725.861
R146 VSS.n38 VSS.n21 561.092
R147 VSS VSS.n22 531.188
R148 VSS.n8 VSS.t12 422.914
R149 VSS.t17 VSS 404.728
R150 VSS VSS.t18 404.728
R151 VSS.t5 VSS 404.728
R152 VSS.n3 VSS.t5 404.728
R153 VSS VSS.t6 400.587
R154 VSS.t8 VSS.n13 384.474
R155 VSS.t7 VSS.t8 366.452
R156 VSS.t6 VSS.t7 366.452
R157 VSS.t4 VSS 364.214
R158 VSS.n27 VSS.t4 362.93
R159 VSS.n25 VSS.t1 362.93
R160 VSS.n11 VSS.t2 362.93
R161 VSS.t14 VSS.n11 362.93
R162 VSS.n5 VSS.t14 362.93
R163 VSS.n40 VSS.n39 343.914
R164 VSS.n18 VSS.n17 84.4562
R165 VSS.n22 VSS.n20 292
R166 VSS.t12 VSS.n14 281.942
R167 VSS.n8 VSS.n15 3.77325
R168 VSS.t9 VSS 235.853
R169 VSS.n32 VSS.n19 214.667
R170 VSS.n26 VSS.n12 212.529
R171 VSS.n21 VSS.n20 196
R172 VSS.t13 VSS.n18 54.7134
R173 VSS VSS.n18 84.3691
R174 VSS.n29 VSS.n27 185.559
R175 VSS.n15 VSS.n14 141.232
R176 VSS.t16 VSS.n16 140.779
R177 VSS.t16 VSS.n2 140.779
R178 VSS.n4 VSS.n35 162.944
R179 VSS VSS.n40 122.695
R180 VSS.n17 VSS.n16 122.695
R181 VSS.n10 VSS.n24 119.171
R182 VSS VSS.n6 117.99
R183 VSS VSS.n14 107.397
R184 VSS VSS.n12 53.2404
R185 VSS VSS.n20 10.6682
R186 VSS.t16 VSS 101.782
R187 VSS.n15 VSS.n2 95.4727
R188 VSS.n31 VSS.n0 94.6426
R189 VSS.n36 VSS.n35 94.5977
R190 VSS.n8 VSS.n6 92.5561
R191 VSS.n31 VSS.n23 88.9588
R192 VSS.n9 VSS.n24 87.2823
R193 VSS.n34 VSS.n3 85.9449
R194 VSS.n5 VSS.n10 85.9449
R195 VSS.n5 VSS.n9 85.9449
R196 VSS.n35 VSS.n34 83.6116
R197 VSS VSS.t19 70.1949
R198 VSS.n39 VSS.n38 65.3372
R199 VSS.n38 VSS 59.0144
R200 VSS.n22 VSS.n7 58.3338
R201 VSS.n37 VSS.n21 58.3338
R202 VSS.n4 VSS.n3 1.73354
R203 VSS.n11 VSS.n9 53.6672
R204 VSS.n2 VSS.n6 49.7403
R205 VSS VSS.n36 49.5838
R206 VSS VSS.n37 47.4449
R207 VSS.n37 VSS 47.4449
R208 VSS VSS.n7 47.4449
R209 VSS VSS.n7 47.4449
R210 VSS.n26 VSS.n23 44.7227
R211 VSS.n0 VSS.n19 44.7227
R212 VSS.n39 VSS.n1 41.7747
R213 VSS VSS.n24 34.9159
R214 VSS.t19 VSS.t9 33.6938
R215 VSS VSS.n1 19.5197
R216 VSS VSS.n13 15.019
R217 VSS.n34 VSS 14.7783
R218 VSS.n11 VSS.n10 14.7783
R219 VSS VSS.n2 12.7217
R220 VSS.n40 VSS.n16 10.1422
R221 VSS VSS.n19 9.69281
R222 VSS VSS.n26 9.69281
R223 VSS.n28 VSS.n23 9.69281
R224 VSS VSS.n0 8.313
R225 VSS.t16 VSS.n1 7.67792
R226 VSS.n36 VSS 3.7099
R227 VSS.n32 VSS.n12 2.13939
R228 VSS VSS.n8 1.9235
R229 VSS.n25 VSS 1.89141
R230 VSS.t16 VSS 1.88106
R231 VSS.n15 VSS 1.76762
R232 VSS.n17 VSS 1.37165
R233 VSS.n33 VSS.n32 1.3005
R234 VSS.n32 VSS 1.3005
R235 VSS.n28 VSS.n27 1.3005
R236 VSS VSS.n11 1.24446
R237 VSS.n4 VSS 1.17589
R238 VSS VSS.n28 1.06099
R239 VSS.n31 VSS.n30 1.0405
R240 VSS VSS.n31 1.0405
R241 VSS.n29 VSS 1.0405
C0 x2.MINUS a_5180_5153# 0.52571f
C1 a_8101_5746# x2.OUT 0
C2 x2.schmitt_0.Y a_8101_5746# 0.13002f
C3 a_8101_5746# a_7295_5746# 0.13792f
C4 OSC a_7325_4375# 0.02617f
C5 a_7325_4375# a_5180_5153# 0.00302f
C6 a_7325_4375# x2.MINUS 0.37476f
C7 OSC VDD 3.67773f
C8 a_2695_3732# COMP 0.03968f
C9 VDD a_5180_5153# 0.98755f
C10 VDD POR 0.99662f
C11 OSC a_4112_4873# 0.014f
C12 VDD x2.MINUS 2.94862f
C13 OSC x2.schmitt_0.A 0.009f
C14 a_5180_5153# a_4112_4873# 0.13891f
C15 x2.schmitt_0.A a_5180_5153# 0.21422f
C16 OSC x1.A 0.39183f
C17 POR a_20110_4621# 0.21968f
C18 x2.schmitt_0.Y x2.OUT 1.11018f
C19 POR x1.A 0.25872f
C20 x2.MINUS a_4112_4873# 0.22041f
C21 x2.schmitt_0.A x2.MINUS 0.63678f
C22 OSC a_14642_5900# 0.01087f
C23 x2.MINUS x1.A 0.04595f
C24 POR a_20886_5992# 0.1219f
C25 x2.schmitt_0.Y a_7295_5746# 0.16321f
C26 a_14642_5900# POR 0.00329f
C27 a_8101_5746# a_5180_5153# 0
C28 VDD a_7325_4375# 0.06257f
C29 a_8101_5746# x2.MINUS 0.23582f
C30 a_7325_4375# x2.schmitt_0.A 0.20611f
C31 OSC COMP 0.00651f
C32 a_5180_5153# COMP 0.09169f
C33 VDD a_4112_4873# 0.38226f
C34 VDD x2.schmitt_0.A 1.20345f
C35 VDD a_20110_4621# 0.06257f
C36 VDD x1.A 4.29038f
C37 POR a_20080_5992# 0.16276f
C38 x2.MINUS COMP 0.26386f
C39 VDD a_20886_5992# 0.37928f
C40 VDD a_14642_5900# 8.58678f
C41 a_20110_4621# x1.A 0.21161f
C42 OSC x2.OUT 0.44657f
C43 OSC x2.schmitt_0.Y 0.01642f
C44 VDD a_8101_5746# 0.40635f
C45 OSC a_2695_3732# 0.38769f
C46 x2.schmitt_0.Y a_5180_5153# 0.00767f
C47 x1.A a_20886_5992# 0.03504f
C48 a_5180_5153# a_7295_5746# 0.00245f
C49 a_14642_5900# x1.A 1.21147f
C50 x2.MINUS x2.OUT 0.16859f
C51 x2.schmitt_0.Y x2.MINUS 0.69466f
C52 a_2695_3732# x2.MINUS 0.00202f
C53 x2.schmitt_0.A a_8101_5746# 0.03504f
C54 a_14642_5900# a_20886_5992# 0
C55 x2.MINUS a_7295_5746# 0.10997f
C56 VDD COMP 1.01188f
C57 VDD a_20080_5992# 0.48952f
C58 a_7325_4375# x2.OUT 0
C59 a_7325_4375# x2.schmitt_0.Y 0.22179f
C60 COMP a_4112_4873# 0.03452f
C61 x1.A a_20080_5992# 0.13547f
C62 VDD x2.OUT 2.65959f
C63 VDD x2.schmitt_0.Y 2.5381f
C64 a_20886_5992# a_20080_5992# 0.13792f
C65 a_14642_5900# a_20080_5992# 0
C66 VDD a_7295_5746# 0.48973f
C67 OSC a_5180_5153# 0.01614f
C68 a_2695_3732# a_4112_4873# 0.00564f
C69 x2.schmitt_0.A x2.schmitt_0.Y 0.25565f
C70 x1.A x2.OUT 0.00605f
C71 x2.schmitt_0.A a_7295_5746# 0.13556f
C72 OSC x2.MINUS 1.07653f
C73 VDD VSS 84.76532f
C74 a_20110_4621# VSS 4.14178f
C75 a_7325_4375# VSS 1.75394f
C76 a_2695_3732# VSS 3.31547f
C77 a_20886_5992# VSS 0.21987f
C78 a_20080_5992# VSS 5.4565f
C79 a_8101_5746# VSS 0.17124f
C80 a_7295_5746# VSS 0
C81 x2.schmitt_0.A VSS 1.50875f
C82 a_5180_5153# VSS 0.70179f
C83 VSS.t16 VSS 1.0867f
C84 VDD.t17 VSS 0.86644f
C85 VDD.n0 VSS 0.1209f
C86 VDD.n1 VSS 0.09064f
C87 VDD.n2 VSS 0.03722f
C88 VDD.n3 VSS 0.02454f
C89 VDD.n4 VSS 0.05427f
C90 VDD.n5 VSS 0.03929f
C91 VDD.n6 VSS 0.06285f
C92 VDD.n7 VSS 0.2204f
C93 VDD.n8 VSS 1.08783f
C94 VDD.n9 VSS 3.77981f
C95 VDD.n10 VSS 0.06285f
C96 VDD.t4 VSS 1.14136f
C97 VDD.n11 VSS 0.0117f
C98 VDD.n12 VSS 0.01165f
C99 VDD.n13 VSS 0.04802f
C100 VDD.n14 VSS 0.16845f
C101 VDD.t8 VSS 1.66953f
C102 VDD.n15 VSS 0.06912f
C103 VDD.n16 VSS 0.0459f
C104 VDD.t11 VSS 0.82461f
C105 VDD.n17 VSS 0.0459f
C106 VDD.n18 VSS 0.02955f
C107 VDD.n19 VSS 0.0459f
C108 VDD.n20 VSS 0.05281f
C109 VDD.n21 VSS 0.04186f
C110 VDD.n22 VSS 0.05281f
C111 VDD.n23 VSS 0.07324f
C112 VDD.n24 VSS 0.0459f
C113 VDD.n25 VSS 0.09246f
C114 VDD.n26 VSS 0.05998f
C115 VDD.n27 VSS 0.05866f
C116 VDD.t5 VSS 1.55475f
C117 VDD.n28 VSS 0.22198f
C118 VDD.n30 VSS 0.01824f
C119 VDD.n31 VSS 0.01191f
C120 VDD.n32 VSS 0.07205f
C121 VDD.t0 VSS 0.05784f
C122 VDD.n34 VSS 0.01824f
C123 VDD.n35 VSS 0.07205f
C124 VDD.n36 VSS 0.09199f
C125 VDD.n37 VSS 0.18124f
C126 VDD.t2 VSS 0.41541f
C127 VDD.n38 VSS 0.02131f
C128 VDD.n39 VSS 0.05998f
C129 VDD.n40 VSS 0.11f
C130 VDD.t13 VSS 3.52351f
C131 VDD.n41 VSS 0.01412f
C132 VDD.t3 VSS 0.41541f
C133 VDD.n42 VSS 0.27694f
C134 VDD.t12 VSS 0.27875f
C135 VDD.n43 VSS 0.43863f
C136 VDD.n44 VSS 0.05866f
C137 VDD.n45 VSS 0.06273f
C138 VDD.n46 VSS 0.2006f
C139 VDD.n47 VSS 0.05038f
C140 VDD.n48 VSS 0.81792f
C141 VDD.n49 VSS 0.2135f
C142 VDD.t14 VSS 0.35727f
C143 VDD.n50 VSS 0.48587f
C144 VDD.n51 VSS 0.04391f
C145 VDD.n52 VSS 0.09421f
C146 VDD.n53 VSS 0.10785f
C147 VDD.n54 VSS 0.08734f
C148 VDD.n55 VSS 0.43076f
C149 VDD.t15 VSS 0.41541f
C150 VDD.t16 VSS 0.41541f
C151 VDD.n56 VSS 0.27694f
C152 VDD.t7 VSS 0.27694f
C153 VDD.n57 VSS 0.85503f
C154 VDD.n58 VSS 0.10637f
C155 VDD.n59 VSS 0.04087f
C156 VDD.n60 VSS 0.03929f
C157 VDD.n61 VSS 0.06479f
C158 VDD.n62 VSS 0.02955f
C159 VDD.t6 VSS 1.06702f
.ends
