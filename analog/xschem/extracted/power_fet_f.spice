* NGSPICE file created from flattened.ext - technology: gf180mcuD

.subckt power_fet_f DVDD DVSS BAT GATE
X0 BAT GATE DVDD DVDD pfet_06v0 ad=58.1552p pd=78.04u as=71.92879p ps=0.15492m w=76.52u l=1u
X1 DVDD GATE BAT DVDD pfet_06v0 ad=35.511p pd=48.245u as=35.511p ps=48.245u w=46.725u l=1u
X2 DVDD GATE BAT DVDD pfet_06v0 ad=71.8771p pd=0.15481m as=58.1134p ps=77.985u w=76.465u l=1u
X3 DVDD GATE BAT DVDD pfet_06v0 ad=71.92879p pd=0.15492m as=58.1552p ps=78.04u w=76.52u l=1u
X4 BAT GATE DVDD DVDD pfet_06v0 ad=35.511p pd=48.245u as=35.511p ps=48.245u w=46.725u l=1u
X5 BAT GATE DVDD DVDD pfet_06v0 ad=35.511p pd=48.245u as=35.511p ps=48.245u w=46.725u l=1u
X6 BAT GATE DVDD DVDD pfet_06v0 ad=58.1172p pd=77.99u as=58.1172p ps=77.99u w=76.47u l=1u
X7 BAT GATE DVDD DVDD pfet_06v0 ad=35.511p pd=48.245u as=35.511p ps=48.245u w=46.725u l=1u
X8 DVDD GATE BAT DVDD pfet_06v0 ad=58.1134p pd=77.985u as=58.1134p ps=77.985u w=76.465u l=1u
X9 BAT GATE DVDD DVDD pfet_06v0 ad=58.0754p pd=77.935u as=58.0754p ps=77.935u w=76.41499u l=1u
X10 DVDD GATE BAT DVDD pfet_06v0 ad=35.511p pd=48.245u as=35.511p ps=48.245u w=46.725u l=1u
X11 BAT GATE DVDD DVDD pfet_06v0 ad=58.1134p pd=77.985u as=58.1134p ps=77.985u w=76.465u l=1u
X12 BAT GATE DVDD DVDD pfet_06v0 ad=47.6862p pd=64.265u as=47.6862p ps=64.265u w=62.745u l=1u
X13 BAT GATE DVDD DVDD pfet_06v0 ad=35.511p pd=48.245u as=35.511p ps=48.245u w=46.725u l=1u
X14 BAT GATE DVDD DVDD pfet_06v0 ad=35.511p pd=48.245u as=35.511p ps=48.245u w=46.725u l=1u
X15 DVDD GATE BAT DVDD pfet_06v0 ad=43.9215p pd=95.32999u as=35.511p ps=48.245u w=46.725u l=1u
X16 BAT GATE DVDD DVDD pfet_06v0 ad=35.511p pd=48.245u as=35.511p ps=48.245u w=46.725u l=1u
X17 BAT GATE DVDD DVDD pfet_06v0 ad=58.1172p pd=77.99u as=71.8818p ps=0.15482m w=76.47u l=1u
X18 DVDD GATE BAT DVDD pfet_06v0 ad=35.511p pd=48.245u as=35.511p ps=48.245u w=46.725u l=1u
X19 BAT GATE DVDD DVDD pfet_06v0 ad=58.1134p pd=77.985u as=58.1134p ps=77.985u w=76.465u l=1u
X20 BAT GATE DVDD DVDD pfet_06v0 ad=35.511p pd=48.245u as=35.511p ps=48.245u w=46.725u l=1u
X21 DVDD GATE BAT DVDD pfet_06v0 ad=58.1134p pd=77.985u as=58.1134p ps=77.985u w=76.465u l=1u
X22 DVDD GATE BAT DVDD pfet_06v0 ad=43.9215p pd=95.32999u as=35.511p ps=48.245u w=46.725u l=1u
X23 DVDD GATE BAT DVDD pfet_06v0 ad=58.1096p pd=77.98u as=58.1096p ps=77.98u w=76.46u l=1u
X24 BAT GATE DVDD DVDD pfet_06v0 ad=35.511p pd=48.245u as=43.9215p ps=95.32999u w=46.725u l=1u
X25 BAT GATE DVDD DVDD pfet_06v0 ad=35.511p pd=48.245u as=35.511p ps=48.245u w=46.725u l=1u
X26 DVDD GATE BAT DVDD pfet_06v0 ad=35.511p pd=48.245u as=35.511p ps=48.245u w=46.725u l=1u
X27 BAT GATE DVDD DVDD pfet_06v0 ad=35.511p pd=48.245u as=35.511p ps=48.245u w=46.725u l=1u
X28 BAT GATE DVDD DVDD pfet_06v0 ad=35.5072p pd=48.24u as=43.9168p ps=95.32u w=46.72u l=1u
X29 DVDD GATE BAT DVDD pfet_06v0 ad=35.511p pd=48.245u as=35.511p ps=48.245u w=46.725u l=1u
X30 BAT GATE DVDD DVDD pfet_06v0 ad=35.511p pd=48.245u as=35.511p ps=48.245u w=46.725u l=1u
X31 DVDD GATE BAT DVDD pfet_06v0 ad=35.511p pd=48.245u as=35.511p ps=48.245u w=46.725u l=1u
X32 BAT GATE DVDD DVDD pfet_06v0 ad=58.1134p pd=77.985u as=71.8771p ps=0.15481m w=76.465u l=1u
X33 BAT GATE DVDD DVDD pfet_06v0 ad=35.511p pd=48.245u as=35.511p ps=48.245u w=46.725u l=1u
X34 DVDD GATE BAT DVDD pfet_06v0 ad=71.8771p pd=0.15481m as=58.1134p ps=77.985u w=76.465u l=1u
X35 BAT GATE DVDD DVDD pfet_06v0 ad=35.511p pd=48.245u as=35.511p ps=48.245u w=46.725u l=1u
X36 DVDD GATE BAT DVDD pfet_06v0 ad=58.1134p pd=77.985u as=58.1134p ps=77.985u w=76.465u l=1u
X37 DVDD GATE BAT DVDD pfet_06v0 ad=35.511p pd=48.245u as=35.511p ps=48.245u w=46.725u l=1u
X38 DVDD GATE BAT DVDD pfet_06v0 ad=35.511p pd=48.245u as=35.511p ps=48.245u w=46.725u l=1u
X39 DVDD GATE BAT DVDD pfet_06v0 ad=58.1134p pd=77.985u as=58.1134p ps=77.985u w=76.465u l=1u
X40 BAT GATE DVDD DVDD pfet_06v0 ad=58.0754p pd=77.935u as=58.0754p ps=77.935u w=76.41499u l=1u
X41 BAT GATE DVDD DVDD pfet_06v0 ad=58.1172p pd=77.99u as=58.1172p ps=77.99u w=76.47u l=1u
X42 DVDD GATE BAT DVDD pfet_06v0 ad=35.511p pd=48.245u as=35.511p ps=48.245u w=46.725u l=1u
X43 DVDD GATE BAT DVDD pfet_06v0 ad=35.511p pd=48.245u as=35.511p ps=48.245u w=46.725u l=1u
X44 BAT GATE DVDD DVDD pfet_06v0 ad=58.1134p pd=77.985u as=58.1134p ps=77.985u w=76.465u l=1u
X45 DVDD GATE BAT DVDD pfet_06v0 ad=43.9215p pd=95.32999u as=35.511p ps=48.245u w=46.725u l=1u
X46 BAT GATE DVDD DVDD pfet_06v0 ad=58.1134p pd=77.985u as=58.1134p ps=77.985u w=76.465u l=1u
X47 DVDD GATE BAT DVDD pfet_06v0 ad=43.9215p pd=95.32999u as=35.511p ps=48.245u w=46.725u l=1u
X48 DVDD GATE BAT DVDD pfet_06v0 ad=35.511p pd=48.245u as=35.511p ps=48.245u w=46.725u l=1u
X49 DVDD GATE BAT DVDD pfet_06v0 ad=35.511p pd=48.245u as=35.511p ps=48.245u w=46.725u l=1u
X50 DVDD GATE BAT DVDD pfet_06v0 ad=43.9215p pd=95.32999u as=35.511p ps=48.245u w=46.725u l=1u
X51 BAT GATE DVDD DVDD pfet_06v0 ad=35.511p pd=48.245u as=35.511p ps=48.245u w=46.725u l=1u
X52 DVDD GATE BAT DVDD pfet_06v0 ad=71.8771p pd=0.15481m as=58.1134p ps=77.985u w=76.465u l=1u
X53 DVDD GATE BAT DVDD pfet_06v0 ad=71.8771p pd=0.15481m as=58.1134p ps=77.985u w=76.465u l=1u
X54 DVDD GATE BAT DVDD pfet_06v0 ad=58.1134p pd=77.985u as=58.1134p ps=77.985u w=76.465u l=1u
X55 DVDD GATE BAT DVDD pfet_06v0 ad=71.8771p pd=0.15481m as=58.1134p ps=77.985u w=76.465u l=1u
X56 BAT GATE DVDD DVDD pfet_06v0 ad=58.1134p pd=77.985u as=58.1134p ps=77.985u w=76.465u l=1u
X57 BAT GATE DVDD DVDD pfet_06v0 ad=58.1134p pd=77.985u as=58.1134p ps=77.985u w=76.465u l=1u
X58 DVDD GATE BAT DVDD pfet_06v0 ad=35.511p pd=48.245u as=35.511p ps=48.245u w=46.725u l=1u
X59 BAT GATE DVDD DVDD pfet_06v0 ad=35.511p pd=48.245u as=43.9215p ps=95.32999u w=46.725u l=1u
X60 BAT GATE DVDD DVDD pfet_06v0 ad=58.1172p pd=77.99u as=58.1172p ps=77.99u w=76.47u l=1u
X61 BAT GATE DVDD DVDD pfet_06v0 ad=58.1134p pd=77.985u as=58.1134p ps=77.985u w=76.465u l=1u
X62 BAT GATE DVDD DVDD pfet_06v0 ad=58.1134p pd=77.985u as=58.1134p ps=77.985u w=76.465u l=1u
X63 BAT GATE DVDD DVDD pfet_06v0 ad=35.511p pd=48.245u as=35.511p ps=48.245u w=46.725u l=1u
X64 BAT GATE DVDD DVDD pfet_06v0 ad=58.1134p pd=77.985u as=58.1134p ps=77.985u w=76.465u l=1u
X65 DVDD GATE BAT DVDD pfet_06v0 ad=58.1552p pd=78.04u as=58.1552p ps=78.04u w=76.52u l=1u
X66 DVDD GATE BAT DVDD pfet_06v0 ad=35.511p pd=48.245u as=35.511p ps=48.245u w=46.725u l=1u
X67 BAT GATE DVDD DVDD pfet_06v0 ad=35.511p pd=48.245u as=35.511p ps=48.245u w=46.725u l=1u
X68 DVDD GATE BAT DVDD pfet_06v0 ad=61.0812p pd=0.13184m as=49.3848p ps=66.5u w=64.98u l=1u
X69 BAT GATE DVDD DVDD pfet_06v0 ad=58.1552p pd=78.04u as=58.1552p ps=78.04u w=76.52u l=1u
X70 DVDD GATE BAT DVDD pfet_06v0 ad=58.1134p pd=77.985u as=58.1134p ps=77.985u w=76.465u l=1u
X71 BAT GATE DVDD DVDD pfet_06v0 ad=35.511p pd=48.245u as=35.511p ps=48.245u w=46.725u l=1u
X72 DVDD GATE BAT DVDD pfet_06v0 ad=47.6862p pd=64.265u as=47.6862p ps=64.265u w=62.745u l=1u
X73 BAT GATE DVDD DVDD pfet_06v0 ad=58.1134p pd=77.985u as=58.1134p ps=77.985u w=76.465u l=1u
X74 BAT GATE DVDD DVDD pfet_06v0 ad=35.511p pd=48.245u as=43.9215p ps=95.32999u w=46.725u l=1u
X75 DVDD GATE BAT DVDD pfet_06v0 ad=71.8771p pd=0.15481m as=58.1134p ps=77.985u w=76.465u l=1u
X76 DVDD GATE BAT DVDD pfet_06v0 ad=58.1134p pd=77.985u as=58.1134p ps=77.985u w=76.465u l=1u
X77 DVDD GATE BAT DVDD pfet_06v0 ad=58.1134p pd=77.985u as=58.1134p ps=77.985u w=76.465u l=1u
X78 DVDD GATE BAT DVDD pfet_06v0 ad=58.1134p pd=77.985u as=58.1134p ps=77.985u w=76.465u l=1u
X79 DVDD GATE BAT DVDD pfet_06v0 ad=58.1172p pd=77.99u as=58.1172p ps=77.99u w=76.47u l=1u
X80 BAT GATE DVDD DVDD pfet_06v0 ad=58.0754p pd=77.935u as=58.0754p ps=77.935u w=76.41499u l=1u
X81 DVDD GATE BAT DVDD pfet_06v0 ad=35.511p pd=48.245u as=35.511p ps=48.245u w=46.725u l=1u
X82 BAT GATE DVDD DVDD pfet_06v0 ad=58.1134p pd=77.985u as=58.1134p ps=77.985u w=76.465u l=1u
X83 DVDD GATE BAT DVDD pfet_06v0 ad=58.1096p pd=77.98u as=58.1096p ps=77.98u w=76.46u l=1u
X84 DVDD GATE BAT DVDD pfet_06v0 ad=43.9215p pd=95.32999u as=35.511p ps=48.245u w=46.725u l=1u
X85 DVDD GATE BAT DVDD pfet_06v0 ad=43.9215p pd=95.32999u as=35.511p ps=48.245u w=46.725u l=1u
X86 DVDD GATE BAT DVDD pfet_06v0 ad=58.1096p pd=77.98u as=58.1096p ps=77.98u w=76.46u l=1u
X87 DVDD GATE BAT DVDD pfet_06v0 ad=71.8771p pd=0.15481m as=58.1134p ps=77.985u w=76.465u l=1u
X88 DVDD GATE BAT DVDD pfet_06v0 ad=58.1134p pd=77.985u as=58.1134p ps=77.985u w=76.465u l=1u
X89 BAT GATE DVDD DVDD pfet_06v0 ad=58.1172p pd=77.99u as=58.1172p ps=77.99u w=76.47u l=1u
X90 BAT GATE DVDD DVDD pfet_06v0 ad=49.3848p pd=66.5u as=49.3848p ps=66.5u w=64.98u l=1u
X91 BAT GATE DVDD DVDD pfet_06v0 ad=58.1134p pd=77.985u as=58.1134p ps=77.985u w=76.465u l=1u
X92 DVDD GATE BAT DVDD pfet_06v0 ad=49.3848p pd=66.5u as=49.3848p ps=66.5u w=64.98u l=1u
X93 DVDD GATE BAT DVDD pfet_06v0 ad=35.511p pd=48.245u as=35.511p ps=48.245u w=46.725u l=1u
X94 BAT GATE DVDD DVDD pfet_06v0 ad=35.511p pd=48.245u as=35.511p ps=48.245u w=46.725u l=1u
X95 BAT GATE DVDD DVDD pfet_06v0 ad=35.511p pd=48.245u as=35.511p ps=48.245u w=46.725u l=1u
X96 DVDD GATE BAT DVDD pfet_06v0 ad=58.1134p pd=77.985u as=58.1134p ps=77.985u w=76.465u l=1u
X97 BAT GATE DVDD DVDD pfet_06v0 ad=35.511p pd=48.245u as=35.511p ps=48.245u w=46.725u l=1u
X98 DVDD GATE BAT DVDD pfet_06v0 ad=35.511p pd=48.245u as=35.511p ps=48.245u w=46.725u l=1u
X99 DVDD GATE BAT DVDD pfet_06v0 ad=35.511p pd=48.245u as=35.511p ps=48.245u w=46.725u l=1u
X100 BAT GATE DVDD DVDD pfet_06v0 ad=58.1134p pd=77.985u as=58.1134p ps=77.985u w=76.465u l=1u
X101 BAT GATE DVDD DVDD pfet_06v0 ad=58.1134p pd=77.985u as=58.1134p ps=77.985u w=76.465u l=1u
X102 DVDD GATE BAT DVDD pfet_06v0 ad=58.0754p pd=77.935u as=58.0754p ps=77.935u w=76.41499u l=1u
X103 BAT GATE DVDD DVDD pfet_06v0 ad=35.511p pd=48.245u as=35.511p ps=48.245u w=46.725u l=1u
X104 BAT GATE DVDD DVDD pfet_06v0 ad=35.511p pd=48.245u as=43.9215p ps=95.32999u w=46.725u l=1u
X105 DVDD GATE BAT DVDD pfet_06v0 ad=58.1172p pd=77.99u as=58.1172p ps=77.99u w=76.47u l=1u
X106 BAT GATE DVDD DVDD pfet_06v0 ad=35.511p pd=48.245u as=35.511p ps=48.245u w=46.725u l=1u
X107 DVDD GATE BAT DVDD pfet_06v0 ad=58.0754p pd=77.935u as=58.0754p ps=77.935u w=76.41499u l=1u
X108 DVDD GATE BAT DVDD pfet_06v0 ad=35.511p pd=48.245u as=35.511p ps=48.245u w=46.725u l=1u
X109 BAT GATE DVDD DVDD pfet_06v0 ad=35.511p pd=48.245u as=35.511p ps=48.245u w=46.725u l=1u
X110 BAT GATE DVDD DVDD pfet_06v0 ad=47.6862p pd=64.265u as=47.6862p ps=64.265u w=62.745u l=1u
X111 DVDD GATE BAT DVDD pfet_06v0 ad=35.511p pd=48.245u as=35.511p ps=48.245u w=46.725u l=1u
X112 BAT GATE DVDD DVDD pfet_06v0 ad=58.1134p pd=77.985u as=58.1134p ps=77.985u w=76.465u l=1u
X113 BAT GATE DVDD DVDD pfet_06v0 ad=35.511p pd=48.245u as=35.511p ps=48.245u w=46.725u l=1u
X114 DVDD GATE BAT DVDD pfet_06v0 ad=35.511p pd=48.245u as=35.511p ps=48.245u w=46.725u l=1u
X115 DVDD GATE BAT DVDD pfet_06v0 ad=35.511p pd=48.245u as=35.511p ps=48.245u w=46.725u l=1u
X116 BAT GATE DVDD DVDD pfet_06v0 ad=35.5072p pd=48.24u as=35.5072p ps=48.24u w=46.72u l=1u
X117 DVDD GATE BAT DVDD pfet_06v0 ad=35.511p pd=48.245u as=35.511p ps=48.245u w=46.725u l=1u
X118 BAT GATE DVDD DVDD pfet_06v0 ad=58.1134p pd=77.985u as=58.1134p ps=77.985u w=76.465u l=1u
X119 BAT GATE DVDD DVDD pfet_06v0 ad=35.511p pd=48.245u as=43.9215p ps=95.32999u w=46.725u l=1u
X120 BAT GATE DVDD DVDD pfet_06v0 ad=35.511p pd=48.245u as=35.511p ps=48.245u w=46.725u l=1u
X121 BAT GATE DVDD DVDD pfet_06v0 ad=58.1096p pd=77.98u as=58.1096p ps=77.98u w=76.46u l=1u
X122 BAT GATE DVDD DVDD pfet_06v0 ad=35.511p pd=48.245u as=35.511p ps=48.245u w=46.725u l=1u
X123 BAT GATE DVDD DVDD pfet_06v0 ad=47.6862p pd=64.265u as=58.9803p ps=0.12737m w=62.745u l=1u
X124 DVDD GATE BAT DVDD pfet_06v0 ad=35.511p pd=48.245u as=35.511p ps=48.245u w=46.725u l=1u
X125 BAT GATE DVDD DVDD pfet_06v0 ad=49.3848p pd=66.5u as=49.3848p ps=66.5u w=64.98u l=1u
X126 BAT GATE DVDD DVDD pfet_06v0 ad=58.0754p pd=77.935u as=58.0754p ps=77.935u w=76.41499u l=1u
X127 BAT GATE DVDD DVDD pfet_06v0 ad=58.1552p pd=78.04u as=71.92879p ps=0.15492m w=76.52u l=1u
X128 BAT GATE DVDD DVDD pfet_06v0 ad=58.1172p pd=77.99u as=58.1172p ps=77.99u w=76.47u l=1u
X129 DVDD GATE BAT DVDD pfet_06v0 ad=43.9215p pd=95.32999u as=35.511p ps=48.245u w=46.725u l=1u
X130 BAT GATE DVDD DVDD pfet_06v0 ad=58.1552p pd=78.04u as=58.1552p ps=78.04u w=76.52u l=1u
X131 BAT GATE DVDD DVDD pfet_06v0 ad=35.511p pd=48.245u as=43.9215p ps=95.32999u w=46.725u l=1u
X132 DVDD GATE BAT DVDD pfet_06v0 ad=35.511p pd=48.245u as=35.511p ps=48.245u w=46.725u l=1u
X133 BAT GATE DVDD DVDD pfet_06v0 ad=35.511p pd=48.245u as=35.511p ps=48.245u w=46.725u l=1u
X134 DVDD GATE BAT DVDD pfet_06v0 ad=58.1134p pd=77.985u as=58.1134p ps=77.985u w=76.465u l=1u
X135 DVDD GATE BAT DVDD pfet_06v0 ad=61.0812p pd=0.13184m as=49.3848p ps=66.5u w=64.98u l=1u
X136 DVDD GATE BAT DVDD pfet_06v0 ad=35.511p pd=48.245u as=35.511p ps=48.245u w=46.725u l=1u
X137 DVDD GATE BAT DVDD pfet_06v0 ad=58.1552p pd=78.04u as=58.1552p ps=78.04u w=76.52u l=1u
X138 DVDD GATE BAT DVDD pfet_06v0 ad=58.1134p pd=77.985u as=58.1134p ps=77.985u w=76.465u l=1u
X139 BAT GATE DVDD DVDD pfet_06v0 ad=58.1134p pd=77.985u as=58.1134p ps=77.985u w=76.465u l=1u
X140 BAT GATE DVDD DVDD pfet_06v0 ad=35.511p pd=48.245u as=35.511p ps=48.245u w=46.725u l=1u
X141 BAT GATE DVDD DVDD pfet_06v0 ad=47.6862p pd=64.265u as=47.6862p ps=64.265u w=62.745u l=1u
X142 DVDD GATE BAT DVDD pfet_06v0 ad=43.9215p pd=95.32999u as=35.511p ps=48.245u w=46.725u l=1u
X143 BAT GATE DVDD DVDD pfet_06v0 ad=35.511p pd=48.245u as=43.9215p ps=95.32999u w=46.725u l=1u
X144 BAT GATE DVDD DVDD pfet_06v0 ad=58.1134p pd=77.985u as=58.1134p ps=77.985u w=76.465u l=1u
X145 BAT GATE DVDD DVDD pfet_06v0 ad=58.1134p pd=77.985u as=71.8771p ps=0.15481m w=76.465u l=1u
X146 DVDD GATE BAT DVDD pfet_06v0 ad=58.1134p pd=77.985u as=58.1134p ps=77.985u w=76.465u l=1u
X147 BAT GATE DVDD DVDD pfet_06v0 ad=58.1134p pd=77.985u as=58.1134p ps=77.985u w=76.465u l=1u
X148 BAT GATE DVDD DVDD pfet_06v0 ad=58.1552p pd=78.04u as=58.1552p ps=78.04u w=76.52u l=1u
X149 DVDD GATE BAT DVDD pfet_06v0 ad=58.1172p pd=77.99u as=58.1172p ps=77.99u w=76.47u l=1u
X150 DVDD GATE BAT DVDD pfet_06v0 ad=71.8771p pd=0.15481m as=58.1134p ps=77.985u w=76.465u l=1u
X151 DVDD GATE BAT DVDD pfet_06v0 ad=58.1552p pd=78.04u as=58.1552p ps=78.04u w=76.52u l=1u
X152 BAT GATE DVDD DVDD pfet_06v0 ad=35.511p pd=48.245u as=35.511p ps=48.245u w=46.725u l=1u
X153 BAT GATE DVDD DVDD pfet_06v0 ad=35.511p pd=48.245u as=43.9215p ps=95.32999u w=46.725u l=1u
X154 DVDD GATE BAT DVDD pfet_06v0 ad=35.511p pd=48.245u as=35.511p ps=48.245u w=46.725u l=1u
X155 DVDD GATE BAT DVDD pfet_06v0 ad=35.5072p pd=48.24u as=35.5072p ps=48.24u w=46.72u l=1u
X156 BAT GATE DVDD DVDD pfet_06v0 ad=58.1134p pd=77.985u as=58.1134p ps=77.985u w=76.465u l=1u
X157 BAT GATE DVDD DVDD pfet_06v0 ad=35.511p pd=48.245u as=43.9215p ps=95.32999u w=46.725u l=1u
X158 DVDD GATE BAT DVDD pfet_06v0 ad=35.511p pd=48.245u as=35.511p ps=48.245u w=46.725u l=1u
X159 DVDD GATE BAT DVDD pfet_06v0 ad=58.1134p pd=77.985u as=58.1134p ps=77.985u w=76.465u l=1u
X160 BAT GATE DVDD DVDD pfet_06v0 ad=58.1134p pd=77.985u as=71.8771p ps=0.15481m w=76.465u l=1u
X161 BAT GATE DVDD DVDD pfet_06v0 ad=35.511p pd=48.245u as=35.511p ps=48.245u w=46.725u l=1u
X162 DVDD GATE BAT DVDD pfet_06v0 ad=58.1134p pd=77.985u as=58.1134p ps=77.985u w=76.465u l=1u
X163 DVDD GATE BAT DVDD pfet_06v0 ad=49.3848p pd=66.5u as=49.3848p ps=66.5u w=64.98u l=1u
X164 BAT GATE DVDD DVDD pfet_06v0 ad=35.511p pd=48.245u as=35.511p ps=48.245u w=46.725u l=1u
X165 BAT GATE DVDD DVDD pfet_06v0 ad=49.3848p pd=66.5u as=49.3848p ps=66.5u w=64.98u l=1u
X166 DVDD GATE BAT DVDD pfet_06v0 ad=58.1134p pd=77.985u as=58.1134p ps=77.985u w=76.465u l=1u
X167 BAT GATE DVDD DVDD pfet_06v0 ad=58.0754p pd=77.935u as=58.0754p ps=77.935u w=76.41499u l=1u
X168 BAT GATE DVDD DVDD pfet_06v0 ad=47.6862p pd=64.265u as=58.9803p ps=0.12737m w=62.745u l=1u
X169 DVDD GATE BAT DVDD pfet_06v0 ad=58.1096p pd=77.98u as=58.1096p ps=77.98u w=76.46u l=1u
X170 DVDD GATE BAT DVDD pfet_06v0 ad=35.511p pd=48.245u as=35.511p ps=48.245u w=46.725u l=1u
X171 BAT GATE DVDD DVDD pfet_06v0 ad=35.511p pd=48.245u as=35.511p ps=48.245u w=46.725u l=1u
X172 DVDD GATE BAT DVDD pfet_06v0 ad=43.9215p pd=95.32999u as=35.511p ps=48.245u w=46.725u l=1u
X173 DVDD GATE BAT DVDD pfet_06v0 ad=58.1552p pd=78.04u as=58.1552p ps=78.04u w=76.52u l=1u
X174 BAT GATE DVDD DVDD pfet_06v0 ad=58.1134p pd=77.985u as=58.1134p ps=77.985u w=76.465u l=1u
X175 BAT GATE DVDD DVDD pfet_06v0 ad=35.511p pd=48.245u as=35.511p ps=48.245u w=46.725u l=1u
X176 DVDD GATE BAT DVDD pfet_06v0 ad=35.511p pd=48.245u as=35.511p ps=48.245u w=46.725u l=1u
X177 DVDD GATE BAT DVDD pfet_06v0 ad=58.1134p pd=77.985u as=58.1134p ps=77.985u w=76.465u l=1u
X178 BAT GATE DVDD DVDD pfet_06v0 ad=35.511p pd=48.245u as=35.511p ps=48.245u w=46.725u l=1u
X179 DVDD GATE BAT DVDD pfet_06v0 ad=35.511p pd=48.245u as=35.511p ps=48.245u w=46.725u l=1u
X180 BAT GATE DVDD DVDD pfet_06v0 ad=58.1134p pd=77.985u as=71.8771p ps=0.15481m w=76.465u l=1u
X181 DVDD GATE BAT DVDD pfet_06v0 ad=35.511p pd=48.245u as=35.511p ps=48.245u w=46.725u l=1u
X182 BAT GATE DVDD DVDD pfet_06v0 ad=58.1172p pd=77.99u as=58.1172p ps=77.99u w=76.47u l=1u
X183 BAT GATE DVDD DVDD pfet_06v0 ad=58.1134p pd=77.985u as=71.8771p ps=0.15481m w=76.465u l=1u
X184 DVDD GATE BAT DVDD pfet_06v0 ad=58.0754p pd=77.935u as=58.0754p ps=77.935u w=76.41499u l=1u
X185 BAT GATE DVDD DVDD pfet_06v0 ad=35.511p pd=48.245u as=35.511p ps=48.245u w=46.725u l=1u
X186 BAT GATE DVDD DVDD pfet_06v0 ad=58.1096p pd=77.98u as=58.1096p ps=77.98u w=76.46u l=1u
X187 BAT GATE DVDD DVDD pfet_06v0 ad=35.511p pd=48.245u as=35.511p ps=48.245u w=46.725u l=1u
X188 DVDD GATE BAT DVDD pfet_06v0 ad=58.9803p pd=0.12737m as=47.6862p ps=64.265u w=62.745u l=1u
X189 DVDD GATE BAT DVDD pfet_06v0 ad=58.1134p pd=77.985u as=58.1134p ps=77.985u w=76.465u l=1u
X190 BAT GATE DVDD DVDD pfet_06v0 ad=35.511p pd=48.245u as=35.511p ps=48.245u w=46.725u l=1u
X191 BAT GATE DVDD DVDD pfet_06v0 ad=35.511p pd=48.245u as=35.511p ps=48.245u w=46.725u l=1u
X192 DVDD GATE BAT DVDD pfet_06v0 ad=71.8771p pd=0.15481m as=58.1134p ps=77.985u w=76.465u l=1u
X193 DVDD GATE BAT DVDD pfet_06v0 ad=49.3848p pd=66.5u as=49.3848p ps=66.5u w=64.98u l=1u
X194 BAT GATE DVDD DVDD pfet_06v0 ad=58.1134p pd=77.985u as=58.1134p ps=77.985u w=76.465u l=1u
X195 DVDD GATE BAT DVDD pfet_06v0 ad=35.511p pd=48.245u as=35.511p ps=48.245u w=46.725u l=1u
X196 DVDD GATE BAT DVDD pfet_06v0 ad=58.1134p pd=77.985u as=58.1134p ps=77.985u w=76.465u l=1u
X197 BAT GATE DVDD DVDD pfet_06v0 ad=35.511p pd=48.245u as=35.511p ps=48.245u w=46.725u l=1u
X198 DVDD GATE BAT DVDD pfet_06v0 ad=58.1134p pd=77.985u as=58.1134p ps=77.985u w=76.465u l=1u
X199 BAT GATE DVDD DVDD pfet_06v0 ad=49.3848p pd=66.5u as=61.0812p ps=0.13184m w=64.98u l=1u
X200 DVDD GATE BAT DVDD pfet_06v0 ad=49.3848p pd=66.5u as=49.3848p ps=66.5u w=64.98u l=1u
X201 DVDD GATE BAT DVDD pfet_06v0 ad=35.511p pd=48.245u as=35.511p ps=48.245u w=46.725u l=1u
X202 BAT GATE DVDD DVDD pfet_06v0 ad=35.511p pd=48.245u as=43.9215p ps=95.32999u w=46.725u l=1u
X203 DVDD GATE BAT DVDD pfet_06v0 ad=47.6862p pd=64.265u as=47.6862p ps=64.265u w=62.745u l=1u
X204 DVDD GATE BAT DVDD pfet_06v0 ad=58.1134p pd=77.985u as=58.1134p ps=77.985u w=76.465u l=1u
X205 BAT GATE DVDD DVDD pfet_06v0 ad=58.1134p pd=77.985u as=58.1134p ps=77.985u w=76.465u l=1u
X206 BAT GATE DVDD DVDD pfet_06v0 ad=58.0754p pd=77.935u as=71.8301p ps=0.15471m w=76.41499u l=1u
X207 BAT GATE DVDD DVDD pfet_06v0 ad=58.0754p pd=77.935u as=58.0754p ps=77.935u w=76.41499u l=1u
X208 BAT GATE DVDD DVDD pfet_06v0 ad=49.3848p pd=66.5u as=49.3848p ps=66.5u w=64.98u l=1u
X209 DVDD GATE BAT DVDD pfet_06v0 ad=35.511p pd=48.245u as=35.511p ps=48.245u w=46.725u l=1u
X210 BAT GATE DVDD DVDD pfet_06v0 ad=58.1134p pd=77.985u as=58.1134p ps=77.985u w=76.465u l=1u
X211 BAT GATE DVDD DVDD pfet_06v0 ad=35.511p pd=48.245u as=35.511p ps=48.245u w=46.725u l=1u
X212 DVDD GATE BAT DVDD pfet_06v0 ad=47.6862p pd=64.265u as=47.6862p ps=64.265u w=62.745u l=1u
X213 DVDD GATE BAT DVDD pfet_06v0 ad=58.1134p pd=77.985u as=58.1134p ps=77.985u w=76.465u l=1u
X214 DVDD GATE BAT DVDD pfet_06v0 ad=58.1134p pd=77.985u as=58.1134p ps=77.985u w=76.465u l=1u
X215 DVDD GATE BAT DVDD pfet_06v0 ad=35.511p pd=48.245u as=35.511p ps=48.245u w=46.725u l=1u
X216 BAT GATE DVDD DVDD pfet_06v0 ad=58.1134p pd=77.985u as=58.1134p ps=77.985u w=76.465u l=1u
X217 DVDD GATE BAT DVDD pfet_06v0 ad=35.5072p pd=48.24u as=35.5072p ps=48.24u w=46.72u l=1u
X218 BAT GATE DVDD DVDD pfet_06v0 ad=58.1172p pd=77.99u as=58.1172p ps=77.99u w=76.47u l=1u
X219 DVDD GATE BAT DVDD pfet_06v0 ad=35.511p pd=48.245u as=35.511p ps=48.245u w=46.725u l=1u
X220 DVDD GATE BAT DVDD pfet_06v0 ad=58.1134p pd=77.985u as=58.1134p ps=77.985u w=76.465u l=1u
X221 BAT GATE DVDD DVDD pfet_06v0 ad=58.0754p pd=77.935u as=58.0754p ps=77.935u w=76.41499u l=1u
X222 BAT GATE DVDD DVDD pfet_06v0 ad=58.1134p pd=77.985u as=71.8771p ps=0.15481m w=76.465u l=1u
X223 BAT GATE DVDD DVDD pfet_06v0 ad=35.511p pd=48.245u as=43.9215p ps=95.32999u w=46.725u l=1u
X224 DVDD GATE BAT DVDD pfet_06v0 ad=35.511p pd=48.245u as=35.511p ps=48.245u w=46.725u l=1u
X225 DVDD GATE BAT DVDD pfet_06v0 ad=47.6862p pd=64.265u as=47.6862p ps=64.265u w=62.745u l=1u
X226 BAT GATE DVDD DVDD pfet_06v0 ad=35.511p pd=48.245u as=35.511p ps=48.245u w=46.725u l=1u
X227 DVDD GATE BAT DVDD pfet_06v0 ad=43.9215p pd=95.32999u as=35.511p ps=48.245u w=46.725u l=1u
X228 BAT GATE DVDD DVDD pfet_06v0 ad=58.1172p pd=77.99u as=58.1172p ps=77.99u w=76.47u l=1u
X229 DVDD GATE BAT DVDD pfet_06v0 ad=35.511p pd=48.245u as=35.511p ps=48.245u w=46.725u l=1u
X230 BAT GATE DVDD DVDD pfet_06v0 ad=58.1096p pd=77.98u as=71.8724p ps=0.1548m w=76.46u l=1u
X231 DVDD GATE BAT DVDD pfet_06v0 ad=35.5072p pd=48.24u as=35.5072p ps=48.24u w=46.72u l=1u
X232 BAT GATE DVDD DVDD pfet_06v0 ad=58.1134p pd=77.985u as=58.1134p ps=77.985u w=76.465u l=1u
X233 DVDD GATE BAT DVDD pfet_06v0 ad=35.511p pd=48.245u as=35.511p ps=48.245u w=46.725u l=1u
X234 DVDD GATE BAT DVDD pfet_06v0 ad=58.1172p pd=77.99u as=58.1172p ps=77.99u w=76.47u l=1u
X235 DVDD GATE BAT DVDD pfet_06v0 ad=35.511p pd=48.245u as=35.511p ps=48.245u w=46.725u l=1u
X236 BAT GATE DVDD DVDD pfet_06v0 ad=58.1134p pd=77.985u as=58.1134p ps=77.985u w=76.465u l=1u
X237 BAT GATE DVDD DVDD pfet_06v0 ad=58.1134p pd=77.985u as=58.1134p ps=77.985u w=76.465u l=1u
X238 DVDD GATE BAT DVDD pfet_06v0 ad=58.1134p pd=77.985u as=58.1134p ps=77.985u w=76.465u l=1u
X239 DVDD GATE BAT DVDD pfet_06v0 ad=35.511p pd=48.245u as=35.511p ps=48.245u w=46.725u l=1u
X240 BAT GATE DVDD DVDD pfet_06v0 ad=35.511p pd=48.245u as=43.9215p ps=95.32999u w=46.725u l=1u
X241 DVDD GATE BAT DVDD pfet_06v0 ad=35.5072p pd=48.24u as=35.5072p ps=48.24u w=46.72u l=1u
X242 DVDD GATE BAT DVDD pfet_06v0 ad=58.1134p pd=77.985u as=58.1134p ps=77.985u w=76.465u l=1u
X243 DVDD GATE BAT DVDD pfet_06v0 ad=43.9215p pd=95.32999u as=35.511p ps=48.245u w=46.725u l=1u
X244 DVDD GATE BAT DVDD pfet_06v0 ad=71.8771p pd=0.15481m as=58.1134p ps=77.985u w=76.465u l=1u
X245 DVDD GATE BAT DVDD pfet_06v0 ad=58.0754p pd=77.935u as=58.0754p ps=77.935u w=76.41499u l=1u
X246 BAT GATE DVDD DVDD pfet_06v0 ad=35.511p pd=48.245u as=43.9215p ps=95.32999u w=46.725u l=1u
X247 DVDD GATE BAT DVDD pfet_06v0 ad=47.6862p pd=64.265u as=47.6862p ps=64.265u w=62.745u l=1u
X248 DVDD GATE BAT DVDD pfet_06v0 ad=71.8771p pd=0.15481m as=58.1134p ps=77.985u w=76.465u l=1u
X249 DVDD GATE BAT DVDD pfet_06v0 ad=58.1134p pd=77.985u as=58.1134p ps=77.985u w=76.465u l=1u
X250 BAT GATE DVDD DVDD pfet_06v0 ad=58.1552p pd=78.04u as=58.1552p ps=78.04u w=76.52u l=1u
X251 DVDD GATE BAT DVDD pfet_06v0 ad=71.8771p pd=0.15481m as=58.1134p ps=77.985u w=76.465u l=1u
X252 DVDD GATE BAT DVDD pfet_06v0 ad=58.1134p pd=77.985u as=58.1134p ps=77.985u w=76.465u l=1u
X253 DVDD GATE BAT DVDD pfet_06v0 ad=47.6862p pd=64.265u as=47.6862p ps=64.265u w=62.745u l=1u
X254 BAT GATE DVDD DVDD pfet_06v0 ad=35.511p pd=48.245u as=35.511p ps=48.245u w=46.725u l=1u
X255 BAT GATE DVDD DVDD pfet_06v0 ad=47.6862p pd=64.265u as=58.9803p ps=0.12737m w=62.745u l=1u
X256 DVDD GATE BAT DVDD pfet_06v0 ad=58.1134p pd=77.985u as=58.1134p ps=77.985u w=76.465u l=1u
X257 DVDD GATE BAT DVDD pfet_06v0 ad=35.511p pd=48.245u as=35.511p ps=48.245u w=46.725u l=1u
X258 BAT GATE DVDD DVDD pfet_06v0 ad=58.1134p pd=77.985u as=71.8771p ps=0.15481m w=76.465u l=1u
X259 DVDD GATE BAT DVDD pfet_06v0 ad=35.511p pd=48.245u as=35.511p ps=48.245u w=46.725u l=1u
X260 DVDD GATE BAT DVDD pfet_06v0 ad=43.9215p pd=95.32999u as=35.511p ps=48.245u w=46.725u l=1u
X261 DVDD GATE BAT DVDD pfet_06v0 ad=35.511p pd=48.245u as=35.511p ps=48.245u w=46.725u l=1u
X262 BAT GATE DVDD DVDD pfet_06v0 ad=58.1172p pd=77.99u as=71.8818p ps=0.15482m w=76.47u l=1u
X263 BAT GATE DVDD DVDD pfet_06v0 ad=58.1134p pd=77.985u as=58.1134p ps=77.985u w=76.465u l=1u
X264 BAT GATE DVDD DVDD pfet_06v0 ad=58.1552p pd=78.04u as=58.1552p ps=78.04u w=76.52u l=1u
X265 DVDD GATE BAT DVDD pfet_06v0 ad=35.511p pd=48.245u as=35.511p ps=48.245u w=46.725u l=1u
X266 BAT GATE DVDD DVDD pfet_06v0 ad=35.5072p pd=48.24u as=35.5072p ps=48.24u w=46.72u l=1u
X267 DVDD GATE BAT DVDD pfet_06v0 ad=35.511p pd=48.245u as=35.511p ps=48.245u w=46.725u l=1u
X268 DVDD GATE BAT DVDD pfet_06v0 ad=58.1134p pd=77.985u as=58.1134p ps=77.985u w=76.465u l=1u
X269 DVDD GATE BAT DVDD pfet_06v0 ad=35.511p pd=48.245u as=35.511p ps=48.245u w=46.725u l=1u
X270 BAT GATE DVDD DVDD pfet_06v0 ad=49.3848p pd=66.5u as=49.3848p ps=66.5u w=64.98u l=1u
X271 DVDD GATE BAT DVDD pfet_06v0 ad=58.0754p pd=77.935u as=58.0754p ps=77.935u w=76.41499u l=1u
X272 DVDD GATE BAT DVDD pfet_06v0 ad=49.3848p pd=66.5u as=49.3848p ps=66.5u w=64.98u l=1u
X273 BAT GATE DVDD DVDD pfet_06v0 ad=58.1134p pd=77.985u as=71.8771p ps=0.15481m w=76.465u l=1u
X274 DVDD GATE BAT DVDD pfet_06v0 ad=35.511p pd=48.245u as=35.511p ps=48.245u w=46.725u l=1u
X275 DVDD GATE BAT DVDD pfet_06v0 ad=71.8301p pd=0.15471m as=58.0754p ps=77.935u w=76.41499u l=1u
X276 DVDD GATE BAT DVDD pfet_06v0 ad=58.1134p pd=77.985u as=58.1134p ps=77.985u w=76.465u l=1u
X277 BAT GATE DVDD DVDD pfet_06v0 ad=58.1096p pd=77.98u as=58.1096p ps=77.98u w=76.46u l=1u
X278 BAT GATE DVDD DVDD pfet_06v0 ad=35.511p pd=48.245u as=35.511p ps=48.245u w=46.725u l=1u
X279 DVDD GATE BAT DVDD pfet_06v0 ad=35.511p pd=48.245u as=35.511p ps=48.245u w=46.725u l=1u
X280 DVDD GATE BAT DVDD pfet_06v0 ad=47.6862p pd=64.265u as=47.6862p ps=64.265u w=62.745u l=1u
X281 DVDD GATE BAT DVDD pfet_06v0 ad=49.3848p pd=66.5u as=49.3848p ps=66.5u w=64.98u l=1u
X282 BAT GATE DVDD DVDD pfet_06v0 ad=58.1134p pd=77.985u as=58.1134p ps=77.985u w=76.465u l=1u
X283 BAT GATE DVDD DVDD pfet_06v0 ad=58.1134p pd=77.985u as=58.1134p ps=77.985u w=76.465u l=1u
X284 BAT GATE DVDD DVDD pfet_06v0 ad=58.1134p pd=77.985u as=58.1134p ps=77.985u w=76.465u l=1u
X285 DVDD GATE BAT DVDD pfet_06v0 ad=43.9215p pd=95.32999u as=35.511p ps=48.245u w=46.725u l=1u
X286 BAT GATE DVDD DVDD pfet_06v0 ad=35.511p pd=48.245u as=35.511p ps=48.245u w=46.725u l=1u
X287 DVDD GATE BAT DVDD pfet_06v0 ad=58.1172p pd=77.99u as=58.1172p ps=77.99u w=76.47u l=1u
X288 DVDD GATE BAT DVDD pfet_06v0 ad=58.1172p pd=77.99u as=58.1172p ps=77.99u w=76.47u l=1u
X289 DVDD GATE BAT DVDD pfet_06v0 ad=58.9803p pd=0.12737m as=47.6862p ps=64.265u w=62.745u l=1u
X290 DVDD GATE BAT DVDD pfet_06v0 ad=58.1134p pd=77.985u as=58.1134p ps=77.985u w=76.465u l=1u
X291 BAT GATE DVDD DVDD pfet_06v0 ad=49.3848p pd=66.5u as=61.0812p ps=0.13184m w=64.98u l=1u
X292 DVDD GATE BAT DVDD pfet_06v0 ad=58.1134p pd=77.985u as=58.1134p ps=77.985u w=76.465u l=1u
X293 BAT GATE DVDD DVDD pfet_06v0 ad=47.6862p pd=64.265u as=47.6862p ps=64.265u w=62.745u l=1u
X294 DVDD GATE BAT DVDD pfet_06v0 ad=43.9215p pd=95.32999u as=35.511p ps=48.245u w=46.725u l=1u
X295 BAT GATE DVDD DVDD pfet_06v0 ad=35.5072p pd=48.24u as=35.5072p ps=48.24u w=46.72u l=1u
X296 BAT GATE DVDD DVDD pfet_06v0 ad=58.1134p pd=77.985u as=58.1134p ps=77.985u w=76.465u l=1u
X297 BAT GATE DVDD DVDD pfet_06v0 ad=58.1134p pd=77.985u as=58.1134p ps=77.985u w=76.465u l=1u
X298 BAT GATE DVDD DVDD pfet_06v0 ad=35.511p pd=48.245u as=43.9215p ps=95.32999u w=46.725u l=1u
X299 DVDD GATE BAT DVDD pfet_06v0 ad=49.3848p pd=66.5u as=49.3848p ps=66.5u w=64.98u l=1u
X300 DVDD GATE BAT DVDD pfet_06v0 ad=35.511p pd=48.245u as=35.511p ps=48.245u w=46.725u l=1u
X301 BAT GATE DVDD DVDD pfet_06v0 ad=35.5072p pd=48.24u as=35.5072p ps=48.24u w=46.72u l=1u
X302 DVDD GATE BAT DVDD pfet_06v0 ad=35.511p pd=48.245u as=35.511p ps=48.245u w=46.725u l=1u
X303 DVDD GATE BAT DVDD pfet_06v0 ad=58.1134p pd=77.985u as=58.1134p ps=77.985u w=76.465u l=1u
X304 BAT GATE DVDD DVDD pfet_06v0 ad=35.5072p pd=48.24u as=35.5072p ps=48.24u w=46.72u l=1u
X305 BAT GATE DVDD DVDD pfet_06v0 ad=35.511p pd=48.245u as=35.511p ps=48.245u w=46.725u l=1u
X306 DVDD GATE BAT DVDD pfet_06v0 ad=35.511p pd=48.245u as=35.511p ps=48.245u w=46.725u l=1u
X307 BAT GATE DVDD DVDD pfet_06v0 ad=58.1134p pd=77.985u as=71.8771p ps=0.15481m w=76.465u l=1u
X308 DVDD GATE BAT DVDD pfet_06v0 ad=58.1134p pd=77.985u as=58.1134p ps=77.985u w=76.465u l=1u
X309 DVDD GATE BAT DVDD pfet_06v0 ad=43.9168p pd=95.32u as=35.5072p ps=48.24u w=46.72u l=1u
X310 DVDD GATE BAT DVDD pfet_06v0 ad=71.8771p pd=0.15481m as=58.1134p ps=77.985u w=76.465u l=1u
X311 DVDD GATE BAT DVDD pfet_06v0 ad=71.8771p pd=0.15481m as=58.1134p ps=77.985u w=76.465u l=1u
X312 BAT GATE DVDD DVDD pfet_06v0 ad=58.1134p pd=77.985u as=58.1134p ps=77.985u w=76.465u l=1u
X313 BAT GATE DVDD DVDD pfet_06v0 ad=58.1134p pd=77.985u as=58.1134p ps=77.985u w=76.465u l=1u
X314 DVDD GATE BAT DVDD pfet_06v0 ad=35.511p pd=48.245u as=35.511p ps=48.245u w=46.725u l=1u
X315 BAT GATE DVDD DVDD pfet_06v0 ad=58.1134p pd=77.985u as=58.1134p ps=77.985u w=76.465u l=1u
X316 BAT GATE DVDD DVDD pfet_06v0 ad=58.1134p pd=77.985u as=58.1134p ps=77.985u w=76.465u l=1u
X317 BAT GATE DVDD DVDD pfet_06v0 ad=47.6862p pd=64.265u as=58.9803p ps=0.12737m w=62.745u l=1u
X318 BAT GATE DVDD DVDD pfet_06v0 ad=35.511p pd=48.245u as=35.511p ps=48.245u w=46.725u l=1u
X319 BAT GATE DVDD DVDD pfet_06v0 ad=58.1096p pd=77.98u as=58.1096p ps=77.98u w=76.46u l=1u
X320 DVDD GATE BAT DVDD pfet_06v0 ad=43.9215p pd=95.32999u as=35.511p ps=48.245u w=46.725u l=1u
X321 BAT GATE DVDD DVDD pfet_06v0 ad=47.6862p pd=64.265u as=47.6862p ps=64.265u w=62.745u l=1u
X322 BAT GATE DVDD DVDD pfet_06v0 ad=35.511p pd=48.245u as=35.511p ps=48.245u w=46.725u l=1u
X323 BAT GATE DVDD DVDD pfet_06v0 ad=35.5072p pd=48.24u as=43.9168p ps=95.32u w=46.72u l=1u
X324 BAT GATE DVDD DVDD pfet_06v0 ad=58.1134p pd=77.985u as=58.1134p ps=77.985u w=76.465u l=1u
X325 BAT GATE DVDD DVDD pfet_06v0 ad=35.511p pd=48.245u as=35.511p ps=48.245u w=46.725u l=1u
X326 DVDD GATE BAT DVDD pfet_06v0 ad=58.1172p pd=77.99u as=58.1172p ps=77.99u w=76.47u l=1u
X327 DVDD GATE BAT DVDD pfet_06v0 ad=58.1134p pd=77.985u as=58.1134p ps=77.985u w=76.465u l=1u
X328 DVDD GATE BAT DVDD pfet_06v0 ad=35.511p pd=48.245u as=35.511p ps=48.245u w=46.725u l=1u
X329 DVDD GATE BAT DVDD pfet_06v0 ad=58.1552p pd=78.04u as=58.1552p ps=78.04u w=76.52u l=1u
X330 DVDD GATE BAT DVDD pfet_06v0 ad=71.8818p pd=0.15482m as=58.1172p ps=77.99u w=76.47u l=1u
X331 DVDD GATE BAT DVDD pfet_06v0 ad=43.9215p pd=95.32999u as=35.511p ps=48.245u w=46.725u l=1u
X332 BAT GATE DVDD DVDD pfet_06v0 ad=35.511p pd=48.245u as=43.9215p ps=95.32999u w=46.725u l=1u
X333 BAT GATE DVDD DVDD pfet_06v0 ad=58.1172p pd=77.99u as=58.1172p ps=77.99u w=76.47u l=1u
X334 BAT GATE DVDD DVDD pfet_06v0 ad=35.5072p pd=48.24u as=43.9168p ps=95.32u w=46.72u l=1u
X335 DVDD GATE BAT DVDD pfet_06v0 ad=35.511p pd=48.245u as=35.511p ps=48.245u w=46.725u l=1u
X336 BAT GATE DVDD DVDD pfet_06v0 ad=58.1134p pd=77.985u as=58.1134p ps=77.985u w=76.465u l=1u
X337 BAT GATE DVDD DVDD pfet_06v0 ad=58.1134p pd=77.985u as=58.1134p ps=77.985u w=76.465u l=1u
X338 BAT GATE DVDD DVDD pfet_06v0 ad=58.1134p pd=77.985u as=58.1134p ps=77.985u w=76.465u l=1u
X339 BAT GATE DVDD DVDD pfet_06v0 ad=58.0754p pd=77.935u as=58.0754p ps=77.935u w=76.41499u l=1u
X340 BAT GATE DVDD DVDD pfet_06v0 ad=58.1134p pd=77.985u as=58.1134p ps=77.985u w=76.465u l=1u
X341 BAT GATE DVDD DVDD pfet_06v0 ad=35.511p pd=48.245u as=35.511p ps=48.245u w=46.725u l=1u
X342 BAT GATE DVDD DVDD pfet_06v0 ad=35.511p pd=48.245u as=35.511p ps=48.245u w=46.725u l=1u
X343 DVDD GATE BAT DVDD pfet_06v0 ad=35.511p pd=48.245u as=35.511p ps=48.245u w=46.725u l=1u
X344 DVDD GATE BAT DVDD pfet_06v0 ad=58.1134p pd=77.985u as=58.1134p ps=77.985u w=76.465u l=1u
X345 BAT GATE DVDD DVDD pfet_06v0 ad=58.1134p pd=77.985u as=58.1134p ps=77.985u w=76.465u l=1u
X346 DVDD GATE BAT DVDD pfet_06v0 ad=35.511p pd=48.245u as=35.511p ps=48.245u w=46.725u l=1u
X347 BAT GATE DVDD DVDD pfet_06v0 ad=58.1134p pd=77.985u as=58.1134p ps=77.985u w=76.465u l=1u
X348 BAT GATE DVDD DVDD pfet_06v0 ad=35.511p pd=48.245u as=35.511p ps=48.245u w=46.725u l=1u
X349 DVDD GATE BAT DVDD pfet_06v0 ad=58.1134p pd=77.985u as=58.1134p ps=77.985u w=76.465u l=1u
X350 DVDD GATE BAT DVDD pfet_06v0 ad=71.8724p pd=0.1548m as=58.1096p ps=77.98u w=76.46u l=1u
X351 DVDD GATE BAT DVDD pfet_06v0 ad=35.511p pd=48.245u as=35.511p ps=48.245u w=46.725u l=1u
X352 DVDD GATE BAT DVDD pfet_06v0 ad=58.1096p pd=77.98u as=58.1096p ps=77.98u w=76.46u l=1u
X353 DVDD GATE BAT DVDD pfet_06v0 ad=43.9215p pd=95.32999u as=35.511p ps=48.245u w=46.725u l=1u
X354 DVDD GATE BAT DVDD pfet_06v0 ad=43.9215p pd=95.32999u as=35.511p ps=48.245u w=46.725u l=1u
X355 DVDD GATE BAT DVDD pfet_06v0 ad=58.1134p pd=77.985u as=58.1134p ps=77.985u w=76.465u l=1u
X356 DVDD GATE BAT DVDD pfet_06v0 ad=35.511p pd=48.245u as=35.511p ps=48.245u w=46.725u l=1u
X357 DVDD GATE BAT DVDD pfet_06v0 ad=43.9215p pd=95.32999u as=35.511p ps=48.245u w=46.725u l=1u
X358 BAT GATE DVDD DVDD pfet_06v0 ad=58.1172p pd=77.99u as=58.1172p ps=77.99u w=76.47u l=1u
X359 BAT GATE DVDD DVDD pfet_06v0 ad=35.511p pd=48.245u as=35.511p ps=48.245u w=46.725u l=1u
X360 DVDD GATE BAT DVDD pfet_06v0 ad=43.9168p pd=95.32u as=35.5072p ps=48.24u w=46.72u l=1u
X361 DVDD GATE BAT DVDD pfet_06v0 ad=43.9215p pd=95.32999u as=35.511p ps=48.245u w=46.725u l=1u
X362 BAT GATE DVDD DVDD pfet_06v0 ad=35.511p pd=48.245u as=35.511p ps=48.245u w=46.725u l=1u
X363 DVDD GATE BAT DVDD pfet_06v0 ad=35.511p pd=48.245u as=35.511p ps=48.245u w=46.725u l=1u
X364 DVDD GATE BAT DVDD pfet_06v0 ad=35.5072p pd=48.24u as=35.5072p ps=48.24u w=46.72u l=1u
X365 BAT GATE DVDD DVDD pfet_06v0 ad=49.3848p pd=66.5u as=49.3848p ps=66.5u w=64.98u l=1u
X366 BAT GATE DVDD DVDD pfet_06v0 ad=35.511p pd=48.245u as=35.511p ps=48.245u w=46.725u l=1u
X367 BAT GATE DVDD DVDD pfet_06v0 ad=35.511p pd=48.245u as=43.9215p ps=95.32999u w=46.725u l=1u
X368 DVDD GATE BAT DVDD pfet_06v0 ad=58.1134p pd=77.985u as=58.1134p ps=77.985u w=76.465u l=1u
X369 BAT GATE DVDD DVDD pfet_06v0 ad=35.511p pd=48.245u as=35.511p ps=48.245u w=46.725u l=1u
X370 BAT GATE DVDD DVDD pfet_06v0 ad=58.1134p pd=77.985u as=58.1134p ps=77.985u w=76.465u l=1u
X371 DVDD GATE BAT DVDD pfet_06v0 ad=58.1134p pd=77.985u as=58.1134p ps=77.985u w=76.465u l=1u
X372 DVDD GATE BAT DVDD pfet_06v0 ad=58.0754p pd=77.935u as=58.0754p ps=77.935u w=76.41499u l=1u
X373 DVDD GATE BAT DVDD pfet_06v0 ad=43.9215p pd=95.32999u as=35.511p ps=48.245u w=46.725u l=1u
X374 BAT GATE DVDD DVDD pfet_06v0 ad=35.511p pd=48.245u as=35.511p ps=48.245u w=46.725u l=1u
X375 DVDD GATE BAT DVDD pfet_06v0 ad=58.1134p pd=77.985u as=58.1134p ps=77.985u w=76.465u l=1u
X376 DVDD GATE BAT DVDD pfet_06v0 ad=58.9803p pd=0.12737m as=47.6862p ps=64.265u w=62.745u l=1u
X377 BAT GATE DVDD DVDD pfet_06v0 ad=58.1134p pd=77.985u as=71.8771p ps=0.15481m w=76.465u l=1u
X378 DVDD GATE BAT DVDD pfet_06v0 ad=35.511p pd=48.245u as=35.511p ps=48.245u w=46.725u l=1u
X379 DVDD GATE BAT DVDD pfet_06v0 ad=35.511p pd=48.245u as=35.511p ps=48.245u w=46.725u l=1u
X380 DVDD GATE BAT DVDD pfet_06v0 ad=35.511p pd=48.245u as=35.511p ps=48.245u w=46.725u l=1u
X381 BAT GATE DVDD DVDD pfet_06v0 ad=35.511p pd=48.245u as=35.511p ps=48.245u w=46.725u l=1u
X382 BAT GATE DVDD DVDD pfet_06v0 ad=35.511p pd=48.245u as=35.511p ps=48.245u w=46.725u l=1u
X383 DVDD GATE BAT DVDD pfet_06v0 ad=58.1134p pd=77.985u as=58.1134p ps=77.985u w=76.465u l=1u
X384 DVDD GATE BAT DVDD pfet_06v0 ad=58.1134p pd=77.985u as=58.1134p ps=77.985u w=76.465u l=1u
X385 DVDD GATE BAT DVDD pfet_06v0 ad=58.1134p pd=77.985u as=58.1134p ps=77.985u w=76.465u l=1u
X386 DVDD GATE BAT DVDD pfet_06v0 ad=47.6862p pd=64.265u as=47.6862p ps=64.265u w=62.745u l=1u
X387 DVDD GATE BAT DVDD pfet_06v0 ad=58.1134p pd=77.985u as=58.1134p ps=77.985u w=76.465u l=1u
X388 BAT GATE DVDD DVDD pfet_06v0 ad=58.1134p pd=77.985u as=58.1134p ps=77.985u w=76.465u l=1u
X389 BAT GATE DVDD DVDD pfet_06v0 ad=47.6862p pd=64.265u as=47.6862p ps=64.265u w=62.745u l=1u
X390 DVDD GATE BAT DVDD pfet_06v0 ad=35.511p pd=48.245u as=35.511p ps=48.245u w=46.725u l=1u
X391 BAT GATE DVDD DVDD pfet_06v0 ad=58.1172p pd=77.99u as=58.1172p ps=77.99u w=76.47u l=1u
X392 BAT GATE DVDD DVDD pfet_06v0 ad=58.1134p pd=77.985u as=58.1134p ps=77.985u w=76.465u l=1u
X393 BAT GATE DVDD DVDD pfet_06v0 ad=35.511p pd=48.245u as=35.511p ps=48.245u w=46.725u l=1u
X394 BAT GATE DVDD DVDD pfet_06v0 ad=58.1134p pd=77.985u as=71.8771p ps=0.15481m w=76.465u l=1u
X395 DVDD GATE BAT DVDD pfet_06v0 ad=58.1552p pd=78.04u as=58.1552p ps=78.04u w=76.52u l=1u
X396 BAT GATE DVDD DVDD pfet_06v0 ad=35.511p pd=48.245u as=35.511p ps=48.245u w=46.725u l=1u
X397 DVDD GATE BAT DVDD pfet_06v0 ad=43.9215p pd=95.32999u as=35.511p ps=48.245u w=46.725u l=1u
X398 BAT GATE DVDD DVDD pfet_06v0 ad=35.511p pd=48.245u as=35.511p ps=48.245u w=46.725u l=1u
X399 BAT GATE DVDD DVDD pfet_06v0 ad=35.511p pd=48.245u as=35.511p ps=48.245u w=46.725u l=1u
X400 DVDD GATE BAT DVDD pfet_06v0 ad=43.9215p pd=95.32999u as=35.511p ps=48.245u w=46.725u l=1u
X401 DVDD GATE BAT DVDD pfet_06v0 ad=71.8771p pd=0.15481m as=58.1134p ps=77.985u w=76.465u l=1u
X402 BAT GATE DVDD DVDD pfet_06v0 ad=58.1552p pd=78.04u as=71.92879p ps=0.15492m w=76.52u l=1u
X403 DVDD GATE BAT DVDD pfet_06v0 ad=43.9215p pd=95.32999u as=35.511p ps=48.245u w=46.725u l=1u
X404 BAT GATE DVDD DVDD pfet_06v0 ad=35.511p pd=48.245u as=35.511p ps=48.245u w=46.725u l=1u
X405 BAT GATE DVDD DVDD pfet_06v0 ad=58.1134p pd=77.985u as=58.1134p ps=77.985u w=76.465u l=1u
X406 BAT GATE DVDD DVDD pfet_06v0 ad=58.1134p pd=77.985u as=58.1134p ps=77.985u w=76.465u l=1u
X407 DVDD GATE BAT DVDD pfet_06v0 ad=58.1134p pd=77.985u as=58.1134p ps=77.985u w=76.465u l=1u
X408 BAT GATE DVDD DVDD pfet_06v0 ad=58.0754p pd=77.935u as=58.0754p ps=77.935u w=76.41499u l=1u
X409 DVDD GATE BAT DVDD pfet_06v0 ad=58.9803p pd=0.12737m as=47.6862p ps=64.265u w=62.745u l=1u
X410 DVDD GATE BAT DVDD pfet_06v0 ad=35.511p pd=48.245u as=35.511p ps=48.245u w=46.725u l=1u
X411 DVDD GATE BAT DVDD pfet_06v0 ad=35.511p pd=48.245u as=35.511p ps=48.245u w=46.725u l=1u
X412 DVDD GATE BAT DVDD pfet_06v0 ad=58.1096p pd=77.98u as=58.1096p ps=77.98u w=76.46u l=1u
X413 DVDD GATE BAT DVDD pfet_06v0 ad=58.1172p pd=77.99u as=58.1172p ps=77.99u w=76.47u l=1u
X414 BAT GATE DVDD DVDD pfet_06v0 ad=35.511p pd=48.245u as=35.511p ps=48.245u w=46.725u l=1u
X415 DVDD GATE BAT DVDD pfet_06v0 ad=35.511p pd=48.245u as=35.511p ps=48.245u w=46.725u l=1u
X416 BAT GATE DVDD DVDD pfet_06v0 ad=58.1134p pd=77.985u as=58.1134p ps=77.985u w=76.465u l=1u
X417 DVDD GATE BAT DVDD pfet_06v0 ad=71.8818p pd=0.15482m as=58.1172p ps=77.99u w=76.47u l=1u
X418 BAT GATE DVDD DVDD pfet_06v0 ad=49.3848p pd=66.5u as=49.3848p ps=66.5u w=64.98u l=1u
X419 DVDD GATE BAT DVDD pfet_06v0 ad=58.1134p pd=77.985u as=58.1134p ps=77.985u w=76.465u l=1u
X420 DVDD GATE BAT DVDD pfet_06v0 ad=58.1134p pd=77.985u as=58.1134p ps=77.985u w=76.465u l=1u
X421 DVDD GATE BAT DVDD pfet_06v0 ad=58.1096p pd=77.98u as=58.1096p ps=77.98u w=76.46u l=1u
X422 BAT GATE DVDD DVDD pfet_06v0 ad=58.1172p pd=77.99u as=58.1172p ps=77.99u w=76.47u l=1u
X423 DVDD GATE BAT DVDD pfet_06v0 ad=58.1096p pd=77.98u as=58.1096p ps=77.98u w=76.46u l=1u
X424 BAT GATE DVDD DVDD pfet_06v0 ad=49.3848p pd=66.5u as=61.0812p ps=0.13184m w=64.98u l=1u
X425 DVDD GATE BAT DVDD pfet_06v0 ad=43.9215p pd=95.32999u as=35.511p ps=48.245u w=46.725u l=1u
X426 BAT GATE DVDD DVDD pfet_06v0 ad=35.511p pd=48.245u as=35.511p ps=48.245u w=46.725u l=1u
X427 DVDD GATE BAT DVDD pfet_06v0 ad=58.1096p pd=77.98u as=58.1096p ps=77.98u w=76.46u l=1u
X428 DVDD GATE BAT DVDD pfet_06v0 ad=43.9215p pd=95.32999u as=35.511p ps=48.245u w=46.725u l=1u
X429 BAT GATE DVDD DVDD pfet_06v0 ad=35.511p pd=48.245u as=35.511p ps=48.245u w=46.725u l=1u
X430 BAT GATE DVDD DVDD pfet_06v0 ad=35.511p pd=48.245u as=35.511p ps=48.245u w=46.725u l=1u
X431 DVDD GATE BAT DVDD pfet_06v0 ad=35.511p pd=48.245u as=35.511p ps=48.245u w=46.725u l=1u
X432 DVDD GATE BAT DVDD pfet_06v0 ad=35.511p pd=48.245u as=35.511p ps=48.245u w=46.725u l=1u
X433 BAT GATE DVDD DVDD pfet_06v0 ad=58.1134p pd=77.985u as=58.1134p ps=77.985u w=76.465u l=1u
X434 DVDD GATE BAT DVDD pfet_06v0 ad=71.8771p pd=0.15481m as=58.1134p ps=77.985u w=76.465u l=1u
X435 BAT GATE DVDD DVDD pfet_06v0 ad=35.511p pd=48.245u as=35.511p ps=48.245u w=46.725u l=1u
X436 DVDD GATE BAT DVDD pfet_06v0 ad=43.9215p pd=95.32999u as=35.511p ps=48.245u w=46.725u l=1u
X437 BAT GATE DVDD DVDD pfet_06v0 ad=35.511p pd=48.245u as=43.9215p ps=95.32999u w=46.725u l=1u
X438 DVDD GATE BAT DVDD pfet_06v0 ad=58.1172p pd=77.99u as=58.1172p ps=77.99u w=76.47u l=1u
X439 BAT GATE DVDD DVDD pfet_06v0 ad=35.511p pd=48.245u as=35.511p ps=48.245u w=46.725u l=1u
X440 DVDD GATE BAT DVDD pfet_06v0 ad=58.0754p pd=77.935u as=58.0754p ps=77.935u w=76.41499u l=1u
X441 DVDD GATE BAT DVDD pfet_06v0 ad=58.1552p pd=78.04u as=58.1552p ps=78.04u w=76.52u l=1u
X442 DVDD GATE BAT DVDD pfet_06v0 ad=58.1172p pd=77.99u as=58.1172p ps=77.99u w=76.47u l=1u
X443 BAT GATE DVDD DVDD pfet_06v0 ad=35.511p pd=48.245u as=35.511p ps=48.245u w=46.725u l=1u
X444 DVDD GATE BAT DVDD pfet_06v0 ad=71.8301p pd=0.15471m as=58.0754p ps=77.935u w=76.41499u l=1u
X445 BAT GATE DVDD DVDD pfet_06v0 ad=35.511p pd=48.245u as=35.511p ps=48.245u w=46.725u l=1u
X446 BAT GATE DVDD DVDD pfet_06v0 ad=35.511p pd=48.245u as=35.511p ps=48.245u w=46.725u l=1u
X447 BAT GATE DVDD DVDD pfet_06v0 ad=47.6862p pd=64.265u as=47.6862p ps=64.265u w=62.745u l=1u
X448 DVDD GATE BAT DVDD pfet_06v0 ad=58.1134p pd=77.985u as=58.1134p ps=77.985u w=76.465u l=1u
X449 BAT GATE DVDD DVDD pfet_06v0 ad=58.1134p pd=77.985u as=58.1134p ps=77.985u w=76.465u l=1u
X450 DVDD GATE BAT DVDD pfet_06v0 ad=58.1134p pd=77.985u as=58.1134p ps=77.985u w=76.465u l=1u
X451 DVDD GATE BAT DVDD pfet_06v0 ad=35.511p pd=48.245u as=35.511p ps=48.245u w=46.725u l=1u
X452 DVDD GATE BAT DVDD pfet_06v0 ad=35.511p pd=48.245u as=35.511p ps=48.245u w=46.725u l=1u
X453 DVDD GATE BAT DVDD pfet_06v0 ad=58.1134p pd=77.985u as=58.1134p ps=77.985u w=76.465u l=1u
X454 BAT GATE DVDD DVDD pfet_06v0 ad=58.1096p pd=77.98u as=58.1096p ps=77.98u w=76.46u l=1u
X455 DVDD GATE BAT DVDD pfet_06v0 ad=71.8771p pd=0.15481m as=58.1134p ps=77.985u w=76.465u l=1u
X456 BAT GATE DVDD DVDD pfet_06v0 ad=35.511p pd=48.245u as=35.511p ps=48.245u w=46.725u l=1u
X457 BAT GATE DVDD DVDD pfet_06v0 ad=35.511p pd=48.245u as=43.9215p ps=95.32999u w=46.725u l=1u
X458 DVDD GATE BAT DVDD pfet_06v0 ad=71.8771p pd=0.15481m as=58.1134p ps=77.985u w=76.465u l=1u
X459 BAT GATE DVDD DVDD pfet_06v0 ad=58.0754p pd=77.935u as=58.0754p ps=77.935u w=76.41499u l=1u
X460 DVDD GATE BAT DVDD pfet_06v0 ad=58.1172p pd=77.99u as=58.1172p ps=77.99u w=76.47u l=1u
X461 DVDD GATE BAT DVDD pfet_06v0 ad=71.8771p pd=0.15481m as=58.1134p ps=77.985u w=76.465u l=1u
X462 BAT GATE DVDD DVDD pfet_06v0 ad=58.1172p pd=77.99u as=58.1172p ps=77.99u w=76.47u l=1u
X463 DVDD GATE BAT DVDD pfet_06v0 ad=35.511p pd=48.245u as=35.511p ps=48.245u w=46.725u l=1u
X464 DVDD GATE BAT DVDD pfet_06v0 ad=35.511p pd=48.245u as=35.511p ps=48.245u w=46.725u l=1u
X465 BAT GATE DVDD DVDD pfet_06v0 ad=58.1134p pd=77.985u as=58.1134p ps=77.985u w=76.465u l=1u
X466 BAT GATE DVDD DVDD pfet_06v0 ad=35.511p pd=48.245u as=35.511p ps=48.245u w=46.725u l=1u
X467 BAT GATE DVDD DVDD pfet_06v0 ad=35.511p pd=48.245u as=35.511p ps=48.245u w=46.725u l=1u
X468 DVDD GATE BAT DVDD pfet_06v0 ad=35.511p pd=48.245u as=35.511p ps=48.245u w=46.725u l=1u
X469 DVDD GATE BAT DVDD pfet_06v0 ad=58.1552p pd=78.04u as=58.1552p ps=78.04u w=76.52u l=1u
X470 BAT GATE DVDD DVDD pfet_06v0 ad=58.1134p pd=77.985u as=58.1134p ps=77.985u w=76.465u l=1u
X471 DVDD GATE BAT DVDD pfet_06v0 ad=58.1134p pd=77.985u as=58.1134p ps=77.985u w=76.465u l=1u
X472 BAT GATE DVDD DVDD pfet_06v0 ad=58.1134p pd=77.985u as=71.8771p ps=0.15481m w=76.465u l=1u
X473 BAT GATE DVDD DVDD pfet_06v0 ad=58.1134p pd=77.985u as=58.1134p ps=77.985u w=76.465u l=1u
X474 DVDD GATE BAT DVDD pfet_06v0 ad=35.511p pd=48.245u as=35.511p ps=48.245u w=46.725u l=1u
X475 DVDD GATE BAT DVDD pfet_06v0 ad=35.511p pd=48.245u as=35.511p ps=48.245u w=46.725u l=1u
X476 BAT GATE DVDD DVDD pfet_06v0 ad=58.1134p pd=77.985u as=58.1134p ps=77.985u w=76.465u l=1u
X477 BAT GATE DVDD DVDD pfet_06v0 ad=58.1134p pd=77.985u as=58.1134p ps=77.985u w=76.465u l=1u
X478 DVDD GATE BAT DVDD pfet_06v0 ad=71.8301p pd=0.15471m as=58.0754p ps=77.935u w=76.41499u l=1u
X479 BAT GATE DVDD DVDD pfet_06v0 ad=35.511p pd=48.245u as=35.511p ps=48.245u w=46.725u l=1u
X480 BAT GATE DVDD DVDD pfet_06v0 ad=58.1552p pd=78.04u as=58.1552p ps=78.04u w=76.52u l=1u
X481 BAT GATE DVDD DVDD pfet_06v0 ad=35.511p pd=48.245u as=35.511p ps=48.245u w=46.725u l=1u
X482 DVDD GATE BAT DVDD pfet_06v0 ad=58.1552p pd=78.04u as=58.1552p ps=78.04u w=76.52u l=1u
X483 BAT GATE DVDD DVDD pfet_06v0 ad=35.511p pd=48.245u as=35.511p ps=48.245u w=46.725u l=1u
X484 DVDD GATE BAT DVDD pfet_06v0 ad=35.5072p pd=48.24u as=35.5072p ps=48.24u w=46.72u l=1u
X485 BAT GATE DVDD DVDD pfet_06v0 ad=58.1096p pd=77.98u as=58.1096p ps=77.98u w=76.46u l=1u
X486 BAT GATE DVDD DVDD pfet_06v0 ad=58.1096p pd=77.98u as=58.1096p ps=77.98u w=76.46u l=1u
X487 DVDD GATE BAT DVDD pfet_06v0 ad=71.8771p pd=0.15481m as=58.1134p ps=77.985u w=76.465u l=1u
X488 BAT GATE DVDD DVDD pfet_06v0 ad=49.3848p pd=66.5u as=49.3848p ps=66.5u w=64.98u l=1u
X489 DVDD GATE BAT DVDD pfet_06v0 ad=49.3848p pd=66.5u as=49.3848p ps=66.5u w=64.98u l=1u
X490 BAT GATE DVDD DVDD pfet_06v0 ad=58.0754p pd=77.935u as=58.0754p ps=77.935u w=76.41499u l=1u
X491 BAT GATE DVDD DVDD pfet_06v0 ad=35.511p pd=48.245u as=35.511p ps=48.245u w=46.725u l=1u
X492 DVDD GATE BAT DVDD pfet_06v0 ad=58.1552p pd=78.04u as=58.1552p ps=78.04u w=76.52u l=1u
X493 DVDD GATE BAT DVDD pfet_06v0 ad=71.8724p pd=0.1548m as=58.1096p ps=77.98u w=76.46u l=1u
X494 DVDD GATE BAT DVDD pfet_06v0 ad=35.511p pd=48.245u as=35.511p ps=48.245u w=46.725u l=1u
X495 BAT GATE DVDD DVDD pfet_06v0 ad=35.511p pd=48.245u as=35.511p ps=48.245u w=46.725u l=1u
X496 BAT GATE DVDD DVDD pfet_06v0 ad=47.6862p pd=64.265u as=58.9803p ps=0.12737m w=62.745u l=1u
X497 DVDD GATE BAT DVDD pfet_06v0 ad=58.1134p pd=77.985u as=58.1134p ps=77.985u w=76.465u l=1u
X498 DVDD GATE BAT DVDD pfet_06v0 ad=35.511p pd=48.245u as=35.511p ps=48.245u w=46.725u l=1u
X499 DVDD GATE BAT DVDD pfet_06v0 ad=58.1134p pd=77.985u as=58.1134p ps=77.985u w=76.465u l=1u
X500 DVDD GATE BAT DVDD pfet_06v0 ad=35.511p pd=48.245u as=35.511p ps=48.245u w=46.725u l=1u
X501 DVDD GATE BAT DVDD pfet_06v0 ad=58.1134p pd=77.985u as=58.1134p ps=77.985u w=76.465u l=1u
X502 BAT GATE DVDD DVDD pfet_06v0 ad=58.1172p pd=77.99u as=58.1172p ps=77.99u w=76.47u l=1u
X503 DVDD GATE BAT DVDD pfet_06v0 ad=58.0754p pd=77.935u as=58.0754p ps=77.935u w=76.41499u l=1u
X504 BAT GATE DVDD DVDD pfet_06v0 ad=35.511p pd=48.245u as=35.511p ps=48.245u w=46.725u l=1u
X505 BAT GATE DVDD DVDD pfet_06v0 ad=58.0754p pd=77.935u as=58.0754p ps=77.935u w=76.41499u l=1u
X506 BAT GATE DVDD DVDD pfet_06v0 ad=58.1096p pd=77.98u as=71.8724p ps=0.1548m w=76.46u l=1u
X507 BAT GATE DVDD DVDD pfet_06v0 ad=35.511p pd=48.245u as=35.511p ps=48.245u w=46.725u l=1u
X508 DVDD GATE BAT DVDD pfet_06v0 ad=47.6862p pd=64.265u as=47.6862p ps=64.265u w=62.745u l=1u
X509 DVDD GATE BAT DVDD pfet_06v0 ad=58.1134p pd=77.985u as=58.1134p ps=77.985u w=76.465u l=1u
X510 BAT GATE DVDD DVDD pfet_06v0 ad=35.511p pd=48.245u as=35.511p ps=48.245u w=46.725u l=1u
X511 DVDD GATE BAT DVDD pfet_06v0 ad=35.5072p pd=48.24u as=35.5072p ps=48.24u w=46.72u l=1u
X512 BAT GATE DVDD DVDD pfet_06v0 ad=58.1172p pd=77.99u as=58.1172p ps=77.99u w=76.47u l=1u
X513 BAT GATE DVDD DVDD pfet_06v0 ad=35.511p pd=48.245u as=35.511p ps=48.245u w=46.725u l=1u
X514 DVDD GATE BAT DVDD pfet_06v0 ad=58.1134p pd=77.985u as=58.1134p ps=77.985u w=76.465u l=1u
X515 BAT GATE DVDD DVDD pfet_06v0 ad=58.1172p pd=77.99u as=58.1172p ps=77.99u w=76.47u l=1u
X516 DVDD GATE BAT DVDD pfet_06v0 ad=49.3848p pd=66.5u as=49.3848p ps=66.5u w=64.98u l=1u
X517 DVDD GATE BAT DVDD pfet_06v0 ad=35.5072p pd=48.24u as=35.5072p ps=48.24u w=46.72u l=1u
X518 DVDD GATE BAT DVDD pfet_06v0 ad=35.511p pd=48.245u as=35.511p ps=48.245u w=46.725u l=1u
X519 BAT GATE DVDD DVDD pfet_06v0 ad=58.1134p pd=77.985u as=71.8771p ps=0.15481m w=76.465u l=1u
X520 BAT GATE DVDD DVDD pfet_06v0 ad=35.511p pd=48.245u as=35.511p ps=48.245u w=46.725u l=1u
X521 DVDD GATE BAT DVDD pfet_06v0 ad=58.1134p pd=77.985u as=58.1134p ps=77.985u w=76.465u l=1u
X522 DVDD GATE BAT DVDD pfet_06v0 ad=35.511p pd=48.245u as=35.511p ps=48.245u w=46.725u l=1u
X523 BAT GATE DVDD DVDD pfet_06v0 ad=58.1096p pd=77.98u as=71.8724p ps=0.1548m w=76.46u l=1u
X524 DVDD GATE BAT DVDD pfet_06v0 ad=58.0754p pd=77.935u as=58.0754p ps=77.935u w=76.41499u l=1u
X525 DVDD GATE BAT DVDD pfet_06v0 ad=47.6862p pd=64.265u as=47.6862p ps=64.265u w=62.745u l=1u
X526 BAT GATE DVDD DVDD pfet_06v0 ad=35.511p pd=48.245u as=35.511p ps=48.245u w=46.725u l=1u
X527 DVDD GATE BAT DVDD pfet_06v0 ad=61.0812p pd=0.13184m as=49.3848p ps=66.5u w=64.98u l=1u
X528 DVDD GATE BAT DVDD pfet_06v0 ad=71.8818p pd=0.15482m as=58.1172p ps=77.99u w=76.47u l=1u
X529 DVDD GATE BAT DVDD pfet_06v0 ad=43.9215p pd=95.32999u as=35.511p ps=48.245u w=46.725u l=1u
X530 BAT GATE DVDD DVDD pfet_06v0 ad=58.1134p pd=77.985u as=58.1134p ps=77.985u w=76.465u l=1u
X531 DVDD GATE BAT DVDD pfet_06v0 ad=35.5072p pd=48.24u as=35.5072p ps=48.24u w=46.72u l=1u
X532 DVDD GATE BAT DVDD pfet_06v0 ad=58.1134p pd=77.985u as=58.1134p ps=77.985u w=76.465u l=1u
X533 BAT GATE DVDD DVDD pfet_06v0 ad=35.511p pd=48.245u as=35.511p ps=48.245u w=46.725u l=1u
X534 DVDD GATE BAT DVDD pfet_06v0 ad=35.511p pd=48.245u as=35.511p ps=48.245u w=46.725u l=1u
X535 DVDD GATE BAT DVDD pfet_06v0 ad=47.6862p pd=64.265u as=47.6862p ps=64.265u w=62.745u l=1u
X536 DVDD GATE BAT DVDD pfet_06v0 ad=43.9215p pd=95.32999u as=35.511p ps=48.245u w=46.725u l=1u
X537 DVDD GATE BAT DVDD pfet_06v0 ad=58.1134p pd=77.985u as=58.1134p ps=77.985u w=76.465u l=1u
X538 DVDD GATE BAT DVDD pfet_06v0 ad=35.511p pd=48.245u as=35.511p ps=48.245u w=46.725u l=1u
X539 DVDD GATE BAT DVDD pfet_06v0 ad=35.511p pd=48.245u as=35.511p ps=48.245u w=46.725u l=1u
X540 DVDD GATE BAT DVDD pfet_06v0 ad=71.8771p pd=0.15481m as=58.1134p ps=77.985u w=76.465u l=1u
X541 BAT GATE DVDD DVDD pfet_06v0 ad=58.1172p pd=77.99u as=71.8818p ps=0.15482m w=76.47u l=1u
X542 DVDD GATE BAT DVDD pfet_06v0 ad=35.511p pd=48.245u as=35.511p ps=48.245u w=46.725u l=1u
X543 BAT GATE DVDD DVDD pfet_06v0 ad=58.1552p pd=78.04u as=58.1552p ps=78.04u w=76.52u l=1u
X544 BAT GATE DVDD DVDD pfet_06v0 ad=35.511p pd=48.245u as=43.9215p ps=95.32999u w=46.725u l=1u
X545 DVDD GATE BAT DVDD pfet_06v0 ad=71.8771p pd=0.15481m as=58.1134p ps=77.985u w=76.465u l=1u
X546 DVDD GATE BAT DVDD pfet_06v0 ad=58.1134p pd=77.985u as=58.1134p ps=77.985u w=76.465u l=1u
X547 DVDD GATE BAT DVDD pfet_06v0 ad=58.1134p pd=77.985u as=58.1134p ps=77.985u w=76.465u l=1u
X548 DVDD GATE BAT DVDD pfet_06v0 ad=47.6862p pd=64.265u as=47.6862p ps=64.265u w=62.745u l=1u
X549 BAT GATE DVDD DVDD pfet_06v0 ad=58.1552p pd=78.04u as=58.1552p ps=78.04u w=76.52u l=1u
X550 BAT GATE DVDD DVDD pfet_06v0 ad=58.1172p pd=77.99u as=58.1172p ps=77.99u w=76.47u l=1u
X551 DVDD GATE BAT DVDD pfet_06v0 ad=35.511p pd=48.245u as=35.511p ps=48.245u w=46.725u l=1u
X552 BAT GATE DVDD DVDD pfet_06v0 ad=35.511p pd=48.245u as=35.511p ps=48.245u w=46.725u l=1u
X553 DVDD GATE BAT DVDD pfet_06v0 ad=58.1172p pd=77.99u as=58.1172p ps=77.99u w=76.47u l=1u
X554 DVDD GATE BAT DVDD pfet_06v0 ad=58.1096p pd=77.98u as=58.1096p ps=77.98u w=76.46u l=1u
X555 DVDD GATE BAT DVDD pfet_06v0 ad=35.511p pd=48.245u as=35.511p ps=48.245u w=46.725u l=1u
X556 BAT GATE DVDD DVDD pfet_06v0 ad=58.1134p pd=77.985u as=58.1134p ps=77.985u w=76.465u l=1u
X557 BAT GATE DVDD DVDD pfet_06v0 ad=58.1134p pd=77.985u as=71.8771p ps=0.15481m w=76.465u l=1u
X558 BAT GATE DVDD DVDD pfet_06v0 ad=58.1134p pd=77.985u as=58.1134p ps=77.985u w=76.465u l=1u
X559 DVDD GATE BAT DVDD pfet_06v0 ad=35.511p pd=48.245u as=35.511p ps=48.245u w=46.725u l=1u
X560 DVDD GATE BAT DVDD pfet_06v0 ad=58.1134p pd=77.985u as=58.1134p ps=77.985u w=76.465u l=1u
X561 DVDD GATE BAT DVDD pfet_06v0 ad=35.511p pd=48.245u as=35.511p ps=48.245u w=46.725u l=1u
X562 DVDD GATE BAT DVDD pfet_06v0 ad=58.1134p pd=77.985u as=58.1134p ps=77.985u w=76.465u l=1u
X563 BAT GATE DVDD DVDD pfet_06v0 ad=58.1134p pd=77.985u as=58.1134p ps=77.985u w=76.465u l=1u
X564 DVDD GATE BAT DVDD pfet_06v0 ad=58.0754p pd=77.935u as=58.0754p ps=77.935u w=76.41499u l=1u
X565 DVDD GATE BAT DVDD pfet_06v0 ad=47.6862p pd=64.265u as=47.6862p ps=64.265u w=62.745u l=1u
X566 DVDD GATE BAT DVDD pfet_06v0 ad=61.0812p pd=0.13184m as=49.3848p ps=66.5u w=64.98u l=1u
X567 BAT GATE DVDD DVDD pfet_06v0 ad=58.1134p pd=77.985u as=58.1134p ps=77.985u w=76.465u l=1u
X568 DVDD GATE BAT DVDD pfet_06v0 ad=35.511p pd=48.245u as=35.511p ps=48.245u w=46.725u l=1u
X569 DVDD GATE BAT DVDD pfet_06v0 ad=58.1134p pd=77.985u as=58.1134p ps=77.985u w=76.465u l=1u
X570 DVDD GATE BAT DVDD pfet_06v0 ad=58.1134p pd=77.985u as=58.1134p ps=77.985u w=76.465u l=1u
X571 BAT GATE DVDD DVDD pfet_06v0 ad=35.511p pd=48.245u as=43.9215p ps=95.32999u w=46.725u l=1u
X572 DVDD GATE BAT DVDD pfet_06v0 ad=58.1134p pd=77.985u as=58.1134p ps=77.985u w=76.465u l=1u
X573 BAT GATE DVDD DVDD pfet_06v0 ad=35.511p pd=48.245u as=43.9215p ps=95.32999u w=46.725u l=1u
X574 BAT GATE DVDD DVDD pfet_06v0 ad=58.1552p pd=78.04u as=58.1552p ps=78.04u w=76.52u l=1u
X575 DVDD GATE BAT DVDD pfet_06v0 ad=58.1134p pd=77.985u as=58.1134p ps=77.985u w=76.465u l=1u
X576 BAT GATE DVDD DVDD pfet_06v0 ad=58.1096p pd=77.98u as=58.1096p ps=77.98u w=76.46u l=1u
X577 DVDD GATE BAT DVDD pfet_06v0 ad=58.1134p pd=77.985u as=58.1134p ps=77.985u w=76.465u l=1u
X578 BAT GATE DVDD DVDD pfet_06v0 ad=35.511p pd=48.245u as=35.511p ps=48.245u w=46.725u l=1u
X579 DVDD GATE BAT DVDD pfet_06v0 ad=58.1134p pd=77.985u as=58.1134p ps=77.985u w=76.465u l=1u
X580 BAT GATE DVDD DVDD pfet_06v0 ad=35.511p pd=48.245u as=35.511p ps=48.245u w=46.725u l=1u
X581 BAT GATE DVDD DVDD pfet_06v0 ad=35.511p pd=48.245u as=35.511p ps=48.245u w=46.725u l=1u
X582 BAT GATE DVDD DVDD pfet_06v0 ad=35.511p pd=48.245u as=35.511p ps=48.245u w=46.725u l=1u
X583 BAT GATE DVDD DVDD pfet_06v0 ad=35.511p pd=48.245u as=35.511p ps=48.245u w=46.725u l=1u
X584 DVDD GATE BAT DVDD pfet_06v0 ad=35.511p pd=48.245u as=35.511p ps=48.245u w=46.725u l=1u
X585 BAT GATE DVDD DVDD pfet_06v0 ad=58.0754p pd=77.935u as=58.0754p ps=77.935u w=76.41499u l=1u
X586 DVDD GATE BAT DVDD pfet_06v0 ad=35.511p pd=48.245u as=35.511p ps=48.245u w=46.725u l=1u
X587 DVDD GATE BAT DVDD pfet_06v0 ad=35.511p pd=48.245u as=35.511p ps=48.245u w=46.725u l=1u
X588 DVDD GATE BAT DVDD pfet_06v0 ad=35.511p pd=48.245u as=35.511p ps=48.245u w=46.725u l=1u
X589 BAT GATE DVDD DVDD pfet_06v0 ad=58.1172p pd=77.99u as=71.8818p ps=0.15482m w=76.47u l=1u
X590 BAT GATE DVDD DVDD pfet_06v0 ad=35.5072p pd=48.24u as=35.5072p ps=48.24u w=46.72u l=1u
X591 BAT GATE DVDD DVDD pfet_06v0 ad=58.1552p pd=78.04u as=71.92879p ps=0.15492m w=76.52u l=1u
X592 BAT GATE DVDD DVDD pfet_06v0 ad=35.5072p pd=48.24u as=43.9168p ps=95.32u w=46.72u l=1u
X593 DVDD GATE BAT DVDD pfet_06v0 ad=58.1134p pd=77.985u as=58.1134p ps=77.985u w=76.465u l=1u
X594 BAT GATE DVDD DVDD pfet_06v0 ad=35.511p pd=48.245u as=35.511p ps=48.245u w=46.725u l=1u
X595 BAT GATE DVDD DVDD pfet_06v0 ad=58.1134p pd=77.985u as=58.1134p ps=77.985u w=76.465u l=1u
X596 BAT GATE DVDD DVDD pfet_06v0 ad=49.3848p pd=66.5u as=49.3848p ps=66.5u w=64.98u l=1u
X597 DVDD GATE BAT DVDD pfet_06v0 ad=58.0754p pd=77.935u as=58.0754p ps=77.935u w=76.41499u l=1u
X598 DVDD GATE BAT DVDD pfet_06v0 ad=49.3848p pd=66.5u as=49.3848p ps=66.5u w=64.98u l=1u
X599 DVDD GATE BAT DVDD pfet_06v0 ad=35.511p pd=48.245u as=35.511p ps=48.245u w=46.725u l=1u
X600 BAT GATE DVDD DVDD pfet_06v0 ad=47.6862p pd=64.265u as=47.6862p ps=64.265u w=62.745u l=1u
X601 DVDD GATE BAT DVDD pfet_06v0 ad=35.511p pd=48.245u as=35.511p ps=48.245u w=46.725u l=1u
X602 BAT GATE DVDD DVDD pfet_06v0 ad=58.1134p pd=77.985u as=58.1134p ps=77.985u w=76.465u l=1u
X603 DVDD GATE BAT DVDD pfet_06v0 ad=58.1134p pd=77.985u as=58.1134p ps=77.985u w=76.465u l=1u
X604 DVDD GATE BAT DVDD pfet_06v0 ad=58.0754p pd=77.935u as=58.0754p ps=77.935u w=76.41499u l=1u
X605 DVDD GATE BAT DVDD pfet_06v0 ad=49.3848p pd=66.5u as=49.3848p ps=66.5u w=64.98u l=1u
X606 DVDD GATE BAT DVDD pfet_06v0 ad=35.511p pd=48.245u as=35.511p ps=48.245u w=46.725u l=1u
X607 BAT GATE DVDD DVDD pfet_06v0 ad=58.1134p pd=77.985u as=58.1134p ps=77.985u w=76.465u l=1u
X608 BAT GATE DVDD DVDD pfet_06v0 ad=58.1096p pd=77.98u as=58.1096p ps=77.98u w=76.46u l=1u
X609 BAT GATE DVDD DVDD pfet_06v0 ad=58.1134p pd=77.985u as=71.8771p ps=0.15481m w=76.465u l=1u
X610 DVDD GATE BAT DVDD pfet_06v0 ad=43.9168p pd=95.32u as=35.5072p ps=48.24u w=46.72u l=1u
X611 BAT GATE DVDD DVDD pfet_06v0 ad=58.1134p pd=77.985u as=58.1134p ps=77.985u w=76.465u l=1u
X612 BAT GATE DVDD DVDD pfet_06v0 ad=35.511p pd=48.245u as=35.511p ps=48.245u w=46.725u l=1u
X613 DVDD GATE BAT DVDD pfet_06v0 ad=58.1172p pd=77.99u as=58.1172p ps=77.99u w=76.47u l=1u
X614 BAT GATE DVDD DVDD pfet_06v0 ad=58.1134p pd=77.985u as=58.1134p ps=77.985u w=76.465u l=1u
X615 DVDD GATE BAT DVDD pfet_06v0 ad=58.1172p pd=77.99u as=58.1172p ps=77.99u w=76.47u l=1u
X616 DVDD GATE BAT DVDD pfet_06v0 ad=58.1134p pd=77.985u as=58.1134p ps=77.985u w=76.465u l=1u
X617 DVDD GATE BAT DVDD pfet_06v0 ad=58.0754p pd=77.935u as=58.0754p ps=77.935u w=76.41499u l=1u
X618 DVDD GATE BAT DVDD pfet_06v0 ad=35.511p pd=48.245u as=35.511p ps=48.245u w=46.725u l=1u
X619 BAT GATE DVDD DVDD pfet_06v0 ad=35.5072p pd=48.24u as=35.5072p ps=48.24u w=46.72u l=1u
X620 BAT GATE DVDD DVDD pfet_06v0 ad=47.6862p pd=64.265u as=47.6862p ps=64.265u w=62.745u l=1u
X621 BAT GATE DVDD DVDD pfet_06v0 ad=58.1134p pd=77.985u as=58.1134p ps=77.985u w=76.465u l=1u
X622 BAT GATE DVDD DVDD pfet_06v0 ad=35.5072p pd=48.24u as=43.9168p ps=95.32u w=46.72u l=1u
X623 DVDD GATE BAT DVDD pfet_06v0 ad=58.1134p pd=77.985u as=58.1134p ps=77.985u w=76.465u l=1u
X624 BAT GATE DVDD DVDD pfet_06v0 ad=35.511p pd=48.245u as=35.511p ps=48.245u w=46.725u l=1u
X625 BAT GATE DVDD DVDD pfet_06v0 ad=35.5072p pd=48.24u as=35.5072p ps=48.24u w=46.72u l=1u
X626 DVDD GATE BAT DVDD pfet_06v0 ad=58.1134p pd=77.985u as=58.1134p ps=77.985u w=76.465u l=1u
X627 BAT GATE DVDD DVDD pfet_06v0 ad=35.5072p pd=48.24u as=35.5072p ps=48.24u w=46.72u l=1u
X628 BAT GATE DVDD DVDD pfet_06v0 ad=35.511p pd=48.245u as=43.9215p ps=95.32999u w=46.725u l=1u
X629 BAT GATE DVDD DVDD pfet_06v0 ad=58.1134p pd=77.985u as=58.1134p ps=77.985u w=76.465u l=1u
X630 DVDD GATE BAT DVDD pfet_06v0 ad=35.511p pd=48.245u as=35.511p ps=48.245u w=46.725u l=1u
X631 DVDD GATE BAT DVDD pfet_06v0 ad=35.511p pd=48.245u as=35.511p ps=48.245u w=46.725u l=1u
X632 DVDD GATE BAT DVDD pfet_06v0 ad=58.1134p pd=77.985u as=58.1134p ps=77.985u w=76.465u l=1u
X633 DVDD GATE BAT DVDD pfet_06v0 ad=35.5072p pd=48.24u as=35.5072p ps=48.24u w=46.72u l=1u
X634 DVDD GATE BAT DVDD pfet_06v0 ad=58.1134p pd=77.985u as=58.1134p ps=77.985u w=76.465u l=1u
X635 BAT GATE DVDD DVDD pfet_06v0 ad=35.511p pd=48.245u as=35.511p ps=48.245u w=46.725u l=1u
X636 DVDD GATE BAT DVDD pfet_06v0 ad=71.8771p pd=0.15481m as=58.1134p ps=77.985u w=76.465u l=1u
X637 BAT GATE DVDD DVDD pfet_06v0 ad=58.1134p pd=77.985u as=71.8771p ps=0.15481m w=76.465u l=1u
X638 DVDD GATE BAT DVDD pfet_06v0 ad=71.92879p pd=0.15492m as=58.1552p ps=78.04u w=76.52u l=1u
X639 BAT GATE DVDD DVDD pfet_06v0 ad=58.1134p pd=77.985u as=71.8771p ps=0.15481m w=76.465u l=1u
X640 BAT GATE DVDD DVDD pfet_06v0 ad=35.511p pd=48.245u as=35.511p ps=48.245u w=46.725u l=1u
X641 BAT GATE DVDD DVDD pfet_06v0 ad=58.1134p pd=77.985u as=71.8771p ps=0.15481m w=76.465u l=1u
X642 BAT GATE DVDD DVDD pfet_06v0 ad=47.6862p pd=64.265u as=47.6862p ps=64.265u w=62.745u l=1u
X643 BAT GATE DVDD DVDD pfet_06v0 ad=58.1134p pd=77.985u as=58.1134p ps=77.985u w=76.465u l=1u
X644 BAT GATE DVDD DVDD pfet_06v0 ad=58.1552p pd=78.04u as=58.1552p ps=78.04u w=76.52u l=1u
X645 BAT GATE DVDD DVDD pfet_06v0 ad=35.511p pd=48.245u as=43.9215p ps=95.32999u w=46.725u l=1u
X646 DVDD GATE BAT DVDD pfet_06v0 ad=35.511p pd=48.245u as=35.511p ps=48.245u w=46.725u l=1u
X647 BAT GATE DVDD DVDD pfet_06v0 ad=58.1134p pd=77.985u as=58.1134p ps=77.985u w=76.465u l=1u
X648 BAT GATE DVDD DVDD pfet_06v0 ad=35.511p pd=48.245u as=35.511p ps=48.245u w=46.725u l=1u
X649 BAT GATE DVDD DVDD pfet_06v0 ad=35.511p pd=48.245u as=35.511p ps=48.245u w=46.725u l=1u
X650 DVDD GATE BAT DVDD pfet_06v0 ad=58.1134p pd=77.985u as=58.1134p ps=77.985u w=76.465u l=1u
X651 DVDD GATE BAT DVDD pfet_06v0 ad=35.511p pd=48.245u as=35.511p ps=48.245u w=46.725u l=1u
X652 DVDD GATE BAT DVDD pfet_06v0 ad=58.1552p pd=78.04u as=58.1552p ps=78.04u w=76.52u l=1u
X653 DVDD GATE BAT DVDD pfet_06v0 ad=58.1172p pd=77.99u as=58.1172p ps=77.99u w=76.47u l=1u
X654 BAT GATE DVDD DVDD pfet_06v0 ad=35.511p pd=48.245u as=35.511p ps=48.245u w=46.725u l=1u
X655 BAT GATE DVDD DVDD pfet_06v0 ad=35.511p pd=48.245u as=35.511p ps=48.245u w=46.725u l=1u
X656 BAT GATE DVDD DVDD pfet_06v0 ad=58.1134p pd=77.985u as=71.8771p ps=0.15481m w=76.465u l=1u
X657 BAT GATE DVDD DVDD pfet_06v0 ad=49.3848p pd=66.5u as=49.3848p ps=66.5u w=64.98u l=1u
X658 DVDD GATE BAT DVDD pfet_06v0 ad=58.1134p pd=77.985u as=58.1134p ps=77.985u w=76.465u l=1u
X659 BAT GATE DVDD DVDD pfet_06v0 ad=58.0754p pd=77.935u as=58.0754p ps=77.935u w=76.41499u l=1u
X660 BAT GATE DVDD DVDD pfet_06v0 ad=35.511p pd=48.245u as=35.511p ps=48.245u w=46.725u l=1u
X661 BAT GATE DVDD DVDD pfet_06v0 ad=35.511p pd=48.245u as=43.9215p ps=95.32999u w=46.725u l=1u
X662 BAT GATE DVDD DVDD pfet_06v0 ad=58.1134p pd=77.985u as=58.1134p ps=77.985u w=76.465u l=1u
X663 BAT GATE DVDD DVDD pfet_06v0 ad=47.6862p pd=64.265u as=47.6862p ps=64.265u w=62.745u l=1u
X664 BAT GATE DVDD DVDD pfet_06v0 ad=35.511p pd=48.245u as=43.9215p ps=95.32999u w=46.725u l=1u
X665 DVDD GATE BAT DVDD pfet_06v0 ad=35.511p pd=48.245u as=35.511p ps=48.245u w=46.725u l=1u
X666 DVDD GATE BAT DVDD pfet_06v0 ad=58.1134p pd=77.985u as=58.1134p ps=77.985u w=76.465u l=1u
X667 BAT GATE DVDD DVDD pfet_06v0 ad=58.1134p pd=77.985u as=71.8771p ps=0.15481m w=76.465u l=1u
X668 BAT GATE DVDD DVDD pfet_06v0 ad=35.511p pd=48.245u as=43.9215p ps=95.32999u w=46.725u l=1u
X669 DVDD GATE BAT DVDD pfet_06v0 ad=58.1096p pd=77.98u as=58.1096p ps=77.98u w=76.46u l=1u
X670 DVDD GATE BAT DVDD pfet_06v0 ad=35.511p pd=48.245u as=35.511p ps=48.245u w=46.725u l=1u
X671 BAT GATE DVDD DVDD pfet_06v0 ad=47.6862p pd=64.265u as=47.6862p ps=64.265u w=62.745u l=1u
X672 BAT GATE DVDD DVDD pfet_06v0 ad=35.511p pd=48.245u as=35.511p ps=48.245u w=46.725u l=1u
X673 DVDD GATE BAT DVDD pfet_06v0 ad=35.511p pd=48.245u as=35.511p ps=48.245u w=46.725u l=1u
X674 DVDD GATE BAT DVDD pfet_06v0 ad=58.1096p pd=77.98u as=58.1096p ps=77.98u w=76.46u l=1u
X675 DVDD GATE BAT DVDD pfet_06v0 ad=35.511p pd=48.245u as=35.511p ps=48.245u w=46.725u l=1u
X676 DVDD GATE BAT DVDD pfet_06v0 ad=58.1134p pd=77.985u as=58.1134p ps=77.985u w=76.465u l=1u
X677 DVDD GATE BAT DVDD pfet_06v0 ad=35.511p pd=48.245u as=35.511p ps=48.245u w=46.725u l=1u
X678 BAT GATE DVDD DVDD pfet_06v0 ad=35.511p pd=48.245u as=35.511p ps=48.245u w=46.725u l=1u
X679 BAT GATE DVDD DVDD pfet_06v0 ad=58.1172p pd=77.99u as=58.1172p ps=77.99u w=76.47u l=1u
X680 BAT GATE DVDD DVDD pfet_06v0 ad=58.1134p pd=77.985u as=58.1134p ps=77.985u w=76.465u l=1u
X681 BAT GATE DVDD DVDD pfet_06v0 ad=35.511p pd=48.245u as=35.511p ps=48.245u w=46.725u l=1u
X682 DVDD GATE BAT DVDD pfet_06v0 ad=35.5072p pd=48.24u as=35.5072p ps=48.24u w=46.72u l=1u
X683 BAT GATE DVDD DVDD pfet_06v0 ad=35.511p pd=48.245u as=43.9215p ps=95.32999u w=46.725u l=1u
X684 DVDD GATE BAT DVDD pfet_06v0 ad=35.511p pd=48.245u as=35.511p ps=48.245u w=46.725u l=1u
X685 DVDD GATE BAT DVDD pfet_06v0 ad=35.5072p pd=48.24u as=35.5072p ps=48.24u w=46.72u l=1u
X686 BAT GATE DVDD DVDD pfet_06v0 ad=35.511p pd=48.245u as=35.511p ps=48.245u w=46.725u l=1u
X687 BAT GATE DVDD DVDD pfet_06v0 ad=49.3848p pd=66.5u as=49.3848p ps=66.5u w=64.98u l=1u
X688 BAT GATE DVDD DVDD pfet_06v0 ad=35.511p pd=48.245u as=43.9215p ps=95.32999u w=46.725u l=1u
X689 DVDD GATE BAT DVDD pfet_06v0 ad=35.5072p pd=48.24u as=35.5072p ps=48.24u w=46.72u l=1u
X690 BAT GATE DVDD DVDD pfet_06v0 ad=58.1134p pd=77.985u as=58.1134p ps=77.985u w=76.465u l=1u
X691 DVDD GATE BAT DVDD pfet_06v0 ad=61.0812p pd=0.13184m as=49.3848p ps=66.5u w=64.98u l=1u
X692 BAT GATE DVDD DVDD pfet_06v0 ad=35.511p pd=48.245u as=35.511p ps=48.245u w=46.725u l=1u
X693 DVDD GATE BAT DVDD pfet_06v0 ad=35.511p pd=48.245u as=35.511p ps=48.245u w=46.725u l=1u
X694 BAT GATE DVDD DVDD pfet_06v0 ad=35.511p pd=48.245u as=35.511p ps=48.245u w=46.725u l=1u
X695 DVDD GATE BAT DVDD pfet_06v0 ad=58.1134p pd=77.985u as=58.1134p ps=77.985u w=76.465u l=1u
X696 BAT GATE DVDD DVDD pfet_06v0 ad=35.511p pd=48.245u as=35.511p ps=48.245u w=46.725u l=1u
X697 BAT GATE DVDD DVDD pfet_06v0 ad=35.511p pd=48.245u as=43.9215p ps=95.32999u w=46.725u l=1u
X698 BAT GATE DVDD DVDD pfet_06v0 ad=35.511p pd=48.245u as=35.511p ps=48.245u w=46.725u l=1u
X699 BAT GATE DVDD DVDD pfet_06v0 ad=58.0754p pd=77.935u as=58.0754p ps=77.935u w=76.41499u l=1u
X700 DVDD GATE BAT DVDD pfet_06v0 ad=58.1134p pd=77.985u as=58.1134p ps=77.985u w=76.465u l=1u
X701 DVDD GATE BAT DVDD pfet_06v0 ad=71.8771p pd=0.15481m as=58.1134p ps=77.985u w=76.465u l=1u
X702 DVDD GATE BAT DVDD pfet_06v0 ad=58.1134p pd=77.985u as=58.1134p ps=77.985u w=76.465u l=1u
X703 DVDD GATE BAT DVDD pfet_06v0 ad=58.1134p pd=77.985u as=58.1134p ps=77.985u w=76.465u l=1u
X704 DVDD GATE BAT DVDD pfet_06v0 ad=47.6862p pd=64.265u as=47.6862p ps=64.265u w=62.745u l=1u
X705 DVDD GATE BAT DVDD pfet_06v0 ad=35.511p pd=48.245u as=35.511p ps=48.245u w=46.725u l=1u
X706 DVDD GATE BAT DVDD pfet_06v0 ad=58.9803p pd=0.12737m as=47.6862p ps=64.265u w=62.745u l=1u
X707 DVDD GATE BAT DVDD pfet_06v0 ad=58.1096p pd=77.98u as=58.1096p ps=77.98u w=76.46u l=1u
X708 DVDD GATE BAT DVDD pfet_06v0 ad=43.9215p pd=95.32999u as=35.511p ps=48.245u w=46.725u l=1u
X709 DVDD GATE BAT DVDD pfet_06v0 ad=58.1096p pd=77.98u as=58.1096p ps=77.98u w=76.46u l=1u
X710 BAT GATE DVDD DVDD pfet_06v0 ad=58.1134p pd=77.985u as=58.1134p ps=77.985u w=76.465u l=1u
X711 BAT GATE DVDD DVDD pfet_06v0 ad=58.1172p pd=77.99u as=71.8818p ps=0.15482m w=76.47u l=1u
X712 BAT GATE DVDD DVDD pfet_06v0 ad=58.1134p pd=77.985u as=58.1134p ps=77.985u w=76.465u l=1u
X713 DVDD GATE BAT DVDD pfet_06v0 ad=71.8771p pd=0.15481m as=58.1134p ps=77.985u w=76.465u l=1u
X714 BAT GATE DVDD DVDD pfet_06v0 ad=58.1552p pd=78.04u as=71.92879p ps=0.15492m w=76.52u l=1u
X715 DVDD GATE BAT DVDD pfet_06v0 ad=35.511p pd=48.245u as=35.511p ps=48.245u w=46.725u l=1u
X716 DVDD GATE BAT DVDD pfet_06v0 ad=58.1552p pd=78.04u as=58.1552p ps=78.04u w=76.52u l=1u
X717 BAT GATE DVDD DVDD pfet_06v0 ad=35.511p pd=48.245u as=35.511p ps=48.245u w=46.725u l=1u
X718 DVDD GATE BAT DVDD pfet_06v0 ad=58.1134p pd=77.985u as=58.1134p ps=77.985u w=76.465u l=1u
X719 BAT GATE DVDD DVDD pfet_06v0 ad=58.1134p pd=77.985u as=71.8771p ps=0.15481m w=76.465u l=1u
X720 DVDD GATE BAT DVDD pfet_06v0 ad=58.1096p pd=77.98u as=58.1096p ps=77.98u w=76.46u l=1u
X721 DVDD GATE BAT DVDD pfet_06v0 ad=35.5072p pd=48.24u as=35.5072p ps=48.24u w=46.72u l=1u
X722 DVDD GATE BAT DVDD pfet_06v0 ad=58.1134p pd=77.985u as=58.1134p ps=77.985u w=76.465u l=1u
X723 DVDD GATE BAT DVDD pfet_06v0 ad=58.1134p pd=77.985u as=58.1134p ps=77.985u w=76.465u l=1u
X724 BAT GATE DVDD DVDD pfet_06v0 ad=35.511p pd=48.245u as=35.511p ps=48.245u w=46.725u l=1u
X725 BAT GATE DVDD DVDD pfet_06v0 ad=58.0754p pd=77.935u as=58.0754p ps=77.935u w=76.41499u l=1u
X726 DVDD GATE BAT DVDD pfet_06v0 ad=71.8771p pd=0.15481m as=58.1134p ps=77.985u w=76.465u l=1u
X727 DVDD GATE BAT DVDD pfet_06v0 ad=35.511p pd=48.245u as=35.511p ps=48.245u w=46.725u l=1u
X728 DVDD GATE BAT DVDD pfet_06v0 ad=35.511p pd=48.245u as=35.511p ps=48.245u w=46.725u l=1u
X729 BAT GATE DVDD DVDD pfet_06v0 ad=58.1134p pd=77.985u as=58.1134p ps=77.985u w=76.465u l=1u
X730 DVDD GATE BAT DVDD pfet_06v0 ad=58.1172p pd=77.99u as=58.1172p ps=77.99u w=76.47u l=1u
X731 BAT GATE DVDD DVDD pfet_06v0 ad=58.1134p pd=77.985u as=58.1134p ps=77.985u w=76.465u l=1u
X732 DVDD GATE BAT DVDD pfet_06v0 ad=58.1172p pd=77.99u as=58.1172p ps=77.99u w=76.47u l=1u
X733 DVDD GATE BAT DVDD pfet_06v0 ad=58.1134p pd=77.985u as=58.1134p ps=77.985u w=76.465u l=1u
X734 DVDD GATE BAT DVDD pfet_06v0 ad=71.8771p pd=0.15481m as=58.1134p ps=77.985u w=76.465u l=1u
X735 BAT GATE DVDD DVDD pfet_06v0 ad=35.511p pd=48.245u as=35.511p ps=48.245u w=46.725u l=1u
X736 DVDD GATE BAT DVDD pfet_06v0 ad=35.511p pd=48.245u as=35.511p ps=48.245u w=46.725u l=1u
X737 BAT GATE DVDD DVDD pfet_06v0 ad=58.1134p pd=77.985u as=58.1134p ps=77.985u w=76.465u l=1u
X738 BAT GATE DVDD DVDD pfet_06v0 ad=49.3848p pd=66.5u as=61.0812p ps=0.13184m w=64.98u l=1u
X739 DVDD GATE BAT DVDD pfet_06v0 ad=58.1134p pd=77.985u as=58.1134p ps=77.985u w=76.465u l=1u
X740 DVDD GATE BAT DVDD pfet_06v0 ad=71.8301p pd=0.15471m as=58.0754p ps=77.935u w=76.41499u l=1u
X741 DVDD GATE BAT DVDD pfet_06v0 ad=58.1096p pd=77.98u as=58.1096p ps=77.98u w=76.46u l=1u
X742 BAT GATE DVDD DVDD pfet_06v0 ad=35.511p pd=48.245u as=43.9215p ps=95.32999u w=46.725u l=1u
X743 BAT GATE DVDD DVDD pfet_06v0 ad=35.511p pd=48.245u as=35.511p ps=48.245u w=46.725u l=1u
X744 DVDD GATE BAT DVDD pfet_06v0 ad=35.511p pd=48.245u as=35.511p ps=48.245u w=46.725u l=1u
X745 BAT GATE DVDD DVDD pfet_06v0 ad=35.511p pd=48.245u as=35.511p ps=48.245u w=46.725u l=1u
X746 BAT GATE DVDD DVDD pfet_06v0 ad=58.1172p pd=77.99u as=58.1172p ps=77.99u w=76.47u l=1u
X747 BAT GATE DVDD DVDD pfet_06v0 ad=58.1134p pd=77.985u as=58.1134p ps=77.985u w=76.465u l=1u
X748 BAT GATE DVDD DVDD pfet_06v0 ad=35.5072p pd=48.24u as=35.5072p ps=48.24u w=46.72u l=1u
X749 BAT GATE DVDD DVDD pfet_06v0 ad=35.511p pd=48.245u as=35.511p ps=48.245u w=46.725u l=1u
X750 BAT GATE DVDD DVDD pfet_06v0 ad=58.1134p pd=77.985u as=71.8771p ps=0.15481m w=76.465u l=1u
X751 DVDD GATE BAT DVDD pfet_06v0 ad=35.511p pd=48.245u as=35.511p ps=48.245u w=46.725u l=1u
X752 DVDD GATE BAT DVDD pfet_06v0 ad=35.511p pd=48.245u as=35.511p ps=48.245u w=46.725u l=1u
X753 DVDD GATE BAT DVDD pfet_06v0 ad=35.511p pd=48.245u as=35.511p ps=48.245u w=46.725u l=1u
X754 DVDD GATE BAT DVDD pfet_06v0 ad=43.9215p pd=95.32999u as=35.511p ps=48.245u w=46.725u l=1u
X755 DVDD GATE BAT DVDD pfet_06v0 ad=71.8771p pd=0.15481m as=58.1134p ps=77.985u w=76.465u l=1u
X756 DVDD GATE BAT DVDD pfet_06v0 ad=58.1134p pd=77.985u as=58.1134p ps=77.985u w=76.465u l=1u
X757 BAT GATE DVDD DVDD pfet_06v0 ad=58.1134p pd=77.985u as=71.8771p ps=0.15481m w=76.465u l=1u
X758 BAT GATE DVDD DVDD pfet_06v0 ad=58.1134p pd=77.985u as=58.1134p ps=77.985u w=76.465u l=1u
X759 BAT GATE DVDD DVDD pfet_06v0 ad=35.511p pd=48.245u as=35.511p ps=48.245u w=46.725u l=1u
X760 DVDD GATE BAT DVDD pfet_06v0 ad=35.511p pd=48.245u as=35.511p ps=48.245u w=46.725u l=1u
X761 DVDD GATE BAT DVDD pfet_06v0 ad=49.3848p pd=66.5u as=49.3848p ps=66.5u w=64.98u l=1u
X762 BAT GATE DVDD DVDD pfet_06v0 ad=58.1134p pd=77.985u as=58.1134p ps=77.985u w=76.465u l=1u
X763 DVDD GATE BAT DVDD pfet_06v0 ad=35.511p pd=48.245u as=35.511p ps=48.245u w=46.725u l=1u
X764 BAT GATE DVDD DVDD pfet_06v0 ad=35.511p pd=48.245u as=35.511p ps=48.245u w=46.725u l=1u
X765 DVDD GATE BAT DVDD pfet_06v0 ad=58.1552p pd=78.04u as=58.1552p ps=78.04u w=76.52u l=1u
X766 BAT GATE DVDD DVDD pfet_06v0 ad=58.1134p pd=77.985u as=58.1134p ps=77.985u w=76.465u l=1u
X767 BAT GATE DVDD DVDD pfet_06v0 ad=58.1134p pd=77.985u as=58.1134p ps=77.985u w=76.465u l=1u
X768 BAT GATE DVDD DVDD pfet_06v0 ad=47.6862p pd=64.265u as=58.9803p ps=0.12737m w=62.745u l=1u
X769 DVDD GATE BAT DVDD pfet_06v0 ad=58.1134p pd=77.985u as=58.1134p ps=77.985u w=76.465u l=1u
X770 DVDD GATE BAT DVDD pfet_06v0 ad=35.511p pd=48.245u as=35.511p ps=48.245u w=46.725u l=1u
X771 DVDD GATE BAT DVDD pfet_06v0 ad=43.9215p pd=95.32999u as=35.511p ps=48.245u w=46.725u l=1u
X772 DVDD GATE BAT DVDD pfet_06v0 ad=35.511p pd=48.245u as=35.511p ps=48.245u w=46.725u l=1u
X773 BAT GATE DVDD DVDD pfet_06v0 ad=35.511p pd=48.245u as=35.511p ps=48.245u w=46.725u l=1u
X774 BAT GATE DVDD DVDD pfet_06v0 ad=35.511p pd=48.245u as=35.511p ps=48.245u w=46.725u l=1u
X775 DVDD GATE BAT DVDD pfet_06v0 ad=35.511p pd=48.245u as=35.511p ps=48.245u w=46.725u l=1u
X776 BAT GATE DVDD DVDD pfet_06v0 ad=58.1096p pd=77.98u as=71.8724p ps=0.1548m w=76.46u l=1u
X777 DVDD GATE BAT DVDD pfet_06v0 ad=58.1134p pd=77.985u as=58.1134p ps=77.985u w=76.465u l=1u
X778 BAT GATE DVDD DVDD pfet_06v0 ad=35.511p pd=48.245u as=35.511p ps=48.245u w=46.725u l=1u
X779 DVDD GATE BAT DVDD pfet_06v0 ad=35.511p pd=48.245u as=35.511p ps=48.245u w=46.725u l=1u
X780 DVDD GATE BAT DVDD pfet_06v0 ad=58.1172p pd=77.99u as=58.1172p ps=77.99u w=76.47u l=1u
X781 BAT GATE DVDD DVDD pfet_06v0 ad=47.6862p pd=64.265u as=47.6862p ps=64.265u w=62.745u l=1u
X782 DVDD GATE BAT DVDD pfet_06v0 ad=58.1134p pd=77.985u as=58.1134p ps=77.985u w=76.465u l=1u
X783 DVDD GATE BAT DVDD pfet_06v0 ad=43.9215p pd=95.32999u as=35.511p ps=48.245u w=46.725u l=1u
X784 BAT GATE DVDD DVDD pfet_06v0 ad=58.1172p pd=77.99u as=58.1172p ps=77.99u w=76.47u l=1u
X785 DVDD GATE BAT DVDD pfet_06v0 ad=35.511p pd=48.245u as=35.511p ps=48.245u w=46.725u l=1u
X786 DVDD GATE BAT DVDD pfet_06v0 ad=58.1552p pd=78.04u as=58.1552p ps=78.04u w=76.52u l=1u
X787 DVDD GATE BAT DVDD pfet_06v0 ad=58.1134p pd=77.985u as=58.1134p ps=77.985u w=76.465u l=1u
X788 DVDD GATE BAT DVDD pfet_06v0 ad=58.1096p pd=77.98u as=58.1096p ps=77.98u w=76.46u l=1u
X789 BAT GATE DVDD DVDD pfet_06v0 ad=58.1134p pd=77.985u as=71.8771p ps=0.15481m w=76.465u l=1u
X790 DVDD GATE BAT DVDD pfet_06v0 ad=35.511p pd=48.245u as=35.511p ps=48.245u w=46.725u l=1u
X791 BAT GATE DVDD DVDD pfet_06v0 ad=58.1134p pd=77.985u as=58.1134p ps=77.985u w=76.465u l=1u
X792 BAT GATE DVDD DVDD pfet_06v0 ad=35.511p pd=48.245u as=43.9215p ps=95.32999u w=46.725u l=1u
X793 BAT GATE DVDD DVDD pfet_06v0 ad=49.3848p pd=66.5u as=49.3848p ps=66.5u w=64.98u l=1u
X794 DVDD GATE BAT DVDD pfet_06v0 ad=71.8724p pd=0.1548m as=58.1096p ps=77.98u w=76.46u l=1u
X795 BAT GATE DVDD DVDD pfet_06v0 ad=58.1134p pd=77.985u as=58.1134p ps=77.985u w=76.465u l=1u
X796 DVDD GATE BAT DVDD pfet_06v0 ad=58.0754p pd=77.935u as=58.0754p ps=77.935u w=76.41499u l=1u
X797 BAT GATE DVDD DVDD pfet_06v0 ad=35.511p pd=48.245u as=35.511p ps=48.245u w=46.725u l=1u
X798 BAT GATE DVDD DVDD pfet_06v0 ad=35.511p pd=48.245u as=43.9215p ps=95.32999u w=46.725u l=1u
X799 BAT GATE DVDD DVDD pfet_06v0 ad=58.1552p pd=78.04u as=58.1552p ps=78.04u w=76.52u l=1u
X800 BAT GATE DVDD DVDD pfet_06v0 ad=35.511p pd=48.245u as=35.511p ps=48.245u w=46.725u l=1u
X801 DVDD GATE BAT DVDD pfet_06v0 ad=35.5072p pd=48.24u as=35.5072p ps=48.24u w=46.72u l=1u
X802 BAT GATE DVDD DVDD pfet_06v0 ad=58.1134p pd=77.985u as=71.8771p ps=0.15481m w=76.465u l=1u
X803 BAT GATE DVDD DVDD pfet_06v0 ad=35.511p pd=48.245u as=35.511p ps=48.245u w=46.725u l=1u
X804 BAT GATE DVDD DVDD pfet_06v0 ad=58.1172p pd=77.99u as=58.1172p ps=77.99u w=76.47u l=1u
X805 DVDD GATE BAT DVDD pfet_06v0 ad=49.3848p pd=66.5u as=49.3848p ps=66.5u w=64.98u l=1u
X806 BAT GATE DVDD DVDD pfet_06v0 ad=58.1096p pd=77.98u as=71.8724p ps=0.1548m w=76.46u l=1u
X807 BAT GATE DVDD DVDD pfet_06v0 ad=58.1096p pd=77.98u as=58.1096p ps=77.98u w=76.46u l=1u
X808 DVDD GATE BAT DVDD pfet_06v0 ad=58.1134p pd=77.985u as=58.1134p ps=77.985u w=76.465u l=1u
X809 DVDD GATE BAT DVDD pfet_06v0 ad=71.8818p pd=0.15482m as=58.1172p ps=77.99u w=76.47u l=1u
X810 BAT GATE DVDD DVDD pfet_06v0 ad=35.511p pd=48.245u as=35.511p ps=48.245u w=46.725u l=1u
X811 DVDD GATE BAT DVDD pfet_06v0 ad=49.3848p pd=66.5u as=49.3848p ps=66.5u w=64.98u l=1u
X812 BAT GATE DVDD DVDD pfet_06v0 ad=58.0754p pd=77.935u as=71.8301p ps=0.15471m w=76.41499u l=1u
X813 BAT GATE DVDD DVDD pfet_06v0 ad=49.3848p pd=66.5u as=49.3848p ps=66.5u w=64.98u l=1u
X814 DVDD GATE BAT DVDD pfet_06v0 ad=43.9215p pd=95.32999u as=35.511p ps=48.245u w=46.725u l=1u
X815 BAT GATE DVDD DVDD pfet_06v0 ad=58.1096p pd=77.98u as=58.1096p ps=77.98u w=76.46u l=1u
X816 BAT GATE DVDD DVDD pfet_06v0 ad=35.511p pd=48.245u as=35.511p ps=48.245u w=46.725u l=1u
X817 DVDD GATE BAT DVDD pfet_06v0 ad=35.511p pd=48.245u as=35.511p ps=48.245u w=46.725u l=1u
X818 DVDD GATE BAT DVDD pfet_06v0 ad=35.511p pd=48.245u as=35.511p ps=48.245u w=46.725u l=1u
X819 DVDD GATE BAT DVDD pfet_06v0 ad=35.511p pd=48.245u as=35.511p ps=48.245u w=46.725u l=1u
X820 BAT GATE DVDD DVDD pfet_06v0 ad=35.5072p pd=48.24u as=43.9168p ps=95.32u w=46.72u l=1u
X821 DVDD GATE BAT DVDD pfet_06v0 ad=35.511p pd=48.245u as=35.511p ps=48.245u w=46.725u l=1u
X822 DVDD GATE BAT DVDD pfet_06v0 ad=58.1096p pd=77.98u as=58.1096p ps=77.98u w=76.46u l=1u
X823 BAT GATE DVDD DVDD pfet_06v0 ad=35.511p pd=48.245u as=35.511p ps=48.245u w=46.725u l=1u
X824 BAT GATE DVDD DVDD pfet_06v0 ad=35.5072p pd=48.24u as=35.5072p ps=48.24u w=46.72u l=1u
X825 DVDD GATE BAT DVDD pfet_06v0 ad=71.8818p pd=0.15482m as=58.1172p ps=77.99u w=76.47u l=1u
X826 DVDD GATE BAT DVDD pfet_06v0 ad=35.511p pd=48.245u as=35.511p ps=48.245u w=46.725u l=1u
X827 DVDD GATE BAT DVDD pfet_06v0 ad=58.1134p pd=77.985u as=58.1134p ps=77.985u w=76.465u l=1u
X828 DVDD GATE BAT DVDD pfet_06v0 ad=35.511p pd=48.245u as=35.511p ps=48.245u w=46.725u l=1u
X829 BAT GATE DVDD DVDD pfet_06v0 ad=58.1172p pd=77.99u as=58.1172p ps=77.99u w=76.47u l=1u
X830 BAT GATE DVDD DVDD pfet_06v0 ad=58.0754p pd=77.935u as=58.0754p ps=77.935u w=76.41499u l=1u
X831 BAT GATE DVDD DVDD pfet_06v0 ad=35.511p pd=48.245u as=43.9215p ps=95.32999u w=46.725u l=1u
X832 DVDD GATE BAT DVDD pfet_06v0 ad=43.9215p pd=95.32999u as=35.511p ps=48.245u w=46.725u l=1u
X833 DVDD GATE BAT DVDD pfet_06v0 ad=47.6862p pd=64.265u as=47.6862p ps=64.265u w=62.745u l=1u
X834 DVDD GATE BAT DVDD pfet_06v0 ad=58.1134p pd=77.985u as=58.1134p ps=77.985u w=76.465u l=1u
X835 DVDD GATE BAT DVDD pfet_06v0 ad=43.9215p pd=95.32999u as=35.511p ps=48.245u w=46.725u l=1u
X836 BAT GATE DVDD DVDD pfet_06v0 ad=58.1134p pd=77.985u as=58.1134p ps=77.985u w=76.465u l=1u
X837 DVDD GATE BAT DVDD pfet_06v0 ad=58.1134p pd=77.985u as=58.1134p ps=77.985u w=76.465u l=1u
X838 BAT GATE DVDD DVDD pfet_06v0 ad=58.1134p pd=77.985u as=58.1134p ps=77.985u w=76.465u l=1u
X839 BAT GATE DVDD DVDD pfet_06v0 ad=58.1134p pd=77.985u as=58.1134p ps=77.985u w=76.465u l=1u
X840 BAT GATE DVDD DVDD pfet_06v0 ad=35.511p pd=48.245u as=43.9215p ps=95.32999u w=46.725u l=1u
X841 BAT GATE DVDD DVDD pfet_06v0 ad=35.511p pd=48.245u as=35.511p ps=48.245u w=46.725u l=1u
X842 BAT GATE DVDD DVDD pfet_06v0 ad=35.511p pd=48.245u as=35.511p ps=48.245u w=46.725u l=1u
X843 DVDD GATE BAT DVDD pfet_06v0 ad=35.511p pd=48.245u as=35.511p ps=48.245u w=46.725u l=1u
X844 BAT GATE DVDD DVDD pfet_06v0 ad=35.511p pd=48.245u as=35.511p ps=48.245u w=46.725u l=1u
X845 DVDD GATE BAT DVDD pfet_06v0 ad=58.0754p pd=77.935u as=58.0754p ps=77.935u w=76.41499u l=1u
X846 BAT GATE DVDD DVDD pfet_06v0 ad=58.1134p pd=77.985u as=58.1134p ps=77.985u w=76.465u l=1u
X847 DVDD GATE BAT DVDD pfet_06v0 ad=58.1134p pd=77.985u as=58.1134p ps=77.985u w=76.465u l=1u
X848 DVDD GATE BAT DVDD pfet_06v0 ad=58.1172p pd=77.99u as=58.1172p ps=77.99u w=76.47u l=1u
X849 BAT GATE DVDD DVDD pfet_06v0 ad=35.511p pd=48.245u as=43.9215p ps=95.32999u w=46.725u l=1u
X850 DVDD GATE BAT DVDD pfet_06v0 ad=35.511p pd=48.245u as=35.511p ps=48.245u w=46.725u l=1u
X851 DVDD GATE BAT DVDD pfet_06v0 ad=35.511p pd=48.245u as=35.511p ps=48.245u w=46.725u l=1u
X852 DVDD GATE BAT DVDD pfet_06v0 ad=35.5072p pd=48.24u as=35.5072p ps=48.24u w=46.72u l=1u
X853 BAT GATE DVDD DVDD pfet_06v0 ad=58.1134p pd=77.985u as=71.8771p ps=0.15481m w=76.465u l=1u
X854 BAT GATE DVDD DVDD pfet_06v0 ad=35.511p pd=48.245u as=35.511p ps=48.245u w=46.725u l=1u
X855 BAT GATE DVDD DVDD pfet_06v0 ad=58.1552p pd=78.04u as=58.1552p ps=78.04u w=76.52u l=1u
X856 BAT GATE DVDD DVDD pfet_06v0 ad=35.511p pd=48.245u as=35.511p ps=48.245u w=46.725u l=1u
X857 DVDD GATE BAT DVDD pfet_06v0 ad=58.1134p pd=77.985u as=58.1134p ps=77.985u w=76.465u l=1u
X858 DVDD GATE BAT DVDD pfet_06v0 ad=35.511p pd=48.245u as=35.511p ps=48.245u w=46.725u l=1u
X859 DVDD GATE BAT DVDD pfet_06v0 ad=35.511p pd=48.245u as=35.511p ps=48.245u w=46.725u l=1u
X860 DVDD GATE BAT DVDD pfet_06v0 ad=58.1134p pd=77.985u as=58.1134p ps=77.985u w=76.465u l=1u
X861 DVDD GATE BAT DVDD pfet_06v0 ad=35.511p pd=48.245u as=35.511p ps=48.245u w=46.725u l=1u
X862 BAT GATE DVDD DVDD pfet_06v0 ad=35.511p pd=48.245u as=35.511p ps=48.245u w=46.725u l=1u
X863 DVDD GATE BAT DVDD pfet_06v0 ad=35.511p pd=48.245u as=35.511p ps=48.245u w=46.725u l=1u
X864 DVDD GATE BAT DVDD pfet_06v0 ad=58.1134p pd=77.985u as=58.1134p ps=77.985u w=76.465u l=1u
X865 DVDD GATE BAT DVDD pfet_06v0 ad=58.1134p pd=77.985u as=58.1134p ps=77.985u w=76.465u l=1u
X866 DVDD GATE BAT DVDD pfet_06v0 ad=71.92879p pd=0.15492m as=58.1552p ps=78.04u w=76.52u l=1u
X867 BAT GATE DVDD DVDD pfet_06v0 ad=58.1172p pd=77.99u as=58.1172p ps=77.99u w=76.47u l=1u
X868 BAT GATE DVDD DVDD pfet_06v0 ad=58.1552p pd=78.04u as=71.92879p ps=0.15492m w=76.52u l=1u
X869 BAT GATE DVDD DVDD pfet_06v0 ad=35.511p pd=48.245u as=43.9215p ps=95.32999u w=46.725u l=1u
X870 BAT GATE DVDD DVDD pfet_06v0 ad=35.511p pd=48.245u as=35.511p ps=48.245u w=46.725u l=1u
X871 BAT GATE DVDD DVDD pfet_06v0 ad=35.511p pd=48.245u as=35.511p ps=48.245u w=46.725u l=1u
X872 DVDD GATE BAT DVDD pfet_06v0 ad=58.1096p pd=77.98u as=58.1096p ps=77.98u w=76.46u l=1u
X873 DVDD GATE BAT DVDD pfet_06v0 ad=35.511p pd=48.245u as=35.511p ps=48.245u w=46.725u l=1u
X874 BAT GATE DVDD DVDD pfet_06v0 ad=58.1134p pd=77.985u as=58.1134p ps=77.985u w=76.465u l=1u
X875 DVDD GATE BAT DVDD pfet_06v0 ad=71.8771p pd=0.15481m as=58.1134p ps=77.985u w=76.465u l=1u
X876 DVDD GATE BAT DVDD pfet_06v0 ad=35.511p pd=48.245u as=35.511p ps=48.245u w=46.725u l=1u
X877 DVDD GATE BAT DVDD pfet_06v0 ad=58.1096p pd=77.98u as=58.1096p ps=77.98u w=76.46u l=1u
X878 DVDD GATE BAT DVDD pfet_06v0 ad=58.1134p pd=77.985u as=58.1134p ps=77.985u w=76.465u l=1u
X879 BAT GATE DVDD DVDD pfet_06v0 ad=35.511p pd=48.245u as=35.511p ps=48.245u w=46.725u l=1u
X880 DVDD GATE BAT DVDD pfet_06v0 ad=49.3848p pd=66.5u as=49.3848p ps=66.5u w=64.98u l=1u
X881 BAT GATE DVDD DVDD pfet_06v0 ad=58.1134p pd=77.985u as=58.1134p ps=77.985u w=76.465u l=1u
X882 DVDD GATE BAT DVDD pfet_06v0 ad=58.0754p pd=77.935u as=58.0754p ps=77.935u w=76.41499u l=1u
X883 DVDD GATE BAT DVDD pfet_06v0 ad=47.6862p pd=64.265u as=47.6862p ps=64.265u w=62.745u l=1u
X884 DVDD GATE BAT DVDD pfet_06v0 ad=35.511p pd=48.245u as=35.511p ps=48.245u w=46.725u l=1u
X885 DVDD GATE BAT DVDD pfet_06v0 ad=35.511p pd=48.245u as=35.511p ps=48.245u w=46.725u l=1u
X886 BAT GATE DVDD DVDD pfet_06v0 ad=35.511p pd=48.245u as=43.9215p ps=95.32999u w=46.725u l=1u
X887 BAT GATE DVDD DVDD pfet_06v0 ad=58.1552p pd=78.04u as=58.1552p ps=78.04u w=76.52u l=1u
X888 BAT GATE DVDD DVDD pfet_06v0 ad=35.511p pd=48.245u as=43.9215p ps=95.32999u w=46.725u l=1u
X889 DVDD GATE BAT DVDD pfet_06v0 ad=43.9215p pd=95.32999u as=35.511p ps=48.245u w=46.725u l=1u
X890 BAT GATE DVDD DVDD pfet_06v0 ad=58.1552p pd=78.04u as=58.1552p ps=78.04u w=76.52u l=1u
X891 BAT GATE DVDD DVDD pfet_06v0 ad=58.1096p pd=77.98u as=58.1096p ps=77.98u w=76.46u l=1u
X892 BAT GATE DVDD DVDD pfet_06v0 ad=58.1134p pd=77.985u as=58.1134p ps=77.985u w=76.465u l=1u
X893 BAT GATE DVDD DVDD pfet_06v0 ad=35.511p pd=48.245u as=35.511p ps=48.245u w=46.725u l=1u
X894 BAT GATE DVDD DVDD pfet_06v0 ad=35.511p pd=48.245u as=35.511p ps=48.245u w=46.725u l=1u
X895 BAT GATE DVDD DVDD pfet_06v0 ad=35.511p pd=48.245u as=35.511p ps=48.245u w=46.725u l=1u
X896 BAT GATE DVDD DVDD pfet_06v0 ad=35.511p pd=48.245u as=35.511p ps=48.245u w=46.725u l=1u
X897 BAT GATE DVDD DVDD pfet_06v0 ad=58.1134p pd=77.985u as=58.1134p ps=77.985u w=76.465u l=1u
X898 BAT GATE DVDD DVDD pfet_06v0 ad=58.0754p pd=77.935u as=58.0754p ps=77.935u w=76.41499u l=1u
X899 DVDD GATE BAT DVDD pfet_06v0 ad=35.511p pd=48.245u as=35.511p ps=48.245u w=46.725u l=1u
X900 BAT GATE DVDD DVDD pfet_06v0 ad=58.1134p pd=77.985u as=58.1134p ps=77.985u w=76.465u l=1u
X901 DVDD GATE BAT DVDD pfet_06v0 ad=43.9215p pd=95.32999u as=35.511p ps=48.245u w=46.725u l=1u
X902 BAT GATE DVDD DVDD pfet_06v0 ad=35.5072p pd=48.24u as=35.5072p ps=48.24u w=46.72u l=1u
X903 BAT GATE DVDD DVDD pfet_06v0 ad=35.5072p pd=48.24u as=35.5072p ps=48.24u w=46.72u l=1u
X904 DVDD GATE BAT DVDD pfet_06v0 ad=58.1134p pd=77.985u as=58.1134p ps=77.985u w=76.465u l=1u
X905 BAT GATE DVDD DVDD pfet_06v0 ad=35.511p pd=48.245u as=35.511p ps=48.245u w=46.725u l=1u
X906 DVDD GATE BAT DVDD pfet_06v0 ad=43.9215p pd=95.32999u as=35.511p ps=48.245u w=46.725u l=1u
X907 DVDD GATE BAT DVDD pfet_06v0 ad=71.8771p pd=0.15481m as=58.1134p ps=77.985u w=76.465u l=1u
X908 DVDD GATE BAT DVDD pfet_06v0 ad=49.3848p pd=66.5u as=49.3848p ps=66.5u w=64.98u l=1u
X909 DVDD GATE BAT DVDD pfet_06v0 ad=35.511p pd=48.245u as=35.511p ps=48.245u w=46.725u l=1u
X910 BAT GATE DVDD DVDD pfet_06v0 ad=49.3848p pd=66.5u as=49.3848p ps=66.5u w=64.98u l=1u
X911 BAT GATE DVDD DVDD pfet_06v0 ad=35.511p pd=48.245u as=35.511p ps=48.245u w=46.725u l=1u
X912 DVDD GATE BAT DVDD pfet_06v0 ad=58.1096p pd=77.98u as=58.1096p ps=77.98u w=76.46u l=1u
X913 BAT GATE DVDD DVDD pfet_06v0 ad=47.6862p pd=64.265u as=47.6862p ps=64.265u w=62.745u l=1u
X914 DVDD GATE BAT DVDD pfet_06v0 ad=35.511p pd=48.245u as=35.511p ps=48.245u w=46.725u l=1u
X915 DVDD GATE BAT DVDD pfet_06v0 ad=43.9215p pd=95.32999u as=35.511p ps=48.245u w=46.725u l=1u
X916 DVDD GATE BAT DVDD pfet_06v0 ad=35.511p pd=48.245u as=35.511p ps=48.245u w=46.725u l=1u
X917 BAT GATE DVDD DVDD pfet_06v0 ad=58.1096p pd=77.98u as=71.8724p ps=0.1548m w=76.46u l=1u
X918 DVDD GATE BAT DVDD pfet_06v0 ad=58.0754p pd=77.935u as=58.0754p ps=77.935u w=76.41499u l=1u
X919 BAT GATE DVDD DVDD pfet_06v0 ad=58.1134p pd=77.985u as=58.1134p ps=77.985u w=76.465u l=1u
X920 BAT GATE DVDD DVDD pfet_06v0 ad=58.1134p pd=77.985u as=58.1134p ps=77.985u w=76.465u l=1u
X921 BAT GATE DVDD DVDD pfet_06v0 ad=35.511p pd=48.245u as=35.511p ps=48.245u w=46.725u l=1u
X922 BAT GATE DVDD DVDD pfet_06v0 ad=47.6862p pd=64.265u as=47.6862p ps=64.265u w=62.745u l=1u
X923 DVDD GATE BAT DVDD pfet_06v0 ad=35.5072p pd=48.24u as=35.5072p ps=48.24u w=46.72u l=1u
X924 BAT GATE DVDD DVDD pfet_06v0 ad=35.511p pd=48.245u as=35.511p ps=48.245u w=46.725u l=1u
X925 BAT GATE DVDD DVDD pfet_06v0 ad=35.511p pd=48.245u as=35.511p ps=48.245u w=46.725u l=1u
X926 BAT GATE DVDD DVDD pfet_06v0 ad=58.1134p pd=77.985u as=58.1134p ps=77.985u w=76.465u l=1u
X927 DVDD GATE BAT DVDD pfet_06v0 ad=58.1172p pd=77.99u as=58.1172p ps=77.99u w=76.47u l=1u
X928 DVDD GATE BAT DVDD pfet_06v0 ad=71.92879p pd=0.15492m as=58.1552p ps=78.04u w=76.52u l=1u
X929 BAT GATE DVDD DVDD pfet_06v0 ad=35.5072p pd=48.24u as=43.9168p ps=95.32u w=46.72u l=1u
X930 BAT GATE DVDD DVDD pfet_06v0 ad=58.1134p pd=77.985u as=58.1134p ps=77.985u w=76.465u l=1u
X931 BAT GATE DVDD DVDD pfet_06v0 ad=47.6862p pd=64.265u as=47.6862p ps=64.265u w=62.745u l=1u
X932 BAT GATE DVDD DVDD pfet_06v0 ad=58.1134p pd=77.985u as=58.1134p ps=77.985u w=76.465u l=1u
X933 DVDD GATE BAT DVDD pfet_06v0 ad=71.8771p pd=0.15481m as=58.1134p ps=77.985u w=76.465u l=1u
X934 BAT GATE DVDD DVDD pfet_06v0 ad=35.511p pd=48.245u as=35.511p ps=48.245u w=46.725u l=1u
X935 DVDD GATE BAT DVDD pfet_06v0 ad=71.8771p pd=0.15481m as=58.1134p ps=77.985u w=76.465u l=1u
X936 DVDD GATE BAT DVDD pfet_06v0 ad=43.9215p pd=95.32999u as=35.511p ps=48.245u w=46.725u l=1u
X937 BAT GATE DVDD DVDD pfet_06v0 ad=58.1096p pd=77.98u as=58.1096p ps=77.98u w=76.46u l=1u
X938 DVDD GATE BAT DVDD pfet_06v0 ad=58.1134p pd=77.985u as=58.1134p ps=77.985u w=76.465u l=1u
X939 DVDD GATE BAT DVDD pfet_06v0 ad=71.8771p pd=0.15481m as=58.1134p ps=77.985u w=76.465u l=1u
X940 DVDD GATE BAT DVDD pfet_06v0 ad=71.8771p pd=0.15481m as=58.1134p ps=77.985u w=76.465u l=1u
X941 BAT GATE DVDD DVDD pfet_06v0 ad=58.1134p pd=77.985u as=58.1134p ps=77.985u w=76.465u l=1u
X942 DVDD GATE BAT DVDD pfet_06v0 ad=58.1134p pd=77.985u as=58.1134p ps=77.985u w=76.465u l=1u
X943 DVDD GATE BAT DVDD pfet_06v0 ad=35.511p pd=48.245u as=35.511p ps=48.245u w=46.725u l=1u
X944 BAT GATE DVDD DVDD pfet_06v0 ad=35.5072p pd=48.24u as=35.5072p ps=48.24u w=46.72u l=1u
X945 DVDD GATE BAT DVDD pfet_06v0 ad=35.511p pd=48.245u as=35.511p ps=48.245u w=46.725u l=1u
X946 BAT GATE DVDD DVDD pfet_06v0 ad=58.1134p pd=77.985u as=58.1134p ps=77.985u w=76.465u l=1u
X947 DVDD GATE BAT DVDD pfet_06v0 ad=58.1134p pd=77.985u as=58.1134p ps=77.985u w=76.465u l=1u
X948 DVDD GATE BAT DVDD pfet_06v0 ad=58.1134p pd=77.985u as=58.1134p ps=77.985u w=76.465u l=1u
X949 DVDD GATE BAT DVDD pfet_06v0 ad=43.9215p pd=95.32999u as=35.511p ps=48.245u w=46.725u l=1u
X950 DVDD GATE BAT DVDD pfet_06v0 ad=35.511p pd=48.245u as=35.511p ps=48.245u w=46.725u l=1u
X951 BAT GATE DVDD DVDD pfet_06v0 ad=35.511p pd=48.245u as=43.9215p ps=95.32999u w=46.725u l=1u
X952 DVDD GATE BAT DVDD pfet_06v0 ad=35.511p pd=48.245u as=35.511p ps=48.245u w=46.725u l=1u
X953 DVDD GATE BAT DVDD pfet_06v0 ad=71.8771p pd=0.15481m as=58.1134p ps=77.985u w=76.465u l=1u
X954 DVDD GATE BAT DVDD pfet_06v0 ad=58.1552p pd=78.04u as=58.1552p ps=78.04u w=76.52u l=1u
X955 DVDD GATE BAT DVDD pfet_06v0 ad=58.1134p pd=77.985u as=58.1134p ps=77.985u w=76.465u l=1u
X956 BAT GATE DVDD DVDD pfet_06v0 ad=35.511p pd=48.245u as=43.9215p ps=95.32999u w=46.725u l=1u
X957 BAT GATE DVDD DVDD pfet_06v0 ad=58.1134p pd=77.985u as=58.1134p ps=77.985u w=76.465u l=1u
X958 DVDD GATE BAT DVDD pfet_06v0 ad=43.9215p pd=95.32999u as=35.511p ps=48.245u w=46.725u l=1u
X959 BAT GATE DVDD DVDD pfet_06v0 ad=58.1134p pd=77.985u as=58.1134p ps=77.985u w=76.465u l=1u
X960 DVDD GATE BAT DVDD pfet_06v0 ad=35.511p pd=48.245u as=35.511p ps=48.245u w=46.725u l=1u
X961 BAT GATE DVDD DVDD pfet_06v0 ad=35.511p pd=48.245u as=35.511p ps=48.245u w=46.725u l=1u
X962 BAT GATE DVDD DVDD pfet_06v0 ad=35.511p pd=48.245u as=35.511p ps=48.245u w=46.725u l=1u
X963 BAT GATE DVDD DVDD pfet_06v0 ad=35.511p pd=48.245u as=35.511p ps=48.245u w=46.725u l=1u
X964 DVDD GATE BAT DVDD pfet_06v0 ad=58.1552p pd=78.04u as=58.1552p ps=78.04u w=76.52u l=1u
X965 BAT GATE DVDD DVDD pfet_06v0 ad=58.1134p pd=77.985u as=58.1134p ps=77.985u w=76.465u l=1u
X966 BAT GATE DVDD DVDD pfet_06v0 ad=58.1552p pd=78.04u as=58.1552p ps=78.04u w=76.52u l=1u
X967 DVDD GATE BAT DVDD pfet_06v0 ad=43.9215p pd=95.32999u as=35.511p ps=48.245u w=46.725u l=1u
X968 BAT GATE DVDD DVDD pfet_06v0 ad=58.1134p pd=77.985u as=58.1134p ps=77.985u w=76.465u l=1u
X969 BAT GATE DVDD DVDD pfet_06v0 ad=35.511p pd=48.245u as=35.511p ps=48.245u w=46.725u l=1u
X970 BAT GATE DVDD DVDD pfet_06v0 ad=35.511p pd=48.245u as=43.9215p ps=95.32999u w=46.725u l=1u
X971 BAT GATE DVDD DVDD pfet_06v0 ad=58.1134p pd=77.985u as=58.1134p ps=77.985u w=76.465u l=1u
X972 BAT GATE DVDD DVDD pfet_06v0 ad=35.511p pd=48.245u as=35.511p ps=48.245u w=46.725u l=1u
X973 BAT GATE DVDD DVDD pfet_06v0 ad=58.0754p pd=77.935u as=58.0754p ps=77.935u w=76.41499u l=1u
X974 BAT GATE DVDD DVDD pfet_06v0 ad=49.3848p pd=66.5u as=49.3848p ps=66.5u w=64.98u l=1u
X975 BAT GATE DVDD DVDD pfet_06v0 ad=35.511p pd=48.245u as=43.9215p ps=95.32999u w=46.725u l=1u
X976 DVDD GATE BAT DVDD pfet_06v0 ad=58.1134p pd=77.985u as=58.1134p ps=77.985u w=76.465u l=1u
X977 BAT GATE DVDD DVDD pfet_06v0 ad=58.1134p pd=77.985u as=58.1134p ps=77.985u w=76.465u l=1u
X978 BAT GATE DVDD DVDD pfet_06v0 ad=35.511p pd=48.245u as=35.511p ps=48.245u w=46.725u l=1u
X979 BAT GATE DVDD DVDD pfet_06v0 ad=47.6862p pd=64.265u as=58.9803p ps=0.12737m w=62.745u l=1u
X980 BAT GATE DVDD DVDD pfet_06v0 ad=58.1134p pd=77.985u as=58.1134p ps=77.985u w=76.465u l=1u
X981 BAT GATE DVDD DVDD pfet_06v0 ad=58.1134p pd=77.985u as=71.8771p ps=0.15481m w=76.465u l=1u
X982 BAT GATE DVDD DVDD pfet_06v0 ad=35.5072p pd=48.24u as=35.5072p ps=48.24u w=46.72u l=1u
X983 DVDD GATE BAT DVDD pfet_06v0 ad=58.1096p pd=77.98u as=58.1096p ps=77.98u w=76.46u l=1u
X984 BAT GATE DVDD DVDD pfet_06v0 ad=35.511p pd=48.245u as=35.511p ps=48.245u w=46.725u l=1u
X985 BAT GATE DVDD DVDD pfet_06v0 ad=47.6862p pd=64.265u as=47.6862p ps=64.265u w=62.745u l=1u
X986 BAT GATE DVDD DVDD pfet_06v0 ad=58.1172p pd=77.99u as=58.1172p ps=77.99u w=76.47u l=1u
X987 DVDD GATE BAT DVDD pfet_06v0 ad=71.8771p pd=0.15481m as=58.1134p ps=77.985u w=76.465u l=1u
X988 BAT GATE DVDD DVDD pfet_06v0 ad=35.511p pd=48.245u as=43.9215p ps=95.32999u w=46.725u l=1u
X989 DVDD GATE BAT DVDD pfet_06v0 ad=35.511p pd=48.245u as=35.511p ps=48.245u w=46.725u l=1u
X990 BAT GATE DVDD DVDD pfet_06v0 ad=35.511p pd=48.245u as=43.9215p ps=95.32999u w=46.725u l=1u
X991 DVDD GATE BAT DVDD pfet_06v0 ad=35.511p pd=48.245u as=35.511p ps=48.245u w=46.725u l=1u
X992 DVDD GATE BAT DVDD pfet_06v0 ad=58.1134p pd=77.985u as=58.1134p ps=77.985u w=76.465u l=1u
X993 BAT GATE DVDD DVDD pfet_06v0 ad=35.511p pd=48.245u as=35.511p ps=48.245u w=46.725u l=1u
X994 BAT GATE DVDD DVDD pfet_06v0 ad=58.1172p pd=77.99u as=58.1172p ps=77.99u w=76.47u l=1u
X995 DVDD GATE BAT DVDD pfet_06v0 ad=58.1134p pd=77.985u as=58.1134p ps=77.985u w=76.465u l=1u
X996 BAT GATE DVDD DVDD pfet_06v0 ad=58.1134p pd=77.985u as=58.1134p ps=77.985u w=76.465u l=1u
X997 BAT GATE DVDD DVDD pfet_06v0 ad=47.6862p pd=64.265u as=58.9803p ps=0.12737m w=62.745u l=1u
X998 DVDD GATE BAT DVDD pfet_06v0 ad=58.9803p pd=0.12737m as=47.6862p ps=64.265u w=62.745u l=1u
X999 DVDD GATE BAT DVDD pfet_06v0 ad=35.5072p pd=48.24u as=35.5072p ps=48.24u w=46.72u l=1u
X1000 DVDD GATE BAT DVDD pfet_06v0 ad=35.511p pd=48.245u as=35.511p ps=48.245u w=46.725u l=1u
X1001 DVDD GATE BAT DVDD pfet_06v0 ad=35.5072p pd=48.24u as=35.5072p ps=48.24u w=46.72u l=1u
X1002 BAT GATE DVDD DVDD pfet_06v0 ad=58.1096p pd=77.98u as=71.8724p ps=0.1548m w=76.46u l=1u
X1003 DVDD GATE BAT DVDD pfet_06v0 ad=43.9168p pd=95.32u as=35.5072p ps=48.24u w=46.72u l=1u
X1004 BAT GATE DVDD DVDD pfet_06v0 ad=58.1134p pd=77.985u as=58.1134p ps=77.985u w=76.465u l=1u
X1005 BAT GATE DVDD DVDD pfet_06v0 ad=58.1134p pd=77.985u as=58.1134p ps=77.985u w=76.465u l=1u
X1006 BAT GATE DVDD DVDD pfet_06v0 ad=35.511p pd=48.245u as=43.9215p ps=95.32999u w=46.725u l=1u
X1007 BAT GATE DVDD DVDD pfet_06v0 ad=35.511p pd=48.245u as=35.511p ps=48.245u w=46.725u l=1u
X1008 DVDD GATE BAT DVDD pfet_06v0 ad=49.3848p pd=66.5u as=49.3848p ps=66.5u w=64.98u l=1u
X1009 BAT GATE DVDD DVDD pfet_06v0 ad=58.1096p pd=77.98u as=58.1096p ps=77.98u w=76.46u l=1u
X1010 BAT GATE DVDD DVDD pfet_06v0 ad=35.511p pd=48.245u as=35.511p ps=48.245u w=46.725u l=1u
X1011 DVDD GATE BAT DVDD pfet_06v0 ad=58.1134p pd=77.985u as=58.1134p ps=77.985u w=76.465u l=1u
X1012 BAT GATE DVDD DVDD pfet_06v0 ad=58.1134p pd=77.985u as=58.1134p ps=77.985u w=76.465u l=1u
X1013 DVDD GATE BAT DVDD pfet_06v0 ad=43.9215p pd=95.32999u as=35.511p ps=48.245u w=46.725u l=1u
X1014 BAT GATE DVDD DVDD pfet_06v0 ad=35.511p pd=48.245u as=35.511p ps=48.245u w=46.725u l=1u
X1015 BAT GATE DVDD DVDD pfet_06v0 ad=35.511p pd=48.245u as=35.511p ps=48.245u w=46.725u l=1u
X1016 DVDD GATE BAT DVDD pfet_06v0 ad=58.1134p pd=77.985u as=58.1134p ps=77.985u w=76.465u l=1u
X1017 DVDD GATE BAT DVDD pfet_06v0 ad=58.1134p pd=77.985u as=58.1134p ps=77.985u w=76.465u l=1u
X1018 DVDD GATE BAT DVDD pfet_06v0 ad=58.1134p pd=77.985u as=58.1134p ps=77.985u w=76.465u l=1u
X1019 DVDD GATE BAT DVDD pfet_06v0 ad=58.1134p pd=77.985u as=58.1134p ps=77.985u w=76.465u l=1u
X1020 DVDD GATE BAT DVDD pfet_06v0 ad=35.511p pd=48.245u as=35.511p ps=48.245u w=46.725u l=1u
X1021 BAT GATE DVDD DVDD pfet_06v0 ad=58.0754p pd=77.935u as=58.0754p ps=77.935u w=76.41499u l=1u
X1022 DVDD GATE BAT DVDD pfet_06v0 ad=47.6862p pd=64.265u as=47.6862p ps=64.265u w=62.745u l=1u
X1023 DVDD GATE BAT DVDD pfet_06v0 ad=35.511p pd=48.245u as=35.511p ps=48.245u w=46.725u l=1u
X1024 DVDD GATE BAT DVDD pfet_06v0 ad=35.511p pd=48.245u as=35.511p ps=48.245u w=46.725u l=1u
X1025 DVDD GATE BAT DVDD pfet_06v0 ad=47.6862p pd=64.265u as=47.6862p ps=64.265u w=62.745u l=1u
X1026 DVDD GATE BAT DVDD pfet_06v0 ad=35.511p pd=48.245u as=35.511p ps=48.245u w=46.725u l=1u
X1027 DVDD GATE BAT DVDD pfet_06v0 ad=58.1134p pd=77.985u as=58.1134p ps=77.985u w=76.465u l=1u
X1028 DVDD GATE BAT DVDD pfet_06v0 ad=43.9215p pd=95.32999u as=35.511p ps=48.245u w=46.725u l=1u
X1029 DVDD GATE BAT DVDD pfet_06v0 ad=35.511p pd=48.245u as=35.511p ps=48.245u w=46.725u l=1u
X1030 DVDD GATE BAT DVDD pfet_06v0 ad=35.511p pd=48.245u as=35.511p ps=48.245u w=46.725u l=1u
X1031 BAT GATE DVDD DVDD pfet_06v0 ad=35.511p pd=48.245u as=35.511p ps=48.245u w=46.725u l=1u
X1032 DVDD GATE BAT DVDD pfet_06v0 ad=35.511p pd=48.245u as=35.511p ps=48.245u w=46.725u l=1u
X1033 DVDD GATE BAT DVDD pfet_06v0 ad=58.1096p pd=77.98u as=58.1096p ps=77.98u w=76.46u l=1u
X1034 BAT GATE DVDD DVDD pfet_06v0 ad=58.1134p pd=77.985u as=58.1134p ps=77.985u w=76.465u l=1u
X1035 BAT GATE DVDD DVDD pfet_06v0 ad=58.1172p pd=77.99u as=58.1172p ps=77.99u w=76.47u l=1u
X1036 BAT GATE DVDD DVDD pfet_06v0 ad=35.511p pd=48.245u as=43.9215p ps=95.32999u w=46.725u l=1u
X1037 DVDD GATE BAT DVDD pfet_06v0 ad=58.1134p pd=77.985u as=58.1134p ps=77.985u w=76.465u l=1u
X1038 BAT GATE DVDD DVDD pfet_06v0 ad=35.511p pd=48.245u as=35.511p ps=48.245u w=46.725u l=1u
X1039 DVDD GATE BAT DVDD pfet_06v0 ad=58.1134p pd=77.985u as=58.1134p ps=77.985u w=76.465u l=1u
X1040 DVDD GATE BAT DVDD pfet_06v0 ad=35.511p pd=48.245u as=35.511p ps=48.245u w=46.725u l=1u
X1041 BAT GATE DVDD DVDD pfet_06v0 ad=58.1134p pd=77.985u as=58.1134p ps=77.985u w=76.465u l=1u
X1042 BAT GATE DVDD DVDD pfet_06v0 ad=58.0754p pd=77.935u as=71.8301p ps=0.15471m w=76.41499u l=1u
X1043 BAT GATE DVDD DVDD pfet_06v0 ad=58.1134p pd=77.985u as=58.1134p ps=77.985u w=76.465u l=1u
X1044 DVDD GATE BAT DVDD pfet_06v0 ad=71.8301p pd=0.15471m as=58.0754p ps=77.935u w=76.41499u l=1u
X1045 BAT GATE DVDD DVDD pfet_06v0 ad=35.511p pd=48.245u as=35.511p ps=48.245u w=46.725u l=1u
X1046 DVDD GATE BAT DVDD pfet_06v0 ad=58.1134p pd=77.985u as=58.1134p ps=77.985u w=76.465u l=1u
X1047 DVDD GATE BAT DVDD pfet_06v0 ad=35.511p pd=48.245u as=35.511p ps=48.245u w=46.725u l=1u
X1048 BAT GATE DVDD DVDD pfet_06v0 ad=58.1134p pd=77.985u as=71.8771p ps=0.15481m w=76.465u l=1u
X1049 BAT GATE DVDD DVDD pfet_06v0 ad=35.511p pd=48.245u as=35.511p ps=48.245u w=46.725u l=1u
X1050 BAT GATE DVDD DVDD pfet_06v0 ad=35.511p pd=48.245u as=35.511p ps=48.245u w=46.725u l=1u
X1051 BAT GATE DVDD DVDD pfet_06v0 ad=58.1134p pd=77.985u as=58.1134p ps=77.985u w=76.465u l=1u
X1052 DVDD GATE BAT DVDD pfet_06v0 ad=58.1134p pd=77.985u as=58.1134p ps=77.985u w=76.465u l=1u
X1053 BAT GATE DVDD DVDD pfet_06v0 ad=35.511p pd=48.245u as=35.511p ps=48.245u w=46.725u l=1u
X1054 DVDD GATE BAT DVDD pfet_06v0 ad=35.511p pd=48.245u as=35.511p ps=48.245u w=46.725u l=1u
X1055 DVDD GATE BAT DVDD pfet_06v0 ad=58.1172p pd=77.99u as=58.1172p ps=77.99u w=76.47u l=1u
X1056 BAT GATE DVDD DVDD pfet_06v0 ad=58.1134p pd=77.985u as=58.1134p ps=77.985u w=76.465u l=1u
X1057 DVDD GATE BAT DVDD pfet_06v0 ad=58.0754p pd=77.935u as=58.0754p ps=77.935u w=76.41499u l=1u
X1058 DVDD GATE BAT DVDD pfet_06v0 ad=35.511p pd=48.245u as=35.511p ps=48.245u w=46.725u l=1u
X1059 BAT GATE DVDD DVDD pfet_06v0 ad=35.511p pd=48.245u as=35.511p ps=48.245u w=46.725u l=1u
X1060 DVDD GATE BAT DVDD pfet_06v0 ad=71.8818p pd=0.15482m as=58.1172p ps=77.99u w=76.47u l=1u
X1061 BAT GATE DVDD DVDD pfet_06v0 ad=58.1172p pd=77.99u as=58.1172p ps=77.99u w=76.47u l=1u
X1062 DVDD GATE BAT DVDD pfet_06v0 ad=43.9215p pd=95.32999u as=35.511p ps=48.245u w=46.725u l=1u
X1063 BAT GATE DVDD DVDD pfet_06v0 ad=58.1134p pd=77.985u as=58.1134p ps=77.985u w=76.465u l=1u
X1064 DVDD GATE BAT DVDD pfet_06v0 ad=58.1134p pd=77.985u as=58.1134p ps=77.985u w=76.465u l=1u
X1065 BAT GATE DVDD DVDD pfet_06v0 ad=35.511p pd=48.245u as=35.511p ps=48.245u w=46.725u l=1u
X1066 BAT GATE DVDD DVDD pfet_06v0 ad=58.1134p pd=77.985u as=58.1134p ps=77.985u w=76.465u l=1u
X1067 BAT GATE DVDD DVDD pfet_06v0 ad=35.5072p pd=48.24u as=35.5072p ps=48.24u w=46.72u l=1u
X1068 DVDD GATE BAT DVDD pfet_06v0 ad=35.511p pd=48.245u as=35.511p ps=48.245u w=46.725u l=1u
X1069 DVDD GATE BAT DVDD pfet_06v0 ad=35.511p pd=48.245u as=35.511p ps=48.245u w=46.725u l=1u
X1070 DVDD GATE BAT DVDD pfet_06v0 ad=71.8771p pd=0.15481m as=58.1134p ps=77.985u w=76.465u l=1u
X1071 DVDD GATE BAT DVDD pfet_06v0 ad=35.511p pd=48.245u as=35.511p ps=48.245u w=46.725u l=1u
X1072 DVDD GATE BAT DVDD pfet_06v0 ad=58.1134p pd=77.985u as=58.1134p ps=77.985u w=76.465u l=1u
X1073 BAT GATE DVDD DVDD pfet_06v0 ad=35.511p pd=48.245u as=43.9215p ps=95.32999u w=46.725u l=1u
X1074 DVDD GATE BAT DVDD pfet_06v0 ad=49.3848p pd=66.5u as=49.3848p ps=66.5u w=64.98u l=1u
X1075 BAT GATE DVDD DVDD pfet_06v0 ad=58.1134p pd=77.985u as=58.1134p ps=77.985u w=76.465u l=1u
X1076 BAT GATE DVDD DVDD pfet_06v0 ad=35.511p pd=48.245u as=35.511p ps=48.245u w=46.725u l=1u
X1077 DVDD GATE BAT DVDD pfet_06v0 ad=58.1552p pd=78.04u as=58.1552p ps=78.04u w=76.52u l=1u
X1078 BAT GATE DVDD DVDD pfet_06v0 ad=58.1134p pd=77.985u as=58.1134p ps=77.985u w=76.465u l=1u
X1079 DVDD GATE BAT DVDD pfet_06v0 ad=71.92879p pd=0.15492m as=58.1552p ps=78.04u w=76.52u l=1u
X1080 BAT GATE DVDD DVDD pfet_06v0 ad=58.1134p pd=77.985u as=71.8771p ps=0.15481m w=76.465u l=1u
X1081 BAT GATE DVDD DVDD pfet_06v0 ad=58.1552p pd=78.04u as=58.1552p ps=78.04u w=76.52u l=1u
X1082 DVDD GATE BAT DVDD pfet_06v0 ad=35.511p pd=48.245u as=35.511p ps=48.245u w=46.725u l=1u
X1083 DVDD GATE BAT DVDD pfet_06v0 ad=35.511p pd=48.245u as=35.511p ps=48.245u w=46.725u l=1u
X1084 DVDD GATE BAT DVDD pfet_06v0 ad=35.511p pd=48.245u as=35.511p ps=48.245u w=46.725u l=1u
X1085 BAT GATE DVDD DVDD pfet_06v0 ad=58.1134p pd=77.985u as=58.1134p ps=77.985u w=76.465u l=1u
X1086 DVDD GATE BAT DVDD pfet_06v0 ad=58.0754p pd=77.935u as=58.0754p ps=77.935u w=76.41499u l=1u
X1087 BAT GATE DVDD DVDD pfet_06v0 ad=58.1134p pd=77.985u as=58.1134p ps=77.985u w=76.465u l=1u
X1088 BAT GATE DVDD DVDD pfet_06v0 ad=35.511p pd=48.245u as=43.9215p ps=95.32999u w=46.725u l=1u
X1089 BAT GATE DVDD DVDD pfet_06v0 ad=58.1134p pd=77.985u as=58.1134p ps=77.985u w=76.465u l=1u
X1090 BAT GATE DVDD DVDD pfet_06v0 ad=58.1096p pd=77.98u as=58.1096p ps=77.98u w=76.46u l=1u
X1091 BAT GATE DVDD DVDD pfet_06v0 ad=35.511p pd=48.245u as=43.9215p ps=95.32999u w=46.725u l=1u
X1092 BAT GATE DVDD DVDD pfet_06v0 ad=35.511p pd=48.245u as=43.9215p ps=95.32999u w=46.725u l=1u
X1093 BAT GATE DVDD DVDD pfet_06v0 ad=58.1134p pd=77.985u as=71.8771p ps=0.15481m w=76.465u l=1u
X1094 DVDD GATE BAT DVDD pfet_06v0 ad=58.1134p pd=77.985u as=58.1134p ps=77.985u w=76.465u l=1u
X1095 BAT GATE DVDD DVDD pfet_06v0 ad=47.6862p pd=64.265u as=58.9803p ps=0.12737m w=62.745u l=1u
X1096 DVDD GATE BAT DVDD pfet_06v0 ad=35.511p pd=48.245u as=35.511p ps=48.245u w=46.725u l=1u
X1097 DVDD GATE BAT DVDD pfet_06v0 ad=58.1172p pd=77.99u as=58.1172p ps=77.99u w=76.47u l=1u
X1098 BAT GATE DVDD DVDD pfet_06v0 ad=35.511p pd=48.245u as=35.511p ps=48.245u w=46.725u l=1u
X1099 DVDD GATE BAT DVDD pfet_06v0 ad=58.1134p pd=77.985u as=58.1134p ps=77.985u w=76.465u l=1u
X1100 DVDD GATE BAT DVDD pfet_06v0 ad=58.1552p pd=78.04u as=58.1552p ps=78.04u w=76.52u l=1u
X1101 DVDD GATE BAT DVDD pfet_06v0 ad=58.1134p pd=77.985u as=58.1134p ps=77.985u w=76.465u l=1u
X1102 BAT GATE DVDD DVDD pfet_06v0 ad=35.511p pd=48.245u as=43.9215p ps=95.32999u w=46.725u l=1u
X1103 DVDD GATE BAT DVDD pfet_06v0 ad=58.1134p pd=77.985u as=58.1134p ps=77.985u w=76.465u l=1u
X1104 DVDD GATE BAT DVDD pfet_06v0 ad=35.511p pd=48.245u as=35.511p ps=48.245u w=46.725u l=1u
X1105 BAT GATE DVDD DVDD pfet_06v0 ad=58.1134p pd=77.985u as=58.1134p ps=77.985u w=76.465u l=1u
X1106 BAT GATE DVDD DVDD pfet_06v0 ad=49.3848p pd=66.5u as=49.3848p ps=66.5u w=64.98u l=1u
X1107 BAT GATE DVDD DVDD pfet_06v0 ad=47.6862p pd=64.265u as=58.9803p ps=0.12737m w=62.745u l=1u
X1108 BAT GATE DVDD DVDD pfet_06v0 ad=35.5072p pd=48.24u as=35.5072p ps=48.24u w=46.72u l=1u
X1109 DVDD GATE BAT DVDD pfet_06v0 ad=58.1096p pd=77.98u as=58.1096p ps=77.98u w=76.46u l=1u
X1110 DVDD GATE BAT DVDD pfet_06v0 ad=58.0754p pd=77.935u as=58.0754p ps=77.935u w=76.41499u l=1u
X1111 BAT GATE DVDD DVDD pfet_06v0 ad=35.511p pd=48.245u as=43.9215p ps=95.32999u w=46.725u l=1u
X1112 BAT GATE DVDD DVDD pfet_06v0 ad=35.511p pd=48.245u as=35.511p ps=48.245u w=46.725u l=1u
X1113 BAT GATE DVDD DVDD pfet_06v0 ad=35.511p pd=48.245u as=35.511p ps=48.245u w=46.725u l=1u
X1114 BAT GATE DVDD DVDD pfet_06v0 ad=35.511p pd=48.245u as=35.511p ps=48.245u w=46.725u l=1u
X1115 DVDD GATE BAT DVDD pfet_06v0 ad=58.1134p pd=77.985u as=58.1134p ps=77.985u w=76.465u l=1u
X1116 BAT GATE DVDD DVDD pfet_06v0 ad=35.511p pd=48.245u as=35.511p ps=48.245u w=46.725u l=1u
X1117 BAT GATE DVDD DVDD pfet_06v0 ad=58.1172p pd=77.99u as=58.1172p ps=77.99u w=76.47u l=1u
X1118 BAT GATE DVDD DVDD pfet_06v0 ad=35.511p pd=48.245u as=35.511p ps=48.245u w=46.725u l=1u
X1119 DVDD GATE BAT DVDD pfet_06v0 ad=71.8771p pd=0.15481m as=58.1134p ps=77.985u w=76.465u l=1u
X1120 BAT GATE DVDD DVDD pfet_06v0 ad=35.511p pd=48.245u as=35.511p ps=48.245u w=46.725u l=1u
X1121 BAT GATE DVDD DVDD pfet_06v0 ad=58.1134p pd=77.985u as=58.1134p ps=77.985u w=76.465u l=1u
X1122 DVDD GATE BAT DVDD pfet_06v0 ad=49.3848p pd=66.5u as=49.3848p ps=66.5u w=64.98u l=1u
X1123 DVDD GATE BAT DVDD pfet_06v0 ad=58.1134p pd=77.985u as=58.1134p ps=77.985u w=76.465u l=1u
X1124 DVDD GATE BAT DVDD pfet_06v0 ad=49.3848p pd=66.5u as=49.3848p ps=66.5u w=64.98u l=1u
X1125 BAT GATE DVDD DVDD pfet_06v0 ad=49.3848p pd=66.5u as=61.0812p ps=0.13184m w=64.98u l=1u
X1126 BAT GATE DVDD DVDD pfet_06v0 ad=35.511p pd=48.245u as=43.9215p ps=95.32999u w=46.725u l=1u
X1127 DVDD GATE BAT DVDD pfet_06v0 ad=35.511p pd=48.245u as=35.511p ps=48.245u w=46.725u l=1u
X1128 DVDD GATE BAT DVDD pfet_06v0 ad=58.1172p pd=77.99u as=58.1172p ps=77.99u w=76.47u l=1u
X1129 BAT GATE DVDD DVDD pfet_06v0 ad=35.511p pd=48.245u as=35.511p ps=48.245u w=46.725u l=1u
X1130 DVDD GATE BAT DVDD pfet_06v0 ad=35.511p pd=48.245u as=35.511p ps=48.245u w=46.725u l=1u
X1131 BAT GATE DVDD DVDD pfet_06v0 ad=58.1096p pd=77.98u as=58.1096p ps=77.98u w=76.46u l=1u
X1132 DVDD GATE BAT DVDD pfet_06v0 ad=35.5072p pd=48.24u as=35.5072p ps=48.24u w=46.72u l=1u
X1133 DVDD GATE BAT DVDD pfet_06v0 ad=35.511p pd=48.245u as=35.511p ps=48.245u w=46.725u l=1u
X1134 DVDD GATE BAT DVDD pfet_06v0 ad=71.8771p pd=0.15481m as=58.1134p ps=77.985u w=76.465u l=1u
X1135 DVDD GATE BAT DVDD pfet_06v0 ad=43.9168p pd=95.32u as=35.5072p ps=48.24u w=46.72u l=1u
X1136 BAT GATE DVDD DVDD pfet_06v0 ad=35.511p pd=48.245u as=35.511p ps=48.245u w=46.725u l=1u
X1137 DVDD GATE BAT DVDD pfet_06v0 ad=58.1134p pd=77.985u as=58.1134p ps=77.985u w=76.465u l=1u
X1138 BAT GATE DVDD DVDD pfet_06v0 ad=35.511p pd=48.245u as=35.511p ps=48.245u w=46.725u l=1u
X1139 BAT GATE DVDD DVDD pfet_06v0 ad=35.511p pd=48.245u as=35.511p ps=48.245u w=46.725u l=1u
X1140 BAT GATE DVDD DVDD pfet_06v0 ad=35.5072p pd=48.24u as=35.5072p ps=48.24u w=46.72u l=1u
X1141 DVDD GATE BAT DVDD pfet_06v0 ad=58.1172p pd=77.99u as=58.1172p ps=77.99u w=76.47u l=1u
X1142 BAT GATE DVDD DVDD pfet_06v0 ad=58.1134p pd=77.985u as=58.1134p ps=77.985u w=76.465u l=1u
X1143 DVDD GATE BAT DVDD pfet_06v0 ad=35.511p pd=48.245u as=35.511p ps=48.245u w=46.725u l=1u
X1144 BAT GATE DVDD DVDD pfet_06v0 ad=58.1172p pd=77.99u as=58.1172p ps=77.99u w=76.47u l=1u
X1145 DVDD GATE BAT DVDD pfet_06v0 ad=58.1134p pd=77.985u as=58.1134p ps=77.985u w=76.465u l=1u
X1146 BAT GATE DVDD DVDD pfet_06v0 ad=35.511p pd=48.245u as=35.511p ps=48.245u w=46.725u l=1u
X1147 BAT GATE DVDD DVDD pfet_06v0 ad=58.1552p pd=78.04u as=58.1552p ps=78.04u w=76.52u l=1u
X1148 DVDD GATE BAT DVDD pfet_06v0 ad=58.1134p pd=77.985u as=58.1134p ps=77.985u w=76.465u l=1u
X1149 DVDD GATE BAT DVDD pfet_06v0 ad=47.6862p pd=64.265u as=47.6862p ps=64.265u w=62.745u l=1u
X1150 DVDD GATE BAT DVDD pfet_06v0 ad=35.511p pd=48.245u as=35.511p ps=48.245u w=46.725u l=1u
X1151 BAT GATE DVDD DVDD pfet_06v0 ad=58.1134p pd=77.985u as=58.1134p ps=77.985u w=76.465u l=1u
X1152 BAT GATE DVDD DVDD pfet_06v0 ad=35.511p pd=48.245u as=35.511p ps=48.245u w=46.725u l=1u
X1153 BAT GATE DVDD DVDD pfet_06v0 ad=58.1134p pd=77.985u as=58.1134p ps=77.985u w=76.465u l=1u
X1154 BAT GATE DVDD DVDD pfet_06v0 ad=58.1134p pd=77.985u as=58.1134p ps=77.985u w=76.465u l=1u
X1155 DVDD GATE BAT DVDD pfet_06v0 ad=35.511p pd=48.245u as=35.511p ps=48.245u w=46.725u l=1u
X1156 BAT GATE DVDD DVDD pfet_06v0 ad=58.1134p pd=77.985u as=58.1134p ps=77.985u w=76.465u l=1u
X1157 BAT GATE DVDD DVDD pfet_06v0 ad=58.1172p pd=77.99u as=58.1172p ps=77.99u w=76.47u l=1u
X1158 BAT GATE DVDD DVDD pfet_06v0 ad=35.511p pd=48.245u as=43.9215p ps=95.32999u w=46.725u l=1u
X1159 DVDD GATE BAT DVDD pfet_06v0 ad=35.511p pd=48.245u as=35.511p ps=48.245u w=46.725u l=1u
X1160 BAT GATE DVDD DVDD pfet_06v0 ad=58.1172p pd=77.99u as=58.1172p ps=77.99u w=76.47u l=1u
X1161 BAT GATE DVDD DVDD pfet_06v0 ad=35.511p pd=48.245u as=43.9215p ps=95.32999u w=46.725u l=1u
X1162 BAT GATE DVDD DVDD pfet_06v0 ad=58.1134p pd=77.985u as=58.1134p ps=77.985u w=76.465u l=1u
X1163 DVDD GATE BAT DVDD pfet_06v0 ad=58.1134p pd=77.985u as=58.1134p ps=77.985u w=76.465u l=1u
X1164 DVDD GATE BAT DVDD pfet_06v0 ad=58.1134p pd=77.985u as=58.1134p ps=77.985u w=76.465u l=1u
X1165 DVDD GATE BAT DVDD pfet_06v0 ad=58.1172p pd=77.99u as=58.1172p ps=77.99u w=76.47u l=1u
X1166 BAT GATE DVDD DVDD pfet_06v0 ad=35.511p pd=48.245u as=35.511p ps=48.245u w=46.725u l=1u
X1167 DVDD GATE BAT DVDD pfet_06v0 ad=58.1134p pd=77.985u as=58.1134p ps=77.985u w=76.465u l=1u
X1168 BAT GATE DVDD DVDD pfet_06v0 ad=35.511p pd=48.245u as=35.511p ps=48.245u w=46.725u l=1u
X1169 BAT GATE DVDD DVDD pfet_06v0 ad=35.511p pd=48.245u as=35.511p ps=48.245u w=46.725u l=1u
X1170 DVDD GATE BAT DVDD pfet_06v0 ad=35.5072p pd=48.24u as=35.5072p ps=48.24u w=46.72u l=1u
X1171 BAT GATE DVDD DVDD pfet_06v0 ad=58.1134p pd=77.985u as=58.1134p ps=77.985u w=76.465u l=1u
X1172 BAT GATE DVDD DVDD pfet_06v0 ad=35.511p pd=48.245u as=35.511p ps=48.245u w=46.725u l=1u
X1173 DVDD GATE BAT DVDD pfet_06v0 ad=49.3848p pd=66.5u as=49.3848p ps=66.5u w=64.98u l=1u
X1174 BAT GATE DVDD DVDD pfet_06v0 ad=58.1552p pd=78.04u as=58.1552p ps=78.04u w=76.52u l=1u
X1175 BAT GATE DVDD DVDD pfet_06v0 ad=35.511p pd=48.245u as=35.511p ps=48.245u w=46.725u l=1u
X1176 BAT GATE DVDD DVDD pfet_06v0 ad=58.1134p pd=77.985u as=58.1134p ps=77.985u w=76.465u l=1u
X1177 DVDD GATE BAT DVDD pfet_06v0 ad=58.1134p pd=77.985u as=58.1134p ps=77.985u w=76.465u l=1u
X1178 DVDD GATE BAT DVDD pfet_06v0 ad=58.1134p pd=77.985u as=58.1134p ps=77.985u w=76.465u l=1u
X1179 DVDD GATE BAT DVDD pfet_06v0 ad=71.8771p pd=0.15481m as=58.1134p ps=77.985u w=76.465u l=1u
X1180 DVDD GATE BAT DVDD pfet_06v0 ad=58.1134p pd=77.985u as=58.1134p ps=77.985u w=76.465u l=1u
X1181 DVDD GATE BAT DVDD pfet_06v0 ad=35.511p pd=48.245u as=35.511p ps=48.245u w=46.725u l=1u
X1182 BAT GATE DVDD DVDD pfet_06v0 ad=58.0754p pd=77.935u as=58.0754p ps=77.935u w=76.41499u l=1u
X1183 BAT GATE DVDD DVDD pfet_06v0 ad=58.1134p pd=77.985u as=58.1134p ps=77.985u w=76.465u l=1u
X1184 DVDD GATE BAT DVDD pfet_06v0 ad=43.9215p pd=95.32999u as=35.511p ps=48.245u w=46.725u l=1u
X1185 DVDD GATE BAT DVDD pfet_06v0 ad=58.1552p pd=78.04u as=58.1552p ps=78.04u w=76.52u l=1u
X1186 DVDD GATE BAT DVDD pfet_06v0 ad=43.9215p pd=95.32999u as=35.511p ps=48.245u w=46.725u l=1u
X1187 BAT GATE DVDD DVDD pfet_06v0 ad=35.511p pd=48.245u as=35.511p ps=48.245u w=46.725u l=1u
X1188 BAT GATE DVDD DVDD pfet_06v0 ad=35.511p pd=48.245u as=35.511p ps=48.245u w=46.725u l=1u
X1189 DVDD GATE BAT DVDD pfet_06v0 ad=58.1134p pd=77.985u as=58.1134p ps=77.985u w=76.465u l=1u
X1190 DVDD GATE BAT DVDD pfet_06v0 ad=58.1134p pd=77.985u as=58.1134p ps=77.985u w=76.465u l=1u
X1191 DVDD GATE BAT DVDD pfet_06v0 ad=58.1096p pd=77.98u as=58.1096p ps=77.98u w=76.46u l=1u
X1192 BAT GATE DVDD DVDD pfet_06v0 ad=58.0754p pd=77.935u as=58.0754p ps=77.935u w=76.41499u l=1u
X1193 DVDD GATE BAT DVDD pfet_06v0 ad=71.8724p pd=0.1548m as=58.1096p ps=77.98u w=76.46u l=1u
X1194 BAT GATE DVDD DVDD pfet_06v0 ad=58.1134p pd=77.985u as=71.8771p ps=0.15481m w=76.465u l=1u
X1195 BAT GATE DVDD DVDD pfet_06v0 ad=35.511p pd=48.245u as=35.511p ps=48.245u w=46.725u l=1u
X1196 DVDD GATE BAT DVDD pfet_06v0 ad=49.3848p pd=66.5u as=49.3848p ps=66.5u w=64.98u l=1u
X1197 BAT GATE DVDD DVDD pfet_06v0 ad=58.1134p pd=77.985u as=71.8771p ps=0.15481m w=76.465u l=1u
X1198 DVDD GATE BAT DVDD pfet_06v0 ad=35.511p pd=48.245u as=35.511p ps=48.245u w=46.725u l=1u
X1199 DVDD GATE BAT DVDD pfet_06v0 ad=58.0754p pd=77.935u as=58.0754p ps=77.935u w=76.41499u l=1u
X1200 DVDD GATE BAT DVDD pfet_06v0 ad=35.511p pd=48.245u as=35.511p ps=48.245u w=46.725u l=1u
X1201 DVDD GATE BAT DVDD pfet_06v0 ad=35.511p pd=48.245u as=35.511p ps=48.245u w=46.725u l=1u
X1202 BAT GATE DVDD DVDD pfet_06v0 ad=35.511p pd=48.245u as=35.511p ps=48.245u w=46.725u l=1u
X1203 DVDD GATE BAT DVDD pfet_06v0 ad=35.5072p pd=48.24u as=35.5072p ps=48.24u w=46.72u l=1u
X1204 DVDD GATE BAT DVDD pfet_06v0 ad=35.511p pd=48.245u as=35.511p ps=48.245u w=46.725u l=1u
X1205 DVDD GATE BAT DVDD pfet_06v0 ad=35.511p pd=48.245u as=35.511p ps=48.245u w=46.725u l=1u
X1206 BAT GATE DVDD DVDD pfet_06v0 ad=58.1096p pd=77.98u as=58.1096p ps=77.98u w=76.46u l=1u
X1207 BAT GATE DVDD DVDD pfet_06v0 ad=58.1134p pd=77.985u as=58.1134p ps=77.985u w=76.465u l=1u
X1208 BAT GATE DVDD DVDD pfet_06v0 ad=35.511p pd=48.245u as=35.511p ps=48.245u w=46.725u l=1u
X1209 BAT GATE DVDD DVDD pfet_06v0 ad=47.6862p pd=64.265u as=58.9803p ps=0.12737m w=62.745u l=1u
X1210 BAT GATE DVDD DVDD pfet_06v0 ad=47.6862p pd=64.265u as=47.6862p ps=64.265u w=62.745u l=1u
X1211 BAT GATE DVDD DVDD pfet_06v0 ad=35.511p pd=48.245u as=35.511p ps=48.245u w=46.725u l=1u
X1212 BAT GATE DVDD DVDD pfet_06v0 ad=58.1134p pd=77.985u as=58.1134p ps=77.985u w=76.465u l=1u
X1213 DVDD GATE BAT DVDD pfet_06v0 ad=35.511p pd=48.245u as=35.511p ps=48.245u w=46.725u l=1u
X1214 DVDD GATE BAT DVDD pfet_06v0 ad=71.8301p pd=0.15471m as=58.0754p ps=77.935u w=76.41499u l=1u
X1215 BAT GATE DVDD DVDD pfet_06v0 ad=58.1134p pd=77.985u as=58.1134p ps=77.985u w=76.465u l=1u
X1216 BAT GATE DVDD DVDD pfet_06v0 ad=35.511p pd=48.245u as=35.511p ps=48.245u w=46.725u l=1u
X1217 BAT GATE DVDD DVDD pfet_06v0 ad=47.6862p pd=64.265u as=47.6862p ps=64.265u w=62.745u l=1u
X1218 BAT GATE DVDD DVDD pfet_06v0 ad=35.5072p pd=48.24u as=35.5072p ps=48.24u w=46.72u l=1u
X1219 DVDD GATE BAT DVDD pfet_06v0 ad=47.6862p pd=64.265u as=47.6862p ps=64.265u w=62.745u l=1u
X1220 DVDD GATE BAT DVDD pfet_06v0 ad=58.1134p pd=77.985u as=58.1134p ps=77.985u w=76.465u l=1u
X1221 BAT GATE DVDD DVDD pfet_06v0 ad=35.5072p pd=48.24u as=35.5072p ps=48.24u w=46.72u l=1u
X1222 BAT GATE DVDD DVDD pfet_06v0 ad=58.1134p pd=77.985u as=58.1134p ps=77.985u w=76.465u l=1u
X1223 DVDD GATE BAT DVDD pfet_06v0 ad=58.1134p pd=77.985u as=58.1134p ps=77.985u w=76.465u l=1u
X1224 DVDD GATE BAT DVDD pfet_06v0 ad=58.1134p pd=77.985u as=58.1134p ps=77.985u w=76.465u l=1u
X1225 DVDD GATE BAT DVDD pfet_06v0 ad=35.511p pd=48.245u as=35.511p ps=48.245u w=46.725u l=1u
X1226 DVDD GATE BAT DVDD pfet_06v0 ad=58.1134p pd=77.985u as=58.1134p ps=77.985u w=76.465u l=1u
X1227 DVDD GATE BAT DVDD pfet_06v0 ad=35.511p pd=48.245u as=35.511p ps=48.245u w=46.725u l=1u
X1228 DVDD GATE BAT DVDD pfet_06v0 ad=58.1134p pd=77.985u as=58.1134p ps=77.985u w=76.465u l=1u
X1229 BAT GATE DVDD DVDD pfet_06v0 ad=35.511p pd=48.245u as=35.511p ps=48.245u w=46.725u l=1u
X1230 DVDD GATE BAT DVDD pfet_06v0 ad=35.511p pd=48.245u as=35.511p ps=48.245u w=46.725u l=1u
X1231 DVDD GATE BAT DVDD pfet_06v0 ad=71.8771p pd=0.15481m as=58.1134p ps=77.985u w=76.465u l=1u
X1232 BAT GATE DVDD DVDD pfet_06v0 ad=58.1134p pd=77.985u as=58.1134p ps=77.985u w=76.465u l=1u
X1233 DVDD GATE BAT DVDD pfet_06v0 ad=35.511p pd=48.245u as=35.511p ps=48.245u w=46.725u l=1u
X1234 DVDD GATE BAT DVDD pfet_06v0 ad=58.1134p pd=77.985u as=58.1134p ps=77.985u w=76.465u l=1u
X1235 DVDD GATE BAT DVDD pfet_06v0 ad=71.8771p pd=0.15481m as=58.1134p ps=77.985u w=76.465u l=1u
X1236 DVDD GATE BAT DVDD pfet_06v0 ad=35.511p pd=48.245u as=35.511p ps=48.245u w=46.725u l=1u
X1237 BAT GATE DVDD DVDD pfet_06v0 ad=58.1134p pd=77.985u as=58.1134p ps=77.985u w=76.465u l=1u
X1238 BAT GATE DVDD DVDD pfet_06v0 ad=35.5072p pd=48.24u as=35.5072p ps=48.24u w=46.72u l=1u
X1239 DVDD GATE BAT DVDD pfet_06v0 ad=35.511p pd=48.245u as=35.511p ps=48.245u w=46.725u l=1u
X1240 DVDD GATE BAT DVDD pfet_06v0 ad=58.0754p pd=77.935u as=58.0754p ps=77.935u w=76.41499u l=1u
X1241 BAT GATE DVDD DVDD pfet_06v0 ad=58.1134p pd=77.985u as=58.1134p ps=77.985u w=76.465u l=1u
X1242 DVDD GATE BAT DVDD pfet_06v0 ad=35.511p pd=48.245u as=35.511p ps=48.245u w=46.725u l=1u
X1243 BAT GATE DVDD DVDD pfet_06v0 ad=58.1134p pd=77.985u as=58.1134p ps=77.985u w=76.465u l=1u
X1244 BAT GATE DVDD DVDD pfet_06v0 ad=35.511p pd=48.245u as=35.511p ps=48.245u w=46.725u l=1u
X1245 DVDD GATE BAT DVDD pfet_06v0 ad=35.5072p pd=48.24u as=35.5072p ps=48.24u w=46.72u l=1u
X1246 DVDD GATE BAT DVDD pfet_06v0 ad=71.8771p pd=0.15481m as=58.1134p ps=77.985u w=76.465u l=1u
X1247 BAT GATE DVDD DVDD pfet_06v0 ad=35.511p pd=48.245u as=35.511p ps=48.245u w=46.725u l=1u
X1248 BAT GATE DVDD DVDD pfet_06v0 ad=35.511p pd=48.245u as=35.511p ps=48.245u w=46.725u l=1u
X1249 BAT GATE DVDD DVDD pfet_06v0 ad=58.1134p pd=77.985u as=71.8771p ps=0.15481m w=76.465u l=1u
X1250 DVDD GATE BAT DVDD pfet_06v0 ad=58.1172p pd=77.99u as=58.1172p ps=77.99u w=76.47u l=1u
X1251 DVDD GATE BAT DVDD pfet_06v0 ad=35.511p pd=48.245u as=35.511p ps=48.245u w=46.725u l=1u
X1252 BAT GATE DVDD DVDD pfet_06v0 ad=35.511p pd=48.245u as=35.511p ps=48.245u w=46.725u l=1u
X1253 BAT GATE DVDD DVDD pfet_06v0 ad=58.1134p pd=77.985u as=58.1134p ps=77.985u w=76.465u l=1u
X1254 DVDD GATE BAT DVDD pfet_06v0 ad=35.511p pd=48.245u as=35.511p ps=48.245u w=46.725u l=1u
X1255 BAT GATE DVDD DVDD pfet_06v0 ad=35.511p pd=48.245u as=43.9215p ps=95.32999u w=46.725u l=1u
X1256 BAT GATE DVDD DVDD pfet_06v0 ad=35.511p pd=48.245u as=35.511p ps=48.245u w=46.725u l=1u
X1257 BAT GATE DVDD DVDD pfet_06v0 ad=35.511p pd=48.245u as=35.511p ps=48.245u w=46.725u l=1u
X1258 DVDD GATE BAT DVDD pfet_06v0 ad=58.1134p pd=77.985u as=58.1134p ps=77.985u w=76.465u l=1u
X1259 DVDD GATE BAT DVDD pfet_06v0 ad=35.511p pd=48.245u as=35.511p ps=48.245u w=46.725u l=1u
X1260 DVDD GATE BAT DVDD pfet_06v0 ad=58.1134p pd=77.985u as=58.1134p ps=77.985u w=76.465u l=1u
X1261 BAT GATE DVDD DVDD pfet_06v0 ad=58.1096p pd=77.98u as=58.1096p ps=77.98u w=76.46u l=1u
X1262 BAT GATE DVDD DVDD pfet_06v0 ad=35.511p pd=48.245u as=35.511p ps=48.245u w=46.725u l=1u
X1263 DVDD GATE BAT DVDD pfet_06v0 ad=58.1134p pd=77.985u as=58.1134p ps=77.985u w=76.465u l=1u
X1264 BAT GATE DVDD DVDD pfet_06v0 ad=35.5072p pd=48.24u as=43.9168p ps=95.32u w=46.72u l=1u
X1265 BAT GATE DVDD DVDD pfet_06v0 ad=58.1134p pd=77.985u as=58.1134p ps=77.985u w=76.465u l=1u
X1266 DVDD GATE BAT DVDD pfet_06v0 ad=35.511p pd=48.245u as=35.511p ps=48.245u w=46.725u l=1u
X1267 BAT GATE DVDD DVDD pfet_06v0 ad=58.1134p pd=77.985u as=71.8771p ps=0.15481m w=76.465u l=1u
X1268 BAT GATE DVDD DVDD pfet_06v0 ad=58.1134p pd=77.985u as=58.1134p ps=77.985u w=76.465u l=1u
X1269 DVDD GATE BAT DVDD pfet_06v0 ad=58.1134p pd=77.985u as=58.1134p ps=77.985u w=76.465u l=1u
X1270 BAT GATE DVDD DVDD pfet_06v0 ad=35.511p pd=48.245u as=35.511p ps=48.245u w=46.725u l=1u
X1271 DVDD GATE BAT DVDD pfet_06v0 ad=35.511p pd=48.245u as=35.511p ps=48.245u w=46.725u l=1u
X1272 DVDD GATE BAT DVDD pfet_06v0 ad=35.511p pd=48.245u as=35.511p ps=48.245u w=46.725u l=1u
X1273 DVDD GATE BAT DVDD pfet_06v0 ad=35.511p pd=48.245u as=35.511p ps=48.245u w=46.725u l=1u
X1274 DVDD GATE BAT DVDD pfet_06v0 ad=35.511p pd=48.245u as=35.511p ps=48.245u w=46.725u l=1u
X1275 BAT GATE DVDD DVDD pfet_06v0 ad=49.3848p pd=66.5u as=49.3848p ps=66.5u w=64.98u l=1u
X1276 DVDD GATE BAT DVDD pfet_06v0 ad=35.511p pd=48.245u as=35.511p ps=48.245u w=46.725u l=1u
X1277 DVDD GATE BAT DVDD pfet_06v0 ad=58.1552p pd=78.04u as=58.1552p ps=78.04u w=76.52u l=1u
X1278 DVDD GATE BAT DVDD pfet_06v0 ad=71.8724p pd=0.1548m as=58.1096p ps=77.98u w=76.46u l=1u
X1279 BAT GATE DVDD DVDD pfet_06v0 ad=58.1134p pd=77.985u as=58.1134p ps=77.985u w=76.465u l=1u
X1280 DVDD GATE BAT DVDD pfet_06v0 ad=58.1134p pd=77.985u as=58.1134p ps=77.985u w=76.465u l=1u
X1281 BAT GATE DVDD DVDD pfet_06v0 ad=58.0754p pd=77.935u as=58.0754p ps=77.935u w=76.41499u l=1u
X1282 DVDD GATE BAT DVDD pfet_06v0 ad=35.511p pd=48.245u as=35.511p ps=48.245u w=46.725u l=1u
X1283 DVDD GATE BAT DVDD pfet_06v0 ad=35.511p pd=48.245u as=35.511p ps=48.245u w=46.725u l=1u
X1284 DVDD GATE BAT DVDD pfet_06v0 ad=35.511p pd=48.245u as=35.511p ps=48.245u w=46.725u l=1u
X1285 BAT GATE DVDD DVDD pfet_06v0 ad=58.1134p pd=77.985u as=58.1134p ps=77.985u w=76.465u l=1u
X1286 DVDD GATE BAT DVDD pfet_06v0 ad=43.9215p pd=95.32999u as=35.511p ps=48.245u w=46.725u l=1u
X1287 DVDD GATE BAT DVDD pfet_06v0 ad=43.9215p pd=95.32999u as=35.511p ps=48.245u w=46.725u l=1u
X1288 DVDD GATE BAT DVDD pfet_06v0 ad=58.1552p pd=78.04u as=58.1552p ps=78.04u w=76.52u l=1u
X1289 DVDD GATE BAT DVDD pfet_06v0 ad=58.1134p pd=77.985u as=58.1134p ps=77.985u w=76.465u l=1u
X1290 DVDD GATE BAT DVDD pfet_06v0 ad=71.8301p pd=0.15471m as=58.0754p ps=77.935u w=76.41499u l=1u
X1291 DVDD GATE BAT DVDD pfet_06v0 ad=71.8771p pd=0.15481m as=58.1134p ps=77.985u w=76.465u l=1u
X1292 BAT GATE DVDD DVDD pfet_06v0 ad=35.511p pd=48.245u as=35.511p ps=48.245u w=46.725u l=1u
X1293 BAT GATE DVDD DVDD pfet_06v0 ad=35.511p pd=48.245u as=35.511p ps=48.245u w=46.725u l=1u
X1294 BAT GATE DVDD DVDD pfet_06v0 ad=58.1134p pd=77.985u as=58.1134p ps=77.985u w=76.465u l=1u
X1295 DVDD GATE BAT DVDD pfet_06v0 ad=35.511p pd=48.245u as=35.511p ps=48.245u w=46.725u l=1u
X1296 BAT GATE DVDD DVDD pfet_06v0 ad=35.511p pd=48.245u as=35.511p ps=48.245u w=46.725u l=1u
X1297 DVDD GATE BAT DVDD pfet_06v0 ad=43.9168p pd=95.32u as=35.5072p ps=48.24u w=46.72u l=1u
X1298 BAT GATE DVDD DVDD pfet_06v0 ad=58.1134p pd=77.985u as=58.1134p ps=77.985u w=76.465u l=1u
X1299 BAT GATE DVDD DVDD pfet_06v0 ad=58.1552p pd=78.04u as=58.1552p ps=78.04u w=76.52u l=1u
X1300 DVDD GATE BAT DVDD pfet_06v0 ad=35.511p pd=48.245u as=35.511p ps=48.245u w=46.725u l=1u
X1301 BAT GATE DVDD DVDD pfet_06v0 ad=58.1134p pd=77.985u as=58.1134p ps=77.985u w=76.465u l=1u
X1302 BAT GATE DVDD DVDD pfet_06v0 ad=58.1134p pd=77.985u as=58.1134p ps=77.985u w=76.465u l=1u
X1303 BAT GATE DVDD DVDD pfet_06v0 ad=35.511p pd=48.245u as=43.9215p ps=95.32999u w=46.725u l=1u
X1304 DVDD GATE BAT DVDD pfet_06v0 ad=35.5072p pd=48.24u as=35.5072p ps=48.24u w=46.72u l=1u
X1305 DVDD GATE BAT DVDD pfet_06v0 ad=58.1134p pd=77.985u as=58.1134p ps=77.985u w=76.465u l=1u
X1306 BAT GATE DVDD DVDD pfet_06v0 ad=58.1134p pd=77.985u as=58.1134p ps=77.985u w=76.465u l=1u
X1307 BAT GATE DVDD DVDD pfet_06v0 ad=35.511p pd=48.245u as=35.511p ps=48.245u w=46.725u l=1u
X1308 BAT GATE DVDD DVDD pfet_06v0 ad=58.0754p pd=77.935u as=58.0754p ps=77.935u w=76.41499u l=1u
X1309 BAT GATE DVDD DVDD pfet_06v0 ad=49.3848p pd=66.5u as=49.3848p ps=66.5u w=64.98u l=1u
X1310 BAT GATE DVDD DVDD pfet_06v0 ad=58.1134p pd=77.985u as=71.8771p ps=0.15481m w=76.465u l=1u
X1311 BAT GATE DVDD DVDD pfet_06v0 ad=58.1096p pd=77.98u as=58.1096p ps=77.98u w=76.46u l=1u
X1312 BAT GATE DVDD DVDD pfet_06v0 ad=35.511p pd=48.245u as=35.511p ps=48.245u w=46.725u l=1u
X1313 DVDD GATE BAT DVDD pfet_06v0 ad=71.8818p pd=0.15482m as=58.1172p ps=77.99u w=76.47u l=1u
X1314 BAT GATE DVDD DVDD pfet_06v0 ad=58.1134p pd=77.985u as=71.8771p ps=0.15481m w=76.465u l=1u
X1315 BAT GATE DVDD DVDD pfet_06v0 ad=35.511p pd=48.245u as=43.9215p ps=95.32999u w=46.725u l=1u
X1316 DVDD GATE BAT DVDD pfet_06v0 ad=35.511p pd=48.245u as=35.511p ps=48.245u w=46.725u l=1u
X1317 BAT GATE DVDD DVDD pfet_06v0 ad=35.5072p pd=48.24u as=35.5072p ps=48.24u w=46.72u l=1u
X1318 BAT GATE DVDD DVDD pfet_06v0 ad=35.511p pd=48.245u as=35.511p ps=48.245u w=46.725u l=1u
X1319 BAT GATE DVDD DVDD pfet_06v0 ad=58.1172p pd=77.99u as=71.8818p ps=0.15482m w=76.47u l=1u
X1320 DVDD GATE BAT DVDD pfet_06v0 ad=58.1134p pd=77.985u as=58.1134p ps=77.985u w=76.465u l=1u
X1321 DVDD GATE BAT DVDD pfet_06v0 ad=58.1096p pd=77.98u as=58.1096p ps=77.98u w=76.46u l=1u
X1322 BAT GATE DVDD DVDD pfet_06v0 ad=35.511p pd=48.245u as=35.511p ps=48.245u w=46.725u l=1u
X1323 BAT GATE DVDD DVDD pfet_06v0 ad=58.0754p pd=77.935u as=58.0754p ps=77.935u w=76.41499u l=1u
X1324 BAT GATE DVDD DVDD pfet_06v0 ad=47.6862p pd=64.265u as=58.9803p ps=0.12737m w=62.745u l=1u
X1325 DVDD GATE BAT DVDD pfet_06v0 ad=58.1134p pd=77.985u as=58.1134p ps=77.985u w=76.465u l=1u
X1326 DVDD GATE BAT DVDD pfet_06v0 ad=35.511p pd=48.245u as=35.511p ps=48.245u w=46.725u l=1u
X1327 DVDD GATE BAT DVDD pfet_06v0 ad=43.9215p pd=95.32999u as=35.511p ps=48.245u w=46.725u l=1u
X1328 DVDD GATE BAT DVDD pfet_06v0 ad=43.9215p pd=95.32999u as=35.511p ps=48.245u w=46.725u l=1u
X1329 BAT GATE DVDD DVDD pfet_06v0 ad=35.511p pd=48.245u as=35.511p ps=48.245u w=46.725u l=1u
X1330 DVDD GATE BAT DVDD pfet_06v0 ad=58.1134p pd=77.985u as=58.1134p ps=77.985u w=76.465u l=1u
X1331 BAT GATE DVDD DVDD pfet_06v0 ad=58.1172p pd=77.99u as=58.1172p ps=77.99u w=76.47u l=1u
X1332 DVDD GATE BAT DVDD pfet_06v0 ad=58.1134p pd=77.985u as=58.1134p ps=77.985u w=76.465u l=1u
X1333 DVDD GATE BAT DVDD pfet_06v0 ad=71.8771p pd=0.15481m as=58.1134p ps=77.985u w=76.465u l=1u
X1334 DVDD GATE BAT DVDD pfet_06v0 ad=35.5072p pd=48.24u as=35.5072p ps=48.24u w=46.72u l=1u
X1335 DVDD GATE BAT DVDD pfet_06v0 ad=58.1096p pd=77.98u as=58.1096p ps=77.98u w=76.46u l=1u
X1336 DVDD GATE BAT DVDD pfet_06v0 ad=47.6862p pd=64.265u as=47.6862p ps=64.265u w=62.745u l=1u
X1337 BAT GATE DVDD DVDD pfet_06v0 ad=58.1134p pd=77.985u as=58.1134p ps=77.985u w=76.465u l=1u
X1338 DVDD GATE BAT DVDD pfet_06v0 ad=71.8724p pd=0.1548m as=58.1096p ps=77.98u w=76.46u l=1u
X1339 BAT GATE DVDD DVDD pfet_06v0 ad=58.1096p pd=77.98u as=58.1096p ps=77.98u w=76.46u l=1u
X1340 BAT GATE DVDD DVDD pfet_06v0 ad=35.511p pd=48.245u as=35.511p ps=48.245u w=46.725u l=1u
X1341 BAT GATE DVDD DVDD pfet_06v0 ad=35.511p pd=48.245u as=35.511p ps=48.245u w=46.725u l=1u
X1342 BAT GATE DVDD DVDD pfet_06v0 ad=58.1134p pd=77.985u as=58.1134p ps=77.985u w=76.465u l=1u
X1343 BAT GATE DVDD DVDD pfet_06v0 ad=58.1134p pd=77.985u as=58.1134p ps=77.985u w=76.465u l=1u
X1344 DVDD GATE BAT DVDD pfet_06v0 ad=58.0754p pd=77.935u as=58.0754p ps=77.935u w=76.41499u l=1u
X1345 BAT GATE DVDD DVDD pfet_06v0 ad=35.511p pd=48.245u as=35.511p ps=48.245u w=46.725u l=1u
X1346 BAT GATE DVDD DVDD pfet_06v0 ad=35.511p pd=48.245u as=43.9215p ps=95.32999u w=46.725u l=1u
X1347 DVDD GATE BAT DVDD pfet_06v0 ad=58.1134p pd=77.985u as=58.1134p ps=77.985u w=76.465u l=1u
X1348 DVDD GATE BAT DVDD pfet_06v0 ad=35.511p pd=48.245u as=35.511p ps=48.245u w=46.725u l=1u
X1349 BAT GATE DVDD DVDD pfet_06v0 ad=58.0754p pd=77.935u as=71.8301p ps=0.15471m w=76.41499u l=1u
X1350 DVDD GATE BAT DVDD pfet_06v0 ad=58.1134p pd=77.985u as=58.1134p ps=77.985u w=76.465u l=1u
X1351 DVDD GATE BAT DVDD pfet_06v0 ad=35.511p pd=48.245u as=35.511p ps=48.245u w=46.725u l=1u
X1352 BAT GATE DVDD DVDD pfet_06v0 ad=47.6862p pd=64.265u as=47.6862p ps=64.265u w=62.745u l=1u
X1353 BAT GATE DVDD DVDD pfet_06v0 ad=58.1134p pd=77.985u as=58.1134p ps=77.985u w=76.465u l=1u
X1354 BAT GATE DVDD DVDD pfet_06v0 ad=58.0754p pd=77.935u as=58.0754p ps=77.935u w=76.41499u l=1u
X1355 BAT GATE DVDD DVDD pfet_06v0 ad=58.1172p pd=77.99u as=58.1172p ps=77.99u w=76.47u l=1u
X1356 DVDD GATE BAT DVDD pfet_06v0 ad=35.511p pd=48.245u as=35.511p ps=48.245u w=46.725u l=1u
X1357 DVDD GATE BAT DVDD pfet_06v0 ad=35.511p pd=48.245u as=35.511p ps=48.245u w=46.725u l=1u
X1358 BAT GATE DVDD DVDD pfet_06v0 ad=35.5072p pd=48.24u as=35.5072p ps=48.24u w=46.72u l=1u
X1359 DVDD GATE BAT DVDD pfet_06v0 ad=43.9215p pd=95.32999u as=35.511p ps=48.245u w=46.725u l=1u
X1360 DVDD GATE BAT DVDD pfet_06v0 ad=35.511p pd=48.245u as=35.511p ps=48.245u w=46.725u l=1u
X1361 DVDD GATE BAT DVDD pfet_06v0 ad=35.511p pd=48.245u as=35.511p ps=48.245u w=46.725u l=1u
X1362 BAT GATE DVDD DVDD pfet_06v0 ad=35.511p pd=48.245u as=35.511p ps=48.245u w=46.725u l=1u
X1363 BAT GATE DVDD DVDD pfet_06v0 ad=58.1134p pd=77.985u as=58.1134p ps=77.985u w=76.465u l=1u
X1364 DVDD GATE BAT DVDD pfet_06v0 ad=71.8818p pd=0.15482m as=58.1172p ps=77.99u w=76.47u l=1u
X1365 DVDD GATE BAT DVDD pfet_06v0 ad=35.511p pd=48.245u as=35.511p ps=48.245u w=46.725u l=1u
X1366 DVDD GATE BAT DVDD pfet_06v0 ad=58.1096p pd=77.98u as=58.1096p ps=77.98u w=76.46u l=1u
X1367 BAT GATE DVDD DVDD pfet_06v0 ad=58.1172p pd=77.99u as=58.1172p ps=77.99u w=76.47u l=1u
X1368 DVDD GATE BAT DVDD pfet_06v0 ad=43.9215p pd=95.32999u as=35.511p ps=48.245u w=46.725u l=1u
X1369 BAT GATE DVDD DVDD pfet_06v0 ad=58.1134p pd=77.985u as=58.1134p ps=77.985u w=76.465u l=1u
X1370 BAT GATE DVDD DVDD pfet_06v0 ad=35.511p pd=48.245u as=35.511p ps=48.245u w=46.725u l=1u
X1371 DVDD GATE BAT DVDD pfet_06v0 ad=61.0812p pd=0.13184m as=49.3848p ps=66.5u w=64.98u l=1u
X1372 BAT GATE DVDD DVDD pfet_06v0 ad=58.1134p pd=77.985u as=58.1134p ps=77.985u w=76.465u l=1u
X1373 DVDD GATE BAT DVDD pfet_06v0 ad=58.0754p pd=77.935u as=58.0754p ps=77.935u w=76.41499u l=1u
X1374 DVDD GATE BAT DVDD pfet_06v0 ad=35.511p pd=48.245u as=35.511p ps=48.245u w=46.725u l=1u
X1375 DVDD GATE BAT DVDD pfet_06v0 ad=58.1134p pd=77.985u as=58.1134p ps=77.985u w=76.465u l=1u
X1376 BAT GATE DVDD DVDD pfet_06v0 ad=49.3848p pd=66.5u as=49.3848p ps=66.5u w=64.98u l=1u
X1377 BAT GATE DVDD DVDD pfet_06v0 ad=35.511p pd=48.245u as=35.511p ps=48.245u w=46.725u l=1u
X1378 BAT GATE DVDD DVDD pfet_06v0 ad=35.511p pd=48.245u as=35.511p ps=48.245u w=46.725u l=1u
X1379 BAT GATE DVDD DVDD pfet_06v0 ad=58.1552p pd=78.04u as=71.92879p ps=0.15492m w=76.52u l=1u
X1380 DVDD GATE BAT DVDD pfet_06v0 ad=58.1134p pd=77.985u as=58.1134p ps=77.985u w=76.465u l=1u
X1381 BAT GATE DVDD DVDD pfet_06v0 ad=35.511p pd=48.245u as=43.9215p ps=95.32999u w=46.725u l=1u
X1382 DVDD GATE BAT DVDD pfet_06v0 ad=58.1134p pd=77.985u as=58.1134p ps=77.985u w=76.465u l=1u
X1383 BAT GATE DVDD DVDD pfet_06v0 ad=58.1096p pd=77.98u as=58.1096p ps=77.98u w=76.46u l=1u
X1384 BAT GATE DVDD DVDD pfet_06v0 ad=58.1134p pd=77.985u as=58.1134p ps=77.985u w=76.465u l=1u
X1385 DVDD GATE BAT DVDD pfet_06v0 ad=58.1134p pd=77.985u as=58.1134p ps=77.985u w=76.465u l=1u
X1386 DVDD GATE BAT DVDD pfet_06v0 ad=35.511p pd=48.245u as=35.511p ps=48.245u w=46.725u l=1u
X1387 DVDD GATE BAT DVDD pfet_06v0 ad=58.1134p pd=77.985u as=58.1134p ps=77.985u w=76.465u l=1u
X1388 BAT GATE DVDD DVDD pfet_06v0 ad=58.1134p pd=77.985u as=71.8771p ps=0.15481m w=76.465u l=1u
X1389 BAT GATE DVDD DVDD pfet_06v0 ad=35.511p pd=48.245u as=35.511p ps=48.245u w=46.725u l=1u
X1390 DVDD GATE BAT DVDD pfet_06v0 ad=58.1172p pd=77.99u as=58.1172p ps=77.99u w=76.47u l=1u
X1391 BAT GATE DVDD DVDD pfet_06v0 ad=35.511p pd=48.245u as=35.511p ps=48.245u w=46.725u l=1u
X1392 DVDD GATE BAT DVDD pfet_06v0 ad=71.8771p pd=0.15481m as=58.1134p ps=77.985u w=76.465u l=1u
X1393 BAT GATE DVDD DVDD pfet_06v0 ad=35.511p pd=48.245u as=43.9215p ps=95.32999u w=46.725u l=1u
X1394 DVDD GATE BAT DVDD pfet_06v0 ad=43.9215p pd=95.32999u as=35.511p ps=48.245u w=46.725u l=1u
X1395 DVDD GATE BAT DVDD pfet_06v0 ad=58.1172p pd=77.99u as=58.1172p ps=77.99u w=76.47u l=1u
X1396 BAT GATE DVDD DVDD pfet_06v0 ad=58.1134p pd=77.985u as=58.1134p ps=77.985u w=76.465u l=1u
X1397 DVDD GATE BAT DVDD pfet_06v0 ad=58.1134p pd=77.985u as=58.1134p ps=77.985u w=76.465u l=1u
X1398 BAT GATE DVDD DVDD pfet_06v0 ad=35.5072p pd=48.24u as=35.5072p ps=48.24u w=46.72u l=1u
X1399 BAT GATE DVDD DVDD pfet_06v0 ad=58.1134p pd=77.985u as=71.8771p ps=0.15481m w=76.465u l=1u
X1400 BAT GATE DVDD DVDD pfet_06v0 ad=35.511p pd=48.245u as=35.511p ps=48.245u w=46.725u l=1u
X1401 BAT GATE DVDD DVDD pfet_06v0 ad=58.1134p pd=77.985u as=58.1134p ps=77.985u w=76.465u l=1u
X1402 BAT GATE DVDD DVDD pfet_06v0 ad=35.5072p pd=48.24u as=35.5072p ps=48.24u w=46.72u l=1u
X1403 DVDD GATE BAT DVDD pfet_06v0 ad=58.1096p pd=77.98u as=58.1096p ps=77.98u w=76.46u l=1u
X1404 DVDD GATE BAT DVDD pfet_06v0 ad=35.511p pd=48.245u as=35.511p ps=48.245u w=46.725u l=1u
X1405 DVDD GATE BAT DVDD pfet_06v0 ad=58.1134p pd=77.985u as=58.1134p ps=77.985u w=76.465u l=1u
X1406 DVDD GATE BAT DVDD pfet_06v0 ad=35.511p pd=48.245u as=35.511p ps=48.245u w=46.725u l=1u
X1407 DVDD GATE BAT DVDD pfet_06v0 ad=58.1134p pd=77.985u as=58.1134p ps=77.985u w=76.465u l=1u
X1408 DVDD GATE BAT DVDD pfet_06v0 ad=43.9215p pd=95.32999u as=35.511p ps=48.245u w=46.725u l=1u
X1409 BAT GATE DVDD DVDD pfet_06v0 ad=58.1134p pd=77.985u as=58.1134p ps=77.985u w=76.465u l=1u
X1410 DVDD GATE BAT DVDD pfet_06v0 ad=43.9215p pd=95.32999u as=35.511p ps=48.245u w=46.725u l=1u
X1411 BAT GATE DVDD DVDD pfet_06v0 ad=35.511p pd=48.245u as=35.511p ps=48.245u w=46.725u l=1u
X1412 DVDD GATE BAT DVDD pfet_06v0 ad=43.9215p pd=95.32999u as=35.511p ps=48.245u w=46.725u l=1u
X1413 DVDD GATE BAT DVDD pfet_06v0 ad=58.1552p pd=78.04u as=58.1552p ps=78.04u w=76.52u l=1u
X1414 BAT GATE DVDD DVDD pfet_06v0 ad=58.1134p pd=77.985u as=58.1134p ps=77.985u w=76.465u l=1u
X1415 BAT GATE DVDD DVDD pfet_06v0 ad=58.1552p pd=78.04u as=58.1552p ps=78.04u w=76.52u l=1u
X1416 BAT GATE DVDD DVDD pfet_06v0 ad=35.511p pd=48.245u as=35.511p ps=48.245u w=46.725u l=1u
X1417 DVDD GATE BAT DVDD pfet_06v0 ad=35.511p pd=48.245u as=35.511p ps=48.245u w=46.725u l=1u
X1418 DVDD GATE BAT DVDD pfet_06v0 ad=35.511p pd=48.245u as=35.511p ps=48.245u w=46.725u l=1u
X1419 DVDD GATE BAT DVDD pfet_06v0 ad=35.511p pd=48.245u as=35.511p ps=48.245u w=46.725u l=1u
X1420 BAT GATE DVDD DVDD pfet_06v0 ad=58.1134p pd=77.985u as=71.8771p ps=0.15481m w=76.465u l=1u
X1421 DVDD GATE BAT DVDD pfet_06v0 ad=35.511p pd=48.245u as=35.511p ps=48.245u w=46.725u l=1u
X1422 DVDD GATE BAT DVDD pfet_06v0 ad=58.0754p pd=77.935u as=58.0754p ps=77.935u w=76.41499u l=1u
X1423 BAT GATE DVDD DVDD pfet_06v0 ad=58.1134p pd=77.985u as=58.1134p ps=77.985u w=76.465u l=1u
X1424 BAT GATE DVDD DVDD pfet_06v0 ad=58.1134p pd=77.985u as=58.1134p ps=77.985u w=76.465u l=1u
X1425 BAT GATE DVDD DVDD pfet_06v0 ad=35.511p pd=48.245u as=35.511p ps=48.245u w=46.725u l=1u
X1426 BAT GATE DVDD DVDD pfet_06v0 ad=58.1096p pd=77.98u as=58.1096p ps=77.98u w=76.46u l=1u
X1427 BAT GATE DVDD DVDD pfet_06v0 ad=35.511p pd=48.245u as=35.511p ps=48.245u w=46.725u l=1u
X1428 DVDD GATE BAT DVDD pfet_06v0 ad=35.511p pd=48.245u as=35.511p ps=48.245u w=46.725u l=1u
X1429 BAT GATE DVDD DVDD pfet_06v0 ad=35.511p pd=48.245u as=35.511p ps=48.245u w=46.725u l=1u
X1430 BAT GATE DVDD DVDD pfet_06v0 ad=35.511p pd=48.245u as=35.511p ps=48.245u w=46.725u l=1u
X1431 BAT GATE DVDD DVDD pfet_06v0 ad=35.5072p pd=48.24u as=35.5072p ps=48.24u w=46.72u l=1u
X1432 BAT GATE DVDD DVDD pfet_06v0 ad=58.1134p pd=77.985u as=58.1134p ps=77.985u w=76.465u l=1u
X1433 DVDD GATE BAT DVDD pfet_06v0 ad=58.1134p pd=77.985u as=58.1134p ps=77.985u w=76.465u l=1u
X1434 DVDD GATE BAT DVDD pfet_06v0 ad=58.1134p pd=77.985u as=58.1134p ps=77.985u w=76.465u l=1u
X1435 DVDD GATE BAT DVDD pfet_06v0 ad=35.511p pd=48.245u as=35.511p ps=48.245u w=46.725u l=1u
X1436 BAT GATE DVDD DVDD pfet_06v0 ad=58.0754p pd=77.935u as=71.8301p ps=0.15471m w=76.41499u l=1u
X1437 BAT GATE DVDD DVDD pfet_06v0 ad=58.1096p pd=77.98u as=58.1096p ps=77.98u w=76.46u l=1u
X1438 BAT GATE DVDD DVDD pfet_06v0 ad=58.1134p pd=77.985u as=58.1134p ps=77.985u w=76.465u l=1u
X1439 BAT GATE DVDD DVDD pfet_06v0 ad=58.1096p pd=77.98u as=58.1096p ps=77.98u w=76.46u l=1u
X1440 DVDD GATE BAT DVDD pfet_06v0 ad=58.1096p pd=77.98u as=58.1096p ps=77.98u w=76.46u l=1u
X1441 BAT GATE DVDD DVDD pfet_06v0 ad=58.1134p pd=77.985u as=58.1134p ps=77.985u w=76.465u l=1u
X1442 DVDD GATE BAT DVDD pfet_06v0 ad=58.0754p pd=77.935u as=58.0754p ps=77.935u w=76.41499u l=1u
X1443 BAT GATE DVDD DVDD pfet_06v0 ad=35.511p pd=48.245u as=35.511p ps=48.245u w=46.725u l=1u
X1444 BAT GATE DVDD DVDD pfet_06v0 ad=35.511p pd=48.245u as=35.511p ps=48.245u w=46.725u l=1u
X1445 DVDD GATE BAT DVDD pfet_06v0 ad=58.1134p pd=77.985u as=58.1134p ps=77.985u w=76.465u l=1u
X1446 BAT GATE DVDD DVDD pfet_06v0 ad=35.5072p pd=48.24u as=35.5072p ps=48.24u w=46.72u l=1u
X1447 BAT GATE DVDD DVDD pfet_06v0 ad=58.1172p pd=77.99u as=58.1172p ps=77.99u w=76.47u l=1u
X1448 BAT GATE DVDD DVDD pfet_06v0 ad=35.511p pd=48.245u as=35.511p ps=48.245u w=46.725u l=1u
X1449 BAT GATE DVDD DVDD pfet_06v0 ad=47.6862p pd=64.265u as=58.9803p ps=0.12737m w=62.745u l=1u
X1450 BAT GATE DVDD DVDD pfet_06v0 ad=58.1134p pd=77.985u as=58.1134p ps=77.985u w=76.465u l=1u
X1451 BAT GATE DVDD DVDD pfet_06v0 ad=35.511p pd=48.245u as=35.511p ps=48.245u w=46.725u l=1u
X1452 DVDD GATE BAT DVDD pfet_06v0 ad=49.3848p pd=66.5u as=49.3848p ps=66.5u w=64.98u l=1u
X1453 DVDD GATE BAT DVDD pfet_06v0 ad=58.1134p pd=77.985u as=58.1134p ps=77.985u w=76.465u l=1u
X1454 DVDD GATE BAT DVDD pfet_06v0 ad=35.511p pd=48.245u as=35.511p ps=48.245u w=46.725u l=1u
X1455 BAT GATE DVDD DVDD pfet_06v0 ad=58.1096p pd=77.98u as=71.8724p ps=0.1548m w=76.46u l=1u
X1456 DVDD GATE BAT DVDD pfet_06v0 ad=35.5072p pd=48.24u as=35.5072p ps=48.24u w=46.72u l=1u
X1457 BAT GATE DVDD DVDD pfet_06v0 ad=58.1134p pd=77.985u as=58.1134p ps=77.985u w=76.465u l=1u
X1458 DVDD GATE BAT DVDD pfet_06v0 ad=35.511p pd=48.245u as=35.511p ps=48.245u w=46.725u l=1u
X1459 BAT GATE DVDD DVDD pfet_06v0 ad=58.1134p pd=77.985u as=58.1134p ps=77.985u w=76.465u l=1u
X1460 DVDD GATE BAT DVDD pfet_06v0 ad=71.8818p pd=0.15482m as=58.1172p ps=77.99u w=76.47u l=1u
X1461 DVDD GATE BAT DVDD pfet_06v0 ad=35.5072p pd=48.24u as=35.5072p ps=48.24u w=46.72u l=1u
X1462 DVDD GATE BAT DVDD pfet_06v0 ad=58.1134p pd=77.985u as=58.1134p ps=77.985u w=76.465u l=1u
X1463 DVDD GATE BAT DVDD pfet_06v0 ad=58.1134p pd=77.985u as=58.1134p ps=77.985u w=76.465u l=1u
X1464 DVDD GATE BAT DVDD pfet_06v0 ad=35.5072p pd=48.24u as=35.5072p ps=48.24u w=46.72u l=1u
X1465 BAT GATE DVDD DVDD pfet_06v0 ad=35.511p pd=48.245u as=43.9215p ps=95.32999u w=46.725u l=1u
X1466 BAT GATE DVDD DVDD pfet_06v0 ad=35.511p pd=48.245u as=43.9215p ps=95.32999u w=46.725u l=1u
X1467 DVDD GATE BAT DVDD pfet_06v0 ad=58.1134p pd=77.985u as=58.1134p ps=77.985u w=76.465u l=1u
X1468 BAT GATE DVDD DVDD pfet_06v0 ad=35.511p pd=48.245u as=35.511p ps=48.245u w=46.725u l=1u
X1469 BAT GATE DVDD DVDD pfet_06v0 ad=35.511p pd=48.245u as=35.511p ps=48.245u w=46.725u l=1u
X1470 BAT GATE DVDD DVDD pfet_06v0 ad=35.511p pd=48.245u as=35.511p ps=48.245u w=46.725u l=1u
X1471 BAT GATE DVDD DVDD pfet_06v0 ad=58.1134p pd=77.985u as=58.1134p ps=77.985u w=76.465u l=1u
X1472 BAT GATE DVDD DVDD pfet_06v0 ad=58.1134p pd=77.985u as=71.8771p ps=0.15481m w=76.465u l=1u
X1473 BAT GATE DVDD DVDD pfet_06v0 ad=35.5072p pd=48.24u as=35.5072p ps=48.24u w=46.72u l=1u
X1474 DVDD GATE BAT DVDD pfet_06v0 ad=58.1172p pd=77.99u as=58.1172p ps=77.99u w=76.47u l=1u
X1475 BAT GATE DVDD DVDD pfet_06v0 ad=35.511p pd=48.245u as=35.511p ps=48.245u w=46.725u l=1u
X1476 DVDD GATE BAT DVDD pfet_06v0 ad=71.8771p pd=0.15481m as=58.1134p ps=77.985u w=76.465u l=1u
X1477 DVDD GATE BAT DVDD pfet_06v0 ad=35.511p pd=48.245u as=35.511p ps=48.245u w=46.725u l=1u
X1478 DVDD GATE BAT DVDD pfet_06v0 ad=35.511p pd=48.245u as=35.511p ps=48.245u w=46.725u l=1u
X1479 BAT GATE DVDD DVDD pfet_06v0 ad=35.511p pd=48.245u as=35.511p ps=48.245u w=46.725u l=1u
X1480 BAT GATE DVDD DVDD pfet_06v0 ad=35.511p pd=48.245u as=35.511p ps=48.245u w=46.725u l=1u
X1481 BAT GATE DVDD DVDD pfet_06v0 ad=58.1552p pd=78.04u as=58.1552p ps=78.04u w=76.52u l=1u
X1482 DVDD GATE BAT DVDD pfet_06v0 ad=58.1134p pd=77.985u as=58.1134p ps=77.985u w=76.465u l=1u
X1483 DVDD GATE BAT DVDD pfet_06v0 ad=47.6862p pd=64.265u as=47.6862p ps=64.265u w=62.745u l=1u
X1484 BAT GATE DVDD DVDD pfet_06v0 ad=58.1134p pd=77.985u as=58.1134p ps=77.985u w=76.465u l=1u
X1485 BAT GATE DVDD DVDD pfet_06v0 ad=35.511p pd=48.245u as=35.511p ps=48.245u w=46.725u l=1u
X1486 DVDD GATE BAT DVDD pfet_06v0 ad=35.511p pd=48.245u as=35.511p ps=48.245u w=46.725u l=1u
X1487 DVDD GATE BAT DVDD pfet_06v0 ad=35.511p pd=48.245u as=35.511p ps=48.245u w=46.725u l=1u
X1488 DVDD GATE BAT DVDD pfet_06v0 ad=58.1134p pd=77.985u as=58.1134p ps=77.985u w=76.465u l=1u
X1489 BAT GATE DVDD DVDD pfet_06v0 ad=58.1134p pd=77.985u as=71.8771p ps=0.15481m w=76.465u l=1u
X1490 DVDD GATE BAT DVDD pfet_06v0 ad=35.511p pd=48.245u as=35.511p ps=48.245u w=46.725u l=1u
X1491 BAT GATE DVDD DVDD pfet_06v0 ad=58.1134p pd=77.985u as=71.8771p ps=0.15481m w=76.465u l=1u
X1492 BAT GATE DVDD DVDD pfet_06v0 ad=58.1134p pd=77.985u as=58.1134p ps=77.985u w=76.465u l=1u
X1493 DVDD GATE BAT DVDD pfet_06v0 ad=58.1096p pd=77.98u as=58.1096p ps=77.98u w=76.46u l=1u
X1494 BAT GATE DVDD DVDD pfet_06v0 ad=58.1172p pd=77.99u as=71.8818p ps=0.15482m w=76.47u l=1u
X1495 DVDD GATE BAT DVDD pfet_06v0 ad=58.1134p pd=77.985u as=58.1134p ps=77.985u w=76.465u l=1u
X1496 BAT GATE DVDD DVDD pfet_06v0 ad=58.1134p pd=77.985u as=58.1134p ps=77.985u w=76.465u l=1u
X1497 DVDD GATE BAT DVDD pfet_06v0 ad=35.511p pd=48.245u as=35.511p ps=48.245u w=46.725u l=1u
X1498 BAT GATE DVDD DVDD pfet_06v0 ad=58.1134p pd=77.985u as=58.1134p ps=77.985u w=76.465u l=1u
X1499 BAT GATE DVDD DVDD pfet_06v0 ad=35.511p pd=48.245u as=35.511p ps=48.245u w=46.725u l=1u
X1500 BAT GATE DVDD DVDD pfet_06v0 ad=58.1172p pd=77.99u as=58.1172p ps=77.99u w=76.47u l=1u
X1501 BAT GATE DVDD DVDD pfet_06v0 ad=58.1134p pd=77.985u as=58.1134p ps=77.985u w=76.465u l=1u
X1502 DVDD GATE BAT DVDD pfet_06v0 ad=35.511p pd=48.245u as=35.511p ps=48.245u w=46.725u l=1u
X1503 BAT GATE DVDD DVDD pfet_06v0 ad=35.511p pd=48.245u as=43.9215p ps=95.32999u w=46.725u l=1u
X1504 BAT GATE DVDD DVDD pfet_06v0 ad=35.511p pd=48.245u as=43.9215p ps=95.32999u w=46.725u l=1u
X1505 BAT GATE DVDD DVDD pfet_06v0 ad=58.1134p pd=77.985u as=58.1134p ps=77.985u w=76.465u l=1u
X1506 BAT GATE DVDD DVDD pfet_06v0 ad=58.1134p pd=77.985u as=58.1134p ps=77.985u w=76.465u l=1u
X1507 DVDD GATE BAT DVDD pfet_06v0 ad=35.511p pd=48.245u as=35.511p ps=48.245u w=46.725u l=1u
X1508 BAT GATE DVDD DVDD pfet_06v0 ad=35.511p pd=48.245u as=43.9215p ps=95.32999u w=46.725u l=1u
X1509 DVDD GATE BAT DVDD pfet_06v0 ad=35.5072p pd=48.24u as=35.5072p ps=48.24u w=46.72u l=1u
X1510 DVDD GATE BAT DVDD pfet_06v0 ad=49.3848p pd=66.5u as=49.3848p ps=66.5u w=64.98u l=1u
X1511 BAT GATE DVDD DVDD pfet_06v0 ad=58.1134p pd=77.985u as=71.8771p ps=0.15481m w=76.465u l=1u
X1512 DVDD GATE BAT DVDD pfet_06v0 ad=58.1134p pd=77.985u as=58.1134p ps=77.985u w=76.465u l=1u
X1513 BAT GATE DVDD DVDD pfet_06v0 ad=35.511p pd=48.245u as=43.9215p ps=95.32999u w=46.725u l=1u
X1514 BAT GATE DVDD DVDD pfet_06v0 ad=58.1134p pd=77.985u as=58.1134p ps=77.985u w=76.465u l=1u
X1515 DVDD GATE BAT DVDD pfet_06v0 ad=58.1172p pd=77.99u as=58.1172p ps=77.99u w=76.47u l=1u
X1516 BAT GATE DVDD DVDD pfet_06v0 ad=35.511p pd=48.245u as=35.511p ps=48.245u w=46.725u l=1u
X1517 DVDD GATE BAT DVDD pfet_06v0 ad=58.1134p pd=77.985u as=58.1134p ps=77.985u w=76.465u l=1u
X1518 DVDD GATE BAT DVDD pfet_06v0 ad=35.511p pd=48.245u as=35.511p ps=48.245u w=46.725u l=1u
X1519 DVDD GATE BAT DVDD pfet_06v0 ad=61.0812p pd=0.13184m as=49.3848p ps=66.5u w=64.98u l=1u
X1520 DVDD GATE BAT DVDD pfet_06v0 ad=47.6862p pd=64.265u as=47.6862p ps=64.265u w=62.745u l=1u
X1521 BAT GATE DVDD DVDD pfet_06v0 ad=58.1134p pd=77.985u as=71.8771p ps=0.15481m w=76.465u l=1u
X1522 DVDD GATE BAT DVDD pfet_06v0 ad=58.1134p pd=77.985u as=58.1134p ps=77.985u w=76.465u l=1u
X1523 DVDD GATE BAT DVDD pfet_06v0 ad=35.511p pd=48.245u as=35.511p ps=48.245u w=46.725u l=1u
X1524 BAT GATE DVDD DVDD pfet_06v0 ad=58.0754p pd=77.935u as=58.0754p ps=77.935u w=76.41499u l=1u
X1525 DVDD GATE BAT DVDD pfet_06v0 ad=35.511p pd=48.245u as=35.511p ps=48.245u w=46.725u l=1u
X1526 DVDD GATE BAT DVDD pfet_06v0 ad=47.6862p pd=64.265u as=47.6862p ps=64.265u w=62.745u l=1u
X1527 DVDD GATE BAT DVDD pfet_06v0 ad=35.511p pd=48.245u as=35.511p ps=48.245u w=46.725u l=1u
X1528 BAT GATE DVDD DVDD pfet_06v0 ad=35.511p pd=48.245u as=35.511p ps=48.245u w=46.725u l=1u
X1529 DVDD GATE BAT DVDD pfet_06v0 ad=58.1134p pd=77.985u as=58.1134p ps=77.985u w=76.465u l=1u
X1530 DVDD GATE BAT DVDD pfet_06v0 ad=58.1134p pd=77.985u as=58.1134p ps=77.985u w=76.465u l=1u
X1531 BAT GATE DVDD DVDD pfet_06v0 ad=58.0754p pd=77.935u as=58.0754p ps=77.935u w=76.41499u l=1u
X1532 BAT GATE DVDD DVDD pfet_06v0 ad=47.6862p pd=64.265u as=47.6862p ps=64.265u w=62.745u l=1u
X1533 BAT GATE DVDD DVDD pfet_06v0 ad=58.1134p pd=77.985u as=58.1134p ps=77.985u w=76.465u l=1u
X1534 DVDD GATE BAT DVDD pfet_06v0 ad=58.1096p pd=77.98u as=58.1096p ps=77.98u w=76.46u l=1u
X1535 BAT GATE DVDD DVDD pfet_06v0 ad=35.511p pd=48.245u as=43.9215p ps=95.32999u w=46.725u l=1u
X1536 DVDD GATE BAT DVDD pfet_06v0 ad=35.511p pd=48.245u as=35.511p ps=48.245u w=46.725u l=1u
X1537 DVDD GATE BAT DVDD pfet_06v0 ad=58.0754p pd=77.935u as=58.0754p ps=77.935u w=76.41499u l=1u
X1538 BAT GATE DVDD DVDD pfet_06v0 ad=58.1172p pd=77.99u as=58.1172p ps=77.99u w=76.47u l=1u
X1539 DVDD GATE BAT DVDD pfet_06v0 ad=35.511p pd=48.245u as=35.511p ps=48.245u w=46.725u l=1u
X1540 DVDD GATE BAT DVDD pfet_06v0 ad=49.3848p pd=66.5u as=49.3848p ps=66.5u w=64.98u l=1u
X1541 BAT GATE DVDD DVDD pfet_06v0 ad=35.5072p pd=48.24u as=35.5072p ps=48.24u w=46.72u l=1u
X1542 BAT GATE DVDD DVDD pfet_06v0 ad=35.511p pd=48.245u as=35.511p ps=48.245u w=46.725u l=1u
X1543 DVDD GATE BAT DVDD pfet_06v0 ad=35.5072p pd=48.24u as=35.5072p ps=48.24u w=46.72u l=1u
X1544 BAT GATE DVDD DVDD pfet_06v0 ad=58.1134p pd=77.985u as=58.1134p ps=77.985u w=76.465u l=1u
X1545 BAT GATE DVDD DVDD pfet_06v0 ad=58.1096p pd=77.98u as=58.1096p ps=77.98u w=76.46u l=1u
X1546 DVDD GATE BAT DVDD pfet_06v0 ad=35.511p pd=48.245u as=35.511p ps=48.245u w=46.725u l=1u
X1547 BAT GATE DVDD DVDD pfet_06v0 ad=35.511p pd=48.245u as=35.511p ps=48.245u w=46.725u l=1u
X1548 DVDD GATE BAT DVDD pfet_06v0 ad=35.5072p pd=48.24u as=35.5072p ps=48.24u w=46.72u l=1u
X1549 BAT GATE DVDD DVDD pfet_06v0 ad=58.1134p pd=77.985u as=71.8771p ps=0.15481m w=76.465u l=1u
X1550 BAT GATE DVDD DVDD pfet_06v0 ad=35.511p pd=48.245u as=43.9215p ps=95.32999u w=46.725u l=1u
X1551 BAT GATE DVDD DVDD pfet_06v0 ad=35.511p pd=48.245u as=35.511p ps=48.245u w=46.725u l=1u
X1552 DVDD GATE BAT DVDD pfet_06v0 ad=43.9168p pd=95.32u as=35.5072p ps=48.24u w=46.72u l=1u
X1553 DVDD GATE BAT DVDD pfet_06v0 ad=58.0754p pd=77.935u as=58.0754p ps=77.935u w=76.41499u l=1u
X1554 BAT GATE DVDD DVDD pfet_06v0 ad=58.1134p pd=77.985u as=58.1134p ps=77.985u w=76.465u l=1u
X1555 BAT GATE DVDD DVDD pfet_06v0 ad=35.511p pd=48.245u as=35.511p ps=48.245u w=46.725u l=1u
X1556 BAT GATE DVDD DVDD pfet_06v0 ad=58.1134p pd=77.985u as=58.1134p ps=77.985u w=76.465u l=1u
X1557 BAT GATE DVDD DVDD pfet_06v0 ad=35.511p pd=48.245u as=35.511p ps=48.245u w=46.725u l=1u
X1558 BAT GATE DVDD DVDD pfet_06v0 ad=58.1134p pd=77.985u as=58.1134p ps=77.985u w=76.465u l=1u
X1559 BAT GATE DVDD DVDD pfet_06v0 ad=47.6862p pd=64.265u as=47.6862p ps=64.265u w=62.745u l=1u
X1560 BAT GATE DVDD DVDD pfet_06v0 ad=35.5072p pd=48.24u as=35.5072p ps=48.24u w=46.72u l=1u
X1561 DVDD GATE BAT DVDD pfet_06v0 ad=35.511p pd=48.245u as=35.511p ps=48.245u w=46.725u l=1u
X1562 BAT GATE DVDD DVDD pfet_06v0 ad=58.1096p pd=77.98u as=58.1096p ps=77.98u w=76.46u l=1u
X1563 DVDD GATE BAT DVDD pfet_06v0 ad=35.511p pd=48.245u as=35.511p ps=48.245u w=46.725u l=1u
X1564 BAT GATE DVDD DVDD pfet_06v0 ad=35.5072p pd=48.24u as=43.9168p ps=95.32u w=46.72u l=1u
X1565 DVDD GATE BAT DVDD pfet_06v0 ad=58.1134p pd=77.985u as=58.1134p ps=77.985u w=76.465u l=1u
X1566 BAT GATE DVDD DVDD pfet_06v0 ad=35.511p pd=48.245u as=35.511p ps=48.245u w=46.725u l=1u
X1567 BAT GATE DVDD DVDD pfet_06v0 ad=35.511p pd=48.245u as=35.511p ps=48.245u w=46.725u l=1u
X1568 DVDD GATE BAT DVDD pfet_06v0 ad=35.511p pd=48.245u as=35.511p ps=48.245u w=46.725u l=1u
X1569 DVDD GATE BAT DVDD pfet_06v0 ad=35.511p pd=48.245u as=35.511p ps=48.245u w=46.725u l=1u
X1570 BAT GATE DVDD DVDD pfet_06v0 ad=35.511p pd=48.245u as=43.9215p ps=95.32999u w=46.725u l=1u
X1571 BAT GATE DVDD DVDD pfet_06v0 ad=35.511p pd=48.245u as=35.511p ps=48.245u w=46.725u l=1u
X1572 DVDD GATE BAT DVDD pfet_06v0 ad=35.511p pd=48.245u as=35.511p ps=48.245u w=46.725u l=1u
X1573 DVDD GATE BAT DVDD pfet_06v0 ad=58.1552p pd=78.04u as=58.1552p ps=78.04u w=76.52u l=1u
X1574 DVDD GATE BAT DVDD pfet_06v0 ad=58.1134p pd=77.985u as=58.1134p ps=77.985u w=76.465u l=1u
X1575 BAT GATE DVDD DVDD pfet_06v0 ad=58.1134p pd=77.985u as=58.1134p ps=77.985u w=76.465u l=1u
X1576 BAT GATE DVDD DVDD pfet_06v0 ad=58.1172p pd=77.99u as=58.1172p ps=77.99u w=76.47u l=1u
X1577 BAT GATE DVDD DVDD pfet_06v0 ad=58.0754p pd=77.935u as=58.0754p ps=77.935u w=76.41499u l=1u
X1578 DVDD GATE BAT DVDD pfet_06v0 ad=35.511p pd=48.245u as=35.511p ps=48.245u w=46.725u l=1u
X1579 DVDD GATE BAT DVDD pfet_06v0 ad=35.511p pd=48.245u as=35.511p ps=48.245u w=46.725u l=1u
X1580 BAT GATE DVDD DVDD pfet_06v0 ad=35.5072p pd=48.24u as=43.9168p ps=95.32u w=46.72u l=1u
X1581 BAT GATE DVDD DVDD pfet_06v0 ad=58.1134p pd=77.985u as=58.1134p ps=77.985u w=76.465u l=1u
X1582 DVDD GATE BAT DVDD pfet_06v0 ad=35.511p pd=48.245u as=35.511p ps=48.245u w=46.725u l=1u
X1583 BAT GATE DVDD DVDD pfet_06v0 ad=35.5072p pd=48.24u as=35.5072p ps=48.24u w=46.72u l=1u
X1584 DVDD GATE BAT DVDD pfet_06v0 ad=35.511p pd=48.245u as=35.511p ps=48.245u w=46.725u l=1u
X1585 DVDD GATE BAT DVDD pfet_06v0 ad=35.5072p pd=48.24u as=35.5072p ps=48.24u w=46.72u l=1u
X1586 BAT GATE DVDD DVDD pfet_06v0 ad=35.511p pd=48.245u as=35.511p ps=48.245u w=46.725u l=1u
X1587 DVDD GATE BAT DVDD pfet_06v0 ad=58.1134p pd=77.985u as=58.1134p ps=77.985u w=76.465u l=1u
X1588 BAT GATE DVDD DVDD pfet_06v0 ad=58.1134p pd=77.985u as=58.1134p ps=77.985u w=76.465u l=1u
X1589 BAT GATE DVDD DVDD pfet_06v0 ad=35.511p pd=48.245u as=35.511p ps=48.245u w=46.725u l=1u
X1590 BAT GATE DVDD DVDD pfet_06v0 ad=35.511p pd=48.245u as=35.511p ps=48.245u w=46.725u l=1u
X1591 DVDD GATE BAT DVDD pfet_06v0 ad=58.1134p pd=77.985u as=58.1134p ps=77.985u w=76.465u l=1u
X1592 BAT GATE DVDD DVDD pfet_06v0 ad=58.1134p pd=77.985u as=58.1134p ps=77.985u w=76.465u l=1u
X1593 BAT GATE DVDD DVDD pfet_06v0 ad=58.1134p pd=77.985u as=58.1134p ps=77.985u w=76.465u l=1u
X1594 BAT GATE DVDD DVDD pfet_06v0 ad=35.511p pd=48.245u as=35.511p ps=48.245u w=46.725u l=1u
X1595 DVDD GATE BAT DVDD pfet_06v0 ad=35.511p pd=48.245u as=35.511p ps=48.245u w=46.725u l=1u
X1596 DVDD GATE BAT DVDD pfet_06v0 ad=58.1134p pd=77.985u as=58.1134p ps=77.985u w=76.465u l=1u
X1597 BAT GATE DVDD DVDD pfet_06v0 ad=35.511p pd=48.245u as=43.9215p ps=95.32999u w=46.725u l=1u
X1598 DVDD GATE BAT DVDD pfet_06v0 ad=35.511p pd=48.245u as=35.511p ps=48.245u w=46.725u l=1u
X1599 DVDD GATE BAT DVDD pfet_06v0 ad=43.9215p pd=95.32999u as=35.511p ps=48.245u w=46.725u l=1u
X1600 BAT GATE DVDD DVDD pfet_06v0 ad=58.1134p pd=77.985u as=58.1134p ps=77.985u w=76.465u l=1u
X1601 DVDD GATE BAT DVDD pfet_06v0 ad=35.511p pd=48.245u as=35.511p ps=48.245u w=46.725u l=1u
X1602 BAT GATE DVDD DVDD pfet_06v0 ad=58.1096p pd=77.98u as=58.1096p ps=77.98u w=76.46u l=1u
X1603 DVDD GATE BAT DVDD pfet_06v0 ad=58.1134p pd=77.985u as=58.1134p ps=77.985u w=76.465u l=1u
X1604 BAT GATE DVDD DVDD pfet_06v0 ad=58.1134p pd=77.985u as=58.1134p ps=77.985u w=76.465u l=1u
X1605 DVDD GATE BAT DVDD pfet_06v0 ad=58.1134p pd=77.985u as=58.1134p ps=77.985u w=76.465u l=1u
X1606 DVDD GATE BAT DVDD pfet_06v0 ad=35.511p pd=48.245u as=35.511p ps=48.245u w=46.725u l=1u
X1607 BAT GATE DVDD DVDD pfet_06v0 ad=49.3848p pd=66.5u as=49.3848p ps=66.5u w=64.98u l=1u
X1608 BAT GATE DVDD DVDD pfet_06v0 ad=58.1134p pd=77.985u as=58.1134p ps=77.985u w=76.465u l=1u
X1609 BAT GATE DVDD DVDD pfet_06v0 ad=35.511p pd=48.245u as=35.511p ps=48.245u w=46.725u l=1u
X1610 BAT GATE DVDD DVDD pfet_06v0 ad=58.1172p pd=77.99u as=58.1172p ps=77.99u w=76.47u l=1u
X1611 DVDD GATE BAT DVDD pfet_06v0 ad=35.511p pd=48.245u as=35.511p ps=48.245u w=46.725u l=1u
X1612 BAT GATE DVDD DVDD pfet_06v0 ad=35.5072p pd=48.24u as=35.5072p ps=48.24u w=46.72u l=1u
X1613 BAT GATE DVDD DVDD pfet_06v0 ad=35.511p pd=48.245u as=35.511p ps=48.245u w=46.725u l=1u
X1614 BAT GATE DVDD DVDD pfet_06v0 ad=58.1134p pd=77.985u as=71.8771p ps=0.15481m w=76.465u l=1u
X1615 DVDD GATE BAT DVDD pfet_06v0 ad=58.1134p pd=77.985u as=58.1134p ps=77.985u w=76.465u l=1u
X1616 BAT GATE DVDD DVDD pfet_06v0 ad=58.1134p pd=77.985u as=71.8771p ps=0.15481m w=76.465u l=1u
X1617 BAT GATE DVDD DVDD pfet_06v0 ad=35.511p pd=48.245u as=35.511p ps=48.245u w=46.725u l=1u
X1618 DVDD GATE BAT DVDD pfet_06v0 ad=58.1134p pd=77.985u as=58.1134p ps=77.985u w=76.465u l=1u
X1619 DVDD GATE BAT DVDD pfet_06v0 ad=58.1096p pd=77.98u as=58.1096p ps=77.98u w=76.46u l=1u
X1620 DVDD GATE BAT DVDD pfet_06v0 ad=58.1134p pd=77.985u as=58.1134p ps=77.985u w=76.465u l=1u
X1621 BAT GATE DVDD DVDD pfet_06v0 ad=58.1134p pd=77.985u as=71.8771p ps=0.15481m w=76.465u l=1u
X1622 BAT GATE DVDD DVDD pfet_06v0 ad=58.1134p pd=77.985u as=58.1134p ps=77.985u w=76.465u l=1u
X1623 DVDD GATE BAT DVDD pfet_06v0 ad=35.511p pd=48.245u as=35.511p ps=48.245u w=46.725u l=1u
X1624 BAT GATE DVDD DVDD pfet_06v0 ad=47.6862p pd=64.265u as=47.6862p ps=64.265u w=62.745u l=1u
X1625 BAT GATE DVDD DVDD pfet_06v0 ad=58.1134p pd=77.985u as=58.1134p ps=77.985u w=76.465u l=1u
X1626 DVDD GATE BAT DVDD pfet_06v0 ad=58.1552p pd=78.04u as=58.1552p ps=78.04u w=76.52u l=1u
X1627 DVDD GATE BAT DVDD pfet_06v0 ad=71.8771p pd=0.15481m as=58.1134p ps=77.985u w=76.465u l=1u
X1628 BAT GATE DVDD DVDD pfet_06v0 ad=35.511p pd=48.245u as=35.511p ps=48.245u w=46.725u l=1u
X1629 DVDD GATE BAT DVDD pfet_06v0 ad=58.1134p pd=77.985u as=58.1134p ps=77.985u w=76.465u l=1u
X1630 DVDD GATE BAT DVDD pfet_06v0 ad=35.511p pd=48.245u as=35.511p ps=48.245u w=46.725u l=1u
X1631 BAT GATE DVDD DVDD pfet_06v0 ad=35.511p pd=48.245u as=43.9215p ps=95.32999u w=46.725u l=1u
X1632 BAT GATE DVDD DVDD pfet_06v0 ad=35.511p pd=48.245u as=35.511p ps=48.245u w=46.725u l=1u
X1633 DVDD GATE BAT DVDD pfet_06v0 ad=35.5072p pd=48.24u as=35.5072p ps=48.24u w=46.72u l=1u
X1634 BAT GATE DVDD DVDD pfet_06v0 ad=58.1134p pd=77.985u as=58.1134p ps=77.985u w=76.465u l=1u
X1635 DVDD GATE BAT DVDD pfet_06v0 ad=43.9215p pd=95.32999u as=35.511p ps=48.245u w=46.725u l=1u
X1636 BAT GATE DVDD DVDD pfet_06v0 ad=58.1552p pd=78.04u as=58.1552p ps=78.04u w=76.52u l=1u
X1637 DVDD GATE BAT DVDD pfet_06v0 ad=58.1134p pd=77.985u as=58.1134p ps=77.985u w=76.465u l=1u
X1638 DVDD GATE BAT DVDD pfet_06v0 ad=35.511p pd=48.245u as=35.511p ps=48.245u w=46.725u l=1u
X1639 BAT GATE DVDD DVDD pfet_06v0 ad=58.1134p pd=77.985u as=71.8771p ps=0.15481m w=76.465u l=1u
X1640 DVDD GATE BAT DVDD pfet_06v0 ad=35.5072p pd=48.24u as=35.5072p ps=48.24u w=46.72u l=1u
X1641 BAT GATE DVDD DVDD pfet_06v0 ad=35.511p pd=48.245u as=35.511p ps=48.245u w=46.725u l=1u
X1642 BAT GATE DVDD DVDD pfet_06v0 ad=58.1096p pd=77.98u as=58.1096p ps=77.98u w=76.46u l=1u
X1643 BAT GATE DVDD DVDD pfet_06v0 ad=47.6862p pd=64.265u as=47.6862p ps=64.265u w=62.745u l=1u
X1644 BAT GATE DVDD DVDD pfet_06v0 ad=58.1134p pd=77.985u as=58.1134p ps=77.985u w=76.465u l=1u
X1645 BAT GATE DVDD DVDD pfet_06v0 ad=35.511p pd=48.245u as=35.511p ps=48.245u w=46.725u l=1u
X1646 BAT GATE DVDD DVDD pfet_06v0 ad=49.3848p pd=66.5u as=49.3848p ps=66.5u w=64.98u l=1u
X1647 BAT GATE DVDD DVDD pfet_06v0 ad=35.511p pd=48.245u as=35.511p ps=48.245u w=46.725u l=1u
X1648 BAT GATE DVDD DVDD pfet_06v0 ad=58.0754p pd=77.935u as=71.8301p ps=0.15471m w=76.41499u l=1u
X1649 DVDD GATE BAT DVDD pfet_06v0 ad=43.9215p pd=95.32999u as=35.511p ps=48.245u w=46.725u l=1u
X1650 BAT GATE DVDD DVDD pfet_06v0 ad=35.511p pd=48.245u as=35.511p ps=48.245u w=46.725u l=1u
X1651 DVDD GATE BAT DVDD pfet_06v0 ad=58.1172p pd=77.99u as=58.1172p ps=77.99u w=76.47u l=1u
X1652 BAT GATE DVDD DVDD pfet_06v0 ad=35.511p pd=48.245u as=35.511p ps=48.245u w=46.725u l=1u
X1653 DVDD GATE BAT DVDD pfet_06v0 ad=35.511p pd=48.245u as=35.511p ps=48.245u w=46.725u l=1u
X1654 BAT GATE DVDD DVDD pfet_06v0 ad=35.5072p pd=48.24u as=35.5072p ps=48.24u w=46.72u l=1u
X1655 BAT GATE DVDD DVDD pfet_06v0 ad=35.511p pd=48.245u as=35.511p ps=48.245u w=46.725u l=1u
X1656 DVDD GATE BAT DVDD pfet_06v0 ad=58.1096p pd=77.98u as=58.1096p ps=77.98u w=76.46u l=1u
X1657 BAT GATE DVDD DVDD pfet_06v0 ad=35.511p pd=48.245u as=43.9215p ps=95.32999u w=46.725u l=1u
X1658 BAT GATE DVDD DVDD pfet_06v0 ad=58.0754p pd=77.935u as=58.0754p ps=77.935u w=76.41499u l=1u
X1659 DVDD GATE BAT DVDD pfet_06v0 ad=58.1134p pd=77.985u as=58.1134p ps=77.985u w=76.465u l=1u
X1660 DVDD GATE BAT DVDD pfet_06v0 ad=58.1134p pd=77.985u as=58.1134p ps=77.985u w=76.465u l=1u
X1661 DVDD GATE BAT DVDD pfet_06v0 ad=35.511p pd=48.245u as=35.511p ps=48.245u w=46.725u l=1u
X1662 BAT GATE DVDD DVDD pfet_06v0 ad=35.5072p pd=48.24u as=35.5072p ps=48.24u w=46.72u l=1u
X1663 DVDD GATE BAT DVDD pfet_06v0 ad=58.1134p pd=77.985u as=58.1134p ps=77.985u w=76.465u l=1u
X1664 BAT GATE DVDD DVDD pfet_06v0 ad=35.511p pd=48.245u as=35.511p ps=48.245u w=46.725u l=1u
X1665 BAT GATE DVDD DVDD pfet_06v0 ad=58.1172p pd=77.99u as=71.8818p ps=0.15482m w=76.47u l=1u
X1666 BAT GATE DVDD DVDD pfet_06v0 ad=35.511p pd=48.245u as=35.511p ps=48.245u w=46.725u l=1u
X1667 DVDD GATE BAT DVDD pfet_06v0 ad=58.1134p pd=77.985u as=58.1134p ps=77.985u w=76.465u l=1u
X1668 DVDD GATE BAT DVDD pfet_06v0 ad=35.5072p pd=48.24u as=35.5072p ps=48.24u w=46.72u l=1u
X1669 DVDD GATE BAT DVDD pfet_06v0 ad=58.1096p pd=77.98u as=58.1096p ps=77.98u w=76.46u l=1u
X1670 DVDD GATE BAT DVDD pfet_06v0 ad=58.1134p pd=77.985u as=58.1134p ps=77.985u w=76.465u l=1u
X1671 BAT GATE DVDD DVDD pfet_06v0 ad=58.1134p pd=77.985u as=71.8771p ps=0.15481m w=76.465u l=1u
X1672 DVDD GATE BAT DVDD pfet_06v0 ad=35.511p pd=48.245u as=35.511p ps=48.245u w=46.725u l=1u
X1673 BAT GATE DVDD DVDD pfet_06v0 ad=58.1172p pd=77.99u as=58.1172p ps=77.99u w=76.47u l=1u
X1674 BAT GATE DVDD DVDD pfet_06v0 ad=35.511p pd=48.245u as=43.9215p ps=95.32999u w=46.725u l=1u
X1675 DVDD GATE BAT DVDD pfet_06v0 ad=58.1134p pd=77.985u as=58.1134p ps=77.985u w=76.465u l=1u
X1676 DVDD GATE BAT DVDD pfet_06v0 ad=35.511p pd=48.245u as=35.511p ps=48.245u w=46.725u l=1u
X1677 DVDD GATE BAT DVDD pfet_06v0 ad=43.9215p pd=95.32999u as=35.511p ps=48.245u w=46.725u l=1u
X1678 BAT GATE DVDD DVDD pfet_06v0 ad=35.511p pd=48.245u as=35.511p ps=48.245u w=46.725u l=1u
X1679 DVDD GATE BAT DVDD pfet_06v0 ad=58.1096p pd=77.98u as=58.1096p ps=77.98u w=76.46u l=1u
X1680 DVDD GATE BAT DVDD pfet_06v0 ad=58.1096p pd=77.98u as=58.1096p ps=77.98u w=76.46u l=1u
X1681 BAT GATE DVDD DVDD pfet_06v0 ad=58.1134p pd=77.985u as=71.8771p ps=0.15481m w=76.465u l=1u
X1682 DVDD GATE BAT DVDD pfet_06v0 ad=35.511p pd=48.245u as=35.511p ps=48.245u w=46.725u l=1u
X1683 DVDD GATE BAT DVDD pfet_06v0 ad=43.9215p pd=95.32999u as=35.511p ps=48.245u w=46.725u l=1u
X1684 DVDD GATE BAT DVDD pfet_06v0 ad=58.1134p pd=77.985u as=58.1134p ps=77.985u w=76.465u l=1u
X1685 BAT GATE DVDD DVDD pfet_06v0 ad=35.511p pd=48.245u as=35.511p ps=48.245u w=46.725u l=1u
X1686 DVDD GATE BAT DVDD pfet_06v0 ad=35.511p pd=48.245u as=35.511p ps=48.245u w=46.725u l=1u
X1687 BAT GATE DVDD DVDD pfet_06v0 ad=58.1096p pd=77.98u as=58.1096p ps=77.98u w=76.46u l=1u
X1688 DVDD GATE BAT DVDD pfet_06v0 ad=58.1134p pd=77.985u as=58.1134p ps=77.985u w=76.465u l=1u
X1689 BAT GATE DVDD DVDD pfet_06v0 ad=35.511p pd=48.245u as=35.511p ps=48.245u w=46.725u l=1u
X1690 DVDD GATE BAT DVDD pfet_06v0 ad=71.8771p pd=0.15481m as=58.1134p ps=77.985u w=76.465u l=1u
X1691 DVDD GATE BAT DVDD pfet_06v0 ad=35.511p pd=48.245u as=35.511p ps=48.245u w=46.725u l=1u
X1692 BAT GATE DVDD DVDD pfet_06v0 ad=58.1134p pd=77.985u as=58.1134p ps=77.985u w=76.465u l=1u
X1693 DVDD GATE BAT DVDD pfet_06v0 ad=58.0754p pd=77.935u as=58.0754p ps=77.935u w=76.41499u l=1u
X1694 BAT GATE DVDD DVDD pfet_06v0 ad=35.511p pd=48.245u as=35.511p ps=48.245u w=46.725u l=1u
X1695 BAT GATE DVDD DVDD pfet_06v0 ad=35.511p pd=48.245u as=35.511p ps=48.245u w=46.725u l=1u
X1696 DVDD GATE BAT DVDD pfet_06v0 ad=58.1172p pd=77.99u as=58.1172p ps=77.99u w=76.47u l=1u
X1697 DVDD GATE BAT DVDD pfet_06v0 ad=61.0812p pd=0.13184m as=49.3848p ps=66.5u w=64.98u l=1u
X1698 DVDD GATE BAT DVDD pfet_06v0 ad=35.511p pd=48.245u as=35.511p ps=48.245u w=46.725u l=1u
X1699 BAT GATE DVDD DVDD pfet_06v0 ad=58.1552p pd=78.04u as=58.1552p ps=78.04u w=76.52u l=1u
X1700 DVDD GATE BAT DVDD pfet_06v0 ad=58.1134p pd=77.985u as=58.1134p ps=77.985u w=76.465u l=1u
X1701 DVDD GATE BAT DVDD pfet_06v0 ad=35.511p pd=48.245u as=35.511p ps=48.245u w=46.725u l=1u
X1702 DVDD GATE BAT DVDD pfet_06v0 ad=71.8301p pd=0.15471m as=58.0754p ps=77.935u w=76.41499u l=1u
X1703 BAT GATE DVDD DVDD pfet_06v0 ad=47.6862p pd=64.265u as=47.6862p ps=64.265u w=62.745u l=1u
X1704 BAT GATE DVDD DVDD pfet_06v0 ad=35.5072p pd=48.24u as=35.5072p ps=48.24u w=46.72u l=1u
X1705 BAT GATE DVDD DVDD pfet_06v0 ad=58.1134p pd=77.985u as=58.1134p ps=77.985u w=76.465u l=1u
X1706 BAT GATE DVDD DVDD pfet_06v0 ad=58.1552p pd=78.04u as=58.1552p ps=78.04u w=76.52u l=1u
X1707 DVDD GATE BAT DVDD pfet_06v0 ad=58.1134p pd=77.985u as=58.1134p ps=77.985u w=76.465u l=1u
X1708 BAT GATE DVDD DVDD pfet_06v0 ad=58.1134p pd=77.985u as=58.1134p ps=77.985u w=76.465u l=1u
X1709 DVDD GATE BAT DVDD pfet_06v0 ad=58.1134p pd=77.985u as=58.1134p ps=77.985u w=76.465u l=1u
X1710 BAT GATE DVDD DVDD pfet_06v0 ad=58.1172p pd=77.99u as=71.8818p ps=0.15482m w=76.47u l=1u
X1711 BAT GATE DVDD DVDD pfet_06v0 ad=58.1134p pd=77.985u as=58.1134p ps=77.985u w=76.465u l=1u
X1712 DVDD GATE BAT DVDD pfet_06v0 ad=58.1134p pd=77.985u as=58.1134p ps=77.985u w=76.465u l=1u
X1713 DVDD GATE BAT DVDD pfet_06v0 ad=58.1172p pd=77.99u as=58.1172p ps=77.99u w=76.47u l=1u
X1714 DVDD GATE BAT DVDD pfet_06v0 ad=71.8771p pd=0.15481m as=58.1134p ps=77.985u w=76.465u l=1u
X1715 BAT GATE DVDD DVDD pfet_06v0 ad=58.1134p pd=77.985u as=71.8771p ps=0.15481m w=76.465u l=1u
X1716 DVDD GATE BAT DVDD pfet_06v0 ad=58.1134p pd=77.985u as=58.1134p ps=77.985u w=76.465u l=1u
X1717 DVDD GATE BAT DVDD pfet_06v0 ad=71.8771p pd=0.15481m as=58.1134p ps=77.985u w=76.465u l=1u
X1718 DVDD GATE BAT DVDD pfet_06v0 ad=35.511p pd=48.245u as=35.511p ps=48.245u w=46.725u l=1u
X1719 BAT GATE DVDD DVDD pfet_06v0 ad=58.1134p pd=77.985u as=58.1134p ps=77.985u w=76.465u l=1u
X1720 DVDD GATE BAT DVDD pfet_06v0 ad=58.1096p pd=77.98u as=58.1096p ps=77.98u w=76.46u l=1u
X1721 DVDD GATE BAT DVDD pfet_06v0 ad=71.8771p pd=0.15481m as=58.1134p ps=77.985u w=76.465u l=1u
X1722 BAT GATE DVDD DVDD pfet_06v0 ad=58.1134p pd=77.985u as=58.1134p ps=77.985u w=76.465u l=1u
X1723 BAT GATE DVDD DVDD pfet_06v0 ad=58.1172p pd=77.99u as=58.1172p ps=77.99u w=76.47u l=1u
X1724 BAT GATE DVDD DVDD pfet_06v0 ad=35.511p pd=48.245u as=35.511p ps=48.245u w=46.725u l=1u
X1725 BAT GATE DVDD DVDD pfet_06v0 ad=58.1134p pd=77.985u as=58.1134p ps=77.985u w=76.465u l=1u
X1726 DVDD GATE BAT DVDD pfet_06v0 ad=35.511p pd=48.245u as=35.511p ps=48.245u w=46.725u l=1u
X1727 BAT GATE DVDD DVDD pfet_06v0 ad=35.511p pd=48.245u as=35.511p ps=48.245u w=46.725u l=1u
X1728 BAT GATE DVDD DVDD pfet_06v0 ad=58.1134p pd=77.985u as=58.1134p ps=77.985u w=76.465u l=1u
X1729 BAT GATE DVDD DVDD pfet_06v0 ad=58.1134p pd=77.985u as=58.1134p ps=77.985u w=76.465u l=1u
X1730 DVDD GATE BAT DVDD pfet_06v0 ad=58.0754p pd=77.935u as=58.0754p ps=77.935u w=76.41499u l=1u
X1731 DVDD GATE BAT DVDD pfet_06v0 ad=49.3848p pd=66.5u as=49.3848p ps=66.5u w=64.98u l=1u
X1732 DVDD GATE BAT DVDD pfet_06v0 ad=35.511p pd=48.245u as=35.511p ps=48.245u w=46.725u l=1u
X1733 BAT GATE DVDD DVDD pfet_06v0 ad=47.6862p pd=64.265u as=47.6862p ps=64.265u w=62.745u l=1u
X1734 DVDD GATE BAT DVDD pfet_06v0 ad=58.1134p pd=77.985u as=58.1134p ps=77.985u w=76.465u l=1u
X1735 DVDD GATE BAT DVDD pfet_06v0 ad=58.1552p pd=78.04u as=58.1552p ps=78.04u w=76.52u l=1u
X1736 DVDD GATE BAT DVDD pfet_06v0 ad=58.1134p pd=77.985u as=58.1134p ps=77.985u w=76.465u l=1u
X1737 BAT GATE DVDD DVDD pfet_06v0 ad=35.511p pd=48.245u as=43.9215p ps=95.32999u w=46.725u l=1u
X1738 DVDD GATE BAT DVDD pfet_06v0 ad=35.511p pd=48.245u as=35.511p ps=48.245u w=46.725u l=1u
X1739 BAT GATE DVDD DVDD pfet_06v0 ad=35.511p pd=48.245u as=35.511p ps=48.245u w=46.725u l=1u
X1740 BAT GATE DVDD DVDD pfet_06v0 ad=58.1096p pd=77.98u as=58.1096p ps=77.98u w=76.46u l=1u
X1741 BAT GATE DVDD DVDD pfet_06v0 ad=58.1134p pd=77.985u as=58.1134p ps=77.985u w=76.465u l=1u
X1742 DVDD GATE BAT DVDD pfet_06v0 ad=71.8301p pd=0.15471m as=58.0754p ps=77.935u w=76.41499u l=1u
X1743 DVDD GATE BAT DVDD pfet_06v0 ad=58.1134p pd=77.985u as=58.1134p ps=77.985u w=76.465u l=1u
X1744 BAT GATE DVDD DVDD pfet_06v0 ad=58.1134p pd=77.985u as=58.1134p ps=77.985u w=76.465u l=1u
X1745 DVDD GATE BAT DVDD pfet_06v0 ad=35.511p pd=48.245u as=35.511p ps=48.245u w=46.725u l=1u
X1746 BAT GATE DVDD DVDD pfet_06v0 ad=35.511p pd=48.245u as=35.511p ps=48.245u w=46.725u l=1u
X1747 BAT GATE DVDD DVDD pfet_06v0 ad=35.511p pd=48.245u as=35.511p ps=48.245u w=46.725u l=1u
X1748 BAT GATE DVDD DVDD pfet_06v0 ad=58.1134p pd=77.985u as=58.1134p ps=77.985u w=76.465u l=1u
X1749 DVDD GATE BAT DVDD pfet_06v0 ad=35.511p pd=48.245u as=35.511p ps=48.245u w=46.725u l=1u
X1750 DVDD GATE BAT DVDD pfet_06v0 ad=58.1172p pd=77.99u as=58.1172p ps=77.99u w=76.47u l=1u
X1751 BAT GATE DVDD DVDD pfet_06v0 ad=58.1134p pd=77.985u as=58.1134p ps=77.985u w=76.465u l=1u
X1752 BAT GATE DVDD DVDD pfet_06v0 ad=35.5072p pd=48.24u as=35.5072p ps=48.24u w=46.72u l=1u
X1753 BAT GATE DVDD DVDD pfet_06v0 ad=58.1096p pd=77.98u as=58.1096p ps=77.98u w=76.46u l=1u
X1754 BAT GATE DVDD DVDD pfet_06v0 ad=58.1134p pd=77.985u as=71.8771p ps=0.15481m w=76.465u l=1u
X1755 BAT GATE DVDD DVDD pfet_06v0 ad=35.5072p pd=48.24u as=43.9168p ps=95.32u w=46.72u l=1u
X1756 DVDD GATE BAT DVDD pfet_06v0 ad=58.1096p pd=77.98u as=58.1096p ps=77.98u w=76.46u l=1u
X1757 DVDD GATE BAT DVDD pfet_06v0 ad=58.1134p pd=77.985u as=58.1134p ps=77.985u w=76.465u l=1u
X1758 DVDD GATE BAT DVDD pfet_06v0 ad=35.511p pd=48.245u as=35.511p ps=48.245u w=46.725u l=1u
X1759 DVDD GATE BAT DVDD pfet_06v0 ad=35.511p pd=48.245u as=35.511p ps=48.245u w=46.725u l=1u
X1760 BAT GATE DVDD DVDD pfet_06v0 ad=35.511p pd=48.245u as=43.9215p ps=95.32999u w=46.725u l=1u
X1761 DVDD GATE BAT DVDD pfet_06v0 ad=71.8724p pd=0.1548m as=58.1096p ps=77.98u w=76.46u l=1u
X1762 DVDD GATE BAT DVDD pfet_06v0 ad=35.511p pd=48.245u as=35.511p ps=48.245u w=46.725u l=1u
X1763 BAT GATE DVDD DVDD pfet_06v0 ad=47.6862p pd=64.265u as=58.9803p ps=0.12737m w=62.745u l=1u
X1764 DVDD GATE BAT DVDD pfet_06v0 ad=35.511p pd=48.245u as=35.511p ps=48.245u w=46.725u l=1u
X1765 BAT GATE DVDD DVDD pfet_06v0 ad=35.511p pd=48.245u as=43.9215p ps=95.32999u w=46.725u l=1u
X1766 DVDD GATE BAT DVDD pfet_06v0 ad=43.9215p pd=95.32999u as=35.511p ps=48.245u w=46.725u l=1u
X1767 DVDD GATE BAT DVDD pfet_06v0 ad=35.511p pd=48.245u as=35.511p ps=48.245u w=46.725u l=1u
X1768 BAT GATE DVDD DVDD pfet_06v0 ad=58.1134p pd=77.985u as=58.1134p ps=77.985u w=76.465u l=1u
X1769 BAT GATE DVDD DVDD pfet_06v0 ad=58.1134p pd=77.985u as=58.1134p ps=77.985u w=76.465u l=1u
X1770 DVDD GATE BAT DVDD pfet_06v0 ad=58.0754p pd=77.935u as=58.0754p ps=77.935u w=76.41499u l=1u
X1771 BAT GATE DVDD DVDD pfet_06v0 ad=58.1096p pd=77.98u as=71.8724p ps=0.1548m w=76.46u l=1u
X1772 BAT GATE DVDD DVDD pfet_06v0 ad=35.511p pd=48.245u as=35.511p ps=48.245u w=46.725u l=1u
X1773 BAT GATE DVDD DVDD pfet_06v0 ad=35.511p pd=48.245u as=35.511p ps=48.245u w=46.725u l=1u
X1774 BAT GATE DVDD DVDD pfet_06v0 ad=49.3848p pd=66.5u as=49.3848p ps=66.5u w=64.98u l=1u
X1775 DVDD GATE BAT DVDD pfet_06v0 ad=47.6862p pd=64.265u as=47.6862p ps=64.265u w=62.745u l=1u
X1776 DVDD GATE BAT DVDD pfet_06v0 ad=58.1134p pd=77.985u as=58.1134p ps=77.985u w=76.465u l=1u
X1777 DVDD GATE BAT DVDD pfet_06v0 ad=58.1134p pd=77.985u as=58.1134p ps=77.985u w=76.465u l=1u
X1778 DVDD GATE BAT DVDD pfet_06v0 ad=58.0754p pd=77.935u as=58.0754p ps=77.935u w=76.41499u l=1u
X1779 DVDD GATE BAT DVDD pfet_06v0 ad=58.1172p pd=77.99u as=58.1172p ps=77.99u w=76.47u l=1u
X1780 BAT GATE DVDD DVDD pfet_06v0 ad=35.511p pd=48.245u as=35.511p ps=48.245u w=46.725u l=1u
X1781 DVDD GATE BAT DVDD pfet_06v0 ad=35.5072p pd=48.24u as=35.5072p ps=48.24u w=46.72u l=1u
X1782 BAT GATE DVDD DVDD pfet_06v0 ad=35.5072p pd=48.24u as=43.9168p ps=95.32u w=46.72u l=1u
X1783 DVDD GATE BAT DVDD pfet_06v0 ad=58.1172p pd=77.99u as=58.1172p ps=77.99u w=76.47u l=1u
X1784 BAT GATE DVDD DVDD pfet_06v0 ad=58.1134p pd=77.985u as=71.8771p ps=0.15481m w=76.465u l=1u
X1785 BAT GATE DVDD DVDD pfet_06v0 ad=35.511p pd=48.245u as=35.511p ps=48.245u w=46.725u l=1u
X1786 DVDD GATE BAT DVDD pfet_06v0 ad=71.8771p pd=0.15481m as=58.1134p ps=77.985u w=76.465u l=1u
X1787 BAT GATE DVDD DVDD pfet_06v0 ad=35.511p pd=48.245u as=35.511p ps=48.245u w=46.725u l=1u
X1788 BAT GATE DVDD DVDD pfet_06v0 ad=35.511p pd=48.245u as=35.511p ps=48.245u w=46.725u l=1u
X1789 DVDD GATE BAT DVDD pfet_06v0 ad=58.1134p pd=77.985u as=58.1134p ps=77.985u w=76.465u l=1u
X1790 DVDD GATE BAT DVDD pfet_06v0 ad=35.511p pd=48.245u as=35.511p ps=48.245u w=46.725u l=1u
X1791 BAT GATE DVDD DVDD pfet_06v0 ad=58.1096p pd=77.98u as=71.8724p ps=0.1548m w=76.46u l=1u
X1792 BAT GATE DVDD DVDD pfet_06v0 ad=58.1096p pd=77.98u as=58.1096p ps=77.98u w=76.46u l=1u
X1793 BAT GATE DVDD DVDD pfet_06v0 ad=58.1096p pd=77.98u as=71.8724p ps=0.1548m w=76.46u l=1u
X1794 DVDD GATE BAT DVDD pfet_06v0 ad=71.8818p pd=0.15482m as=58.1172p ps=77.99u w=76.47u l=1u
X1795 BAT GATE DVDD DVDD pfet_06v0 ad=58.0754p pd=77.935u as=71.8301p ps=0.15471m w=76.41499u l=1u
X1796 DVDD GATE BAT DVDD pfet_06v0 ad=58.1096p pd=77.98u as=58.1096p ps=77.98u w=76.46u l=1u
X1797 DVDD GATE BAT DVDD pfet_06v0 ad=35.5072p pd=48.24u as=35.5072p ps=48.24u w=46.72u l=1u
X1798 BAT GATE DVDD DVDD pfet_06v0 ad=58.1134p pd=77.985u as=58.1134p ps=77.985u w=76.465u l=1u
X1799 DVDD GATE BAT DVDD pfet_06v0 ad=35.511p pd=48.245u as=35.511p ps=48.245u w=46.725u l=1u
X1800 BAT GATE DVDD DVDD pfet_06v0 ad=58.1134p pd=77.985u as=58.1134p ps=77.985u w=76.465u l=1u
X1801 BAT GATE DVDD DVDD pfet_06v0 ad=35.511p pd=48.245u as=43.9215p ps=95.32999u w=46.725u l=1u
X1802 DVDD GATE BAT DVDD pfet_06v0 ad=35.511p pd=48.245u as=35.511p ps=48.245u w=46.725u l=1u
X1803 DVDD GATE BAT DVDD pfet_06v0 ad=43.9215p pd=95.32999u as=35.511p ps=48.245u w=46.725u l=1u
X1804 DVDD GATE BAT DVDD pfet_06v0 ad=58.1552p pd=78.04u as=58.1552p ps=78.04u w=76.52u l=1u
X1805 BAT GATE DVDD DVDD pfet_06v0 ad=35.5072p pd=48.24u as=43.9168p ps=95.32u w=46.72u l=1u
X1806 BAT GATE DVDD DVDD pfet_06v0 ad=58.1134p pd=77.985u as=58.1134p ps=77.985u w=76.465u l=1u
X1807 BAT GATE DVDD DVDD pfet_06v0 ad=58.1134p pd=77.985u as=58.1134p ps=77.985u w=76.465u l=1u
X1808 BAT GATE DVDD DVDD pfet_06v0 ad=58.1172p pd=77.99u as=71.8818p ps=0.15482m w=76.47u l=1u
X1809 BAT GATE DVDD DVDD pfet_06v0 ad=35.511p pd=48.245u as=35.511p ps=48.245u w=46.725u l=1u
X1810 DVDD GATE BAT DVDD pfet_06v0 ad=58.1134p pd=77.985u as=58.1134p ps=77.985u w=76.465u l=1u
X1811 DVDD GATE BAT DVDD pfet_06v0 ad=58.1134p pd=77.985u as=58.1134p ps=77.985u w=76.465u l=1u
X1812 DVDD GATE BAT DVDD pfet_06v0 ad=71.8771p pd=0.15481m as=58.1134p ps=77.985u w=76.465u l=1u
X1813 BAT GATE DVDD DVDD pfet_06v0 ad=58.1172p pd=77.99u as=58.1172p ps=77.99u w=76.47u l=1u
X1814 DVDD GATE BAT DVDD pfet_06v0 ad=58.1552p pd=78.04u as=58.1552p ps=78.04u w=76.52u l=1u
X1815 DVDD GATE BAT DVDD pfet_06v0 ad=35.511p pd=48.245u as=35.511p ps=48.245u w=46.725u l=1u
X1816 BAT GATE DVDD DVDD pfet_06v0 ad=58.1134p pd=77.985u as=58.1134p ps=77.985u w=76.465u l=1u
X1817 BAT GATE DVDD DVDD pfet_06v0 ad=58.1552p pd=78.04u as=71.92879p ps=0.15492m w=76.52u l=1u
X1818 DVDD GATE BAT DVDD pfet_06v0 ad=43.9215p pd=95.32999u as=35.511p ps=48.245u w=46.725u l=1u
X1819 DVDD GATE BAT DVDD pfet_06v0 ad=58.1134p pd=77.985u as=58.1134p ps=77.985u w=76.465u l=1u
X1820 BAT GATE DVDD DVDD pfet_06v0 ad=58.1134p pd=77.985u as=58.1134p ps=77.985u w=76.465u l=1u
X1821 BAT GATE DVDD DVDD pfet_06v0 ad=58.1134p pd=77.985u as=58.1134p ps=77.985u w=76.465u l=1u
X1822 DVDD GATE BAT DVDD pfet_06v0 ad=58.1134p pd=77.985u as=58.1134p ps=77.985u w=76.465u l=1u
X1823 DVDD GATE BAT DVDD pfet_06v0 ad=35.5072p pd=48.24u as=35.5072p ps=48.24u w=46.72u l=1u
X1824 BAT GATE DVDD DVDD pfet_06v0 ad=58.1134p pd=77.985u as=58.1134p ps=77.985u w=76.465u l=1u
X1825 BAT GATE DVDD DVDD pfet_06v0 ad=58.1096p pd=77.98u as=58.1096p ps=77.98u w=76.46u l=1u
X1826 BAT GATE DVDD DVDD pfet_06v0 ad=35.511p pd=48.245u as=35.511p ps=48.245u w=46.725u l=1u
X1827 BAT GATE DVDD DVDD pfet_06v0 ad=35.511p pd=48.245u as=35.511p ps=48.245u w=46.725u l=1u
X1828 DVDD GATE BAT DVDD pfet_06v0 ad=58.1134p pd=77.985u as=58.1134p ps=77.985u w=76.465u l=1u
X1829 BAT GATE DVDD DVDD pfet_06v0 ad=35.511p pd=48.245u as=43.9215p ps=95.32999u w=46.725u l=1u
X1830 DVDD GATE BAT DVDD pfet_06v0 ad=71.8818p pd=0.15482m as=58.1172p ps=77.99u w=76.47u l=1u
X1831 BAT GATE DVDD DVDD pfet_06v0 ad=35.511p pd=48.245u as=43.9215p ps=95.32999u w=46.725u l=1u
X1832 DVDD GATE BAT DVDD pfet_06v0 ad=35.511p pd=48.245u as=35.511p ps=48.245u w=46.725u l=1u
X1833 DVDD GATE BAT DVDD pfet_06v0 ad=58.1134p pd=77.985u as=58.1134p ps=77.985u w=76.465u l=1u
X1834 BAT GATE DVDD DVDD pfet_06v0 ad=35.511p pd=48.245u as=43.9215p ps=95.32999u w=46.725u l=1u
X1835 DVDD GATE BAT DVDD pfet_06v0 ad=35.511p pd=48.245u as=35.511p ps=48.245u w=46.725u l=1u
X1836 BAT GATE DVDD DVDD pfet_06v0 ad=35.511p pd=48.245u as=43.9215p ps=95.32999u w=46.725u l=1u
X1837 BAT GATE DVDD DVDD pfet_06v0 ad=58.1552p pd=78.04u as=58.1552p ps=78.04u w=76.52u l=1u
X1838 DVDD GATE BAT DVDD pfet_06v0 ad=58.1134p pd=77.985u as=58.1134p ps=77.985u w=76.465u l=1u
X1839 DVDD GATE BAT DVDD pfet_06v0 ad=71.92879p pd=0.15492m as=58.1552p ps=78.04u w=76.52u l=1u
X1840 BAT GATE DVDD DVDD pfet_06v0 ad=58.1134p pd=77.985u as=71.8771p ps=0.15481m w=76.465u l=1u
X1841 BAT GATE DVDD DVDD pfet_06v0 ad=35.511p pd=48.245u as=35.511p ps=48.245u w=46.725u l=1u
X1842 DVDD GATE BAT DVDD pfet_06v0 ad=35.511p pd=48.245u as=35.511p ps=48.245u w=46.725u l=1u
X1843 BAT GATE DVDD DVDD pfet_06v0 ad=35.511p pd=48.245u as=43.9215p ps=95.32999u w=46.725u l=1u
X1844 BAT GATE DVDD DVDD pfet_06v0 ad=35.511p pd=48.245u as=35.511p ps=48.245u w=46.725u l=1u
X1845 DVDD GATE BAT DVDD pfet_06v0 ad=58.1134p pd=77.985u as=58.1134p ps=77.985u w=76.465u l=1u
X1846 BAT GATE DVDD DVDD pfet_06v0 ad=58.0754p pd=77.935u as=58.0754p ps=77.935u w=76.41499u l=1u
X1847 DVDD GATE BAT DVDD pfet_06v0 ad=71.8771p pd=0.15481m as=58.1134p ps=77.985u w=76.465u l=1u
X1848 DVDD GATE BAT DVDD pfet_06v0 ad=71.8771p pd=0.15481m as=58.1134p ps=77.985u w=76.465u l=1u
X1849 DVDD GATE BAT DVDD pfet_06v0 ad=58.1096p pd=77.98u as=58.1096p ps=77.98u w=76.46u l=1u
X1850 DVDD GATE BAT DVDD pfet_06v0 ad=35.511p pd=48.245u as=35.511p ps=48.245u w=46.725u l=1u
X1851 DVDD GATE BAT DVDD pfet_06v0 ad=58.1134p pd=77.985u as=58.1134p ps=77.985u w=76.465u l=1u
X1852 BAT GATE DVDD DVDD pfet_06v0 ad=35.511p pd=48.245u as=35.511p ps=48.245u w=46.725u l=1u
X1853 BAT GATE DVDD DVDD pfet_06v0 ad=58.1134p pd=77.985u as=58.1134p ps=77.985u w=76.465u l=1u
X1854 BAT GATE DVDD DVDD pfet_06v0 ad=58.1134p pd=77.985u as=58.1134p ps=77.985u w=76.465u l=1u
X1855 DVDD GATE BAT DVDD pfet_06v0 ad=35.5072p pd=48.24u as=35.5072p ps=48.24u w=46.72u l=1u
X1856 DVDD GATE BAT DVDD pfet_06v0 ad=58.1134p pd=77.985u as=58.1134p ps=77.985u w=76.465u l=1u
X1857 BAT GATE DVDD DVDD pfet_06v0 ad=58.1134p pd=77.985u as=58.1134p ps=77.985u w=76.465u l=1u
X1858 DVDD GATE BAT DVDD pfet_06v0 ad=35.511p pd=48.245u as=35.511p ps=48.245u w=46.725u l=1u
X1859 DVDD GATE BAT DVDD pfet_06v0 ad=49.3848p pd=66.5u as=49.3848p ps=66.5u w=64.98u l=1u
X1860 BAT GATE DVDD DVDD pfet_06v0 ad=58.1134p pd=77.985u as=58.1134p ps=77.985u w=76.465u l=1u
X1861 DVDD GATE BAT DVDD pfet_06v0 ad=61.0812p pd=0.13184m as=49.3848p ps=66.5u w=64.98u l=1u
X1862 DVDD GATE BAT DVDD pfet_06v0 ad=58.1134p pd=77.985u as=58.1134p ps=77.985u w=76.465u l=1u
X1863 DVDD GATE BAT DVDD pfet_06v0 ad=58.1134p pd=77.985u as=58.1134p ps=77.985u w=76.465u l=1u
X1864 DVDD GATE BAT DVDD pfet_06v0 ad=47.6862p pd=64.265u as=47.6862p ps=64.265u w=62.745u l=1u
X1865 BAT GATE DVDD DVDD pfet_06v0 ad=58.1096p pd=77.98u as=58.1096p ps=77.98u w=76.46u l=1u
X1866 DVDD GATE BAT DVDD pfet_06v0 ad=35.511p pd=48.245u as=35.511p ps=48.245u w=46.725u l=1u
X1867 BAT GATE DVDD DVDD pfet_06v0 ad=58.0754p pd=77.935u as=58.0754p ps=77.935u w=76.41499u l=1u
X1868 BAT GATE DVDD DVDD pfet_06v0 ad=58.1134p pd=77.985u as=58.1134p ps=77.985u w=76.465u l=1u
X1869 DVDD GATE BAT DVDD pfet_06v0 ad=35.511p pd=48.245u as=35.511p ps=48.245u w=46.725u l=1u
X1870 DVDD GATE BAT DVDD pfet_06v0 ad=71.92879p pd=0.15492m as=58.1552p ps=78.04u w=76.52u l=1u
X1871 BAT GATE DVDD DVDD pfet_06v0 ad=35.511p pd=48.245u as=35.511p ps=48.245u w=46.725u l=1u
X1872 BAT GATE DVDD DVDD pfet_06v0 ad=35.511p pd=48.245u as=35.511p ps=48.245u w=46.725u l=1u
X1873 DVDD GATE BAT DVDD pfet_06v0 ad=35.511p pd=48.245u as=35.511p ps=48.245u w=46.725u l=1u
X1874 DVDD GATE BAT DVDD pfet_06v0 ad=58.1134p pd=77.985u as=58.1134p ps=77.985u w=76.465u l=1u
X1875 BAT GATE DVDD DVDD pfet_06v0 ad=58.0754p pd=77.935u as=58.0754p ps=77.935u w=76.41499u l=1u
X1876 BAT GATE DVDD DVDD pfet_06v0 ad=47.6862p pd=64.265u as=47.6862p ps=64.265u w=62.745u l=1u
X1877 BAT GATE DVDD DVDD pfet_06v0 ad=58.1134p pd=77.985u as=58.1134p ps=77.985u w=76.465u l=1u
X1878 BAT GATE DVDD DVDD pfet_06v0 ad=35.511p pd=48.245u as=35.511p ps=48.245u w=46.725u l=1u
X1879 BAT GATE DVDD DVDD pfet_06v0 ad=35.5072p pd=48.24u as=35.5072p ps=48.24u w=46.72u l=1u
X1880 DVDD GATE BAT DVDD pfet_06v0 ad=35.511p pd=48.245u as=35.511p ps=48.245u w=46.725u l=1u
X1881 BAT GATE DVDD DVDD pfet_06v0 ad=35.511p pd=48.245u as=35.511p ps=48.245u w=46.725u l=1u
X1882 DVDD GATE BAT DVDD pfet_06v0 ad=43.9215p pd=95.32999u as=35.511p ps=48.245u w=46.725u l=1u
X1883 DVDD GATE BAT DVDD pfet_06v0 ad=35.511p pd=48.245u as=35.511p ps=48.245u w=46.725u l=1u
X1884 BAT GATE DVDD DVDD pfet_06v0 ad=35.5072p pd=48.24u as=35.5072p ps=48.24u w=46.72u l=1u
X1885 DVDD GATE BAT DVDD pfet_06v0 ad=35.511p pd=48.245u as=35.511p ps=48.245u w=46.725u l=1u
X1886 BAT GATE DVDD DVDD pfet_06v0 ad=58.1134p pd=77.985u as=58.1134p ps=77.985u w=76.465u l=1u
X1887 DVDD GATE BAT DVDD pfet_06v0 ad=43.9215p pd=95.32999u as=35.511p ps=48.245u w=46.725u l=1u
X1888 DVDD GATE BAT DVDD pfet_06v0 ad=43.9215p pd=95.32999u as=35.511p ps=48.245u w=46.725u l=1u
X1889 DVDD GATE BAT DVDD pfet_06v0 ad=35.5072p pd=48.24u as=35.5072p ps=48.24u w=46.72u l=1u
X1890 BAT GATE DVDD DVDD pfet_06v0 ad=58.1172p pd=77.99u as=58.1172p ps=77.99u w=76.47u l=1u
X1891 BAT GATE DVDD DVDD pfet_06v0 ad=35.511p pd=48.245u as=35.511p ps=48.245u w=46.725u l=1u
X1892 BAT GATE DVDD DVDD pfet_06v0 ad=58.1096p pd=77.98u as=58.1096p ps=77.98u w=76.46u l=1u
X1893 BAT GATE DVDD DVDD pfet_06v0 ad=58.1134p pd=77.985u as=58.1134p ps=77.985u w=76.465u l=1u
X1894 BAT GATE DVDD DVDD pfet_06v0 ad=58.1134p pd=77.985u as=71.8771p ps=0.15481m w=76.465u l=1u
X1895 BAT GATE DVDD DVDD pfet_06v0 ad=35.511p pd=48.245u as=35.511p ps=48.245u w=46.725u l=1u
X1896 DVDD GATE BAT DVDD pfet_06v0 ad=35.511p pd=48.245u as=35.511p ps=48.245u w=46.725u l=1u
X1897 DVDD GATE BAT DVDD pfet_06v0 ad=71.92879p pd=0.15492m as=58.1552p ps=78.04u w=76.52u l=1u
X1898 BAT GATE DVDD DVDD pfet_06v0 ad=58.1134p pd=77.985u as=58.1134p ps=77.985u w=76.465u l=1u
X1899 BAT GATE DVDD DVDD pfet_06v0 ad=47.6862p pd=64.265u as=47.6862p ps=64.265u w=62.745u l=1u
X1900 BAT GATE DVDD DVDD pfet_06v0 ad=58.1552p pd=78.04u as=58.1552p ps=78.04u w=76.52u l=1u
X1901 DVDD GATE BAT DVDD pfet_06v0 ad=35.511p pd=48.245u as=35.511p ps=48.245u w=46.725u l=1u
X1902 BAT GATE DVDD DVDD pfet_06v0 ad=35.511p pd=48.245u as=35.511p ps=48.245u w=46.725u l=1u
X1903 BAT GATE DVDD DVDD pfet_06v0 ad=35.511p pd=48.245u as=35.511p ps=48.245u w=46.725u l=1u
X1904 DVDD GATE BAT DVDD pfet_06v0 ad=71.8771p pd=0.15481m as=58.1134p ps=77.985u w=76.465u l=1u
X1905 BAT GATE DVDD DVDD pfet_06v0 ad=58.1134p pd=77.985u as=58.1134p ps=77.985u w=76.465u l=1u
X1906 DVDD GATE BAT DVDD pfet_06v0 ad=58.1134p pd=77.985u as=58.1134p ps=77.985u w=76.465u l=1u
X1907 BAT GATE DVDD DVDD pfet_06v0 ad=35.511p pd=48.245u as=35.511p ps=48.245u w=46.725u l=1u
X1908 BAT GATE DVDD DVDD pfet_06v0 ad=58.1134p pd=77.985u as=58.1134p ps=77.985u w=76.465u l=1u
X1909 BAT GATE DVDD DVDD pfet_06v0 ad=35.511p pd=48.245u as=35.511p ps=48.245u w=46.725u l=1u
X1910 BAT GATE DVDD DVDD pfet_06v0 ad=58.1134p pd=77.985u as=58.1134p ps=77.985u w=76.465u l=1u
X1911 DVDD GATE BAT DVDD pfet_06v0 ad=35.511p pd=48.245u as=35.511p ps=48.245u w=46.725u l=1u
X1912 BAT GATE DVDD DVDD pfet_06v0 ad=35.511p pd=48.245u as=35.511p ps=48.245u w=46.725u l=1u
X1913 BAT GATE DVDD DVDD pfet_06v0 ad=35.511p pd=48.245u as=35.511p ps=48.245u w=46.725u l=1u
X1914 DVDD GATE BAT DVDD pfet_06v0 ad=71.8818p pd=0.15482m as=58.1172p ps=77.99u w=76.47u l=1u
X1915 DVDD GATE BAT DVDD pfet_06v0 ad=35.511p pd=48.245u as=35.511p ps=48.245u w=46.725u l=1u
X1916 DVDD GATE BAT DVDD pfet_06v0 ad=43.9215p pd=95.32999u as=35.511p ps=48.245u w=46.725u l=1u
X1917 BAT GATE DVDD DVDD pfet_06v0 ad=58.0754p pd=77.935u as=71.8301p ps=0.15471m w=76.41499u l=1u
X1918 BAT GATE DVDD DVDD pfet_06v0 ad=35.511p pd=48.245u as=35.511p ps=48.245u w=46.725u l=1u
X1919 BAT GATE DVDD DVDD pfet_06v0 ad=58.1134p pd=77.985u as=58.1134p ps=77.985u w=76.465u l=1u
X1920 DVDD GATE BAT DVDD pfet_06v0 ad=35.511p pd=48.245u as=35.511p ps=48.245u w=46.725u l=1u
X1921 DVDD GATE BAT DVDD pfet_06v0 ad=35.511p pd=48.245u as=35.511p ps=48.245u w=46.725u l=1u
X1922 BAT GATE DVDD DVDD pfet_06v0 ad=35.5072p pd=48.24u as=35.5072p ps=48.24u w=46.72u l=1u
X1923 DVDD GATE BAT DVDD pfet_06v0 ad=71.8771p pd=0.15481m as=58.1134p ps=77.985u w=76.465u l=1u
X1924 DVDD GATE BAT DVDD pfet_06v0 ad=71.8771p pd=0.15481m as=58.1134p ps=77.985u w=76.465u l=1u
X1925 BAT GATE DVDD DVDD pfet_06v0 ad=49.3848p pd=66.5u as=49.3848p ps=66.5u w=64.98u l=1u
X1926 DVDD GATE BAT DVDD pfet_06v0 ad=58.1134p pd=77.985u as=58.1134p ps=77.985u w=76.465u l=1u
X1927 BAT GATE DVDD DVDD pfet_06v0 ad=58.1134p pd=77.985u as=58.1134p ps=77.985u w=76.465u l=1u
X1928 DVDD GATE BAT DVDD pfet_06v0 ad=35.511p pd=48.245u as=35.511p ps=48.245u w=46.725u l=1u
X1929 BAT GATE DVDD DVDD pfet_06v0 ad=58.1172p pd=77.99u as=58.1172p ps=77.99u w=76.47u l=1u
X1930 BAT GATE DVDD DVDD pfet_06v0 ad=35.511p pd=48.245u as=43.9215p ps=95.32999u w=46.725u l=1u
X1931 DVDD GATE BAT DVDD pfet_06v0 ad=35.511p pd=48.245u as=35.511p ps=48.245u w=46.725u l=1u
X1932 BAT GATE DVDD DVDD pfet_06v0 ad=58.1134p pd=77.985u as=58.1134p ps=77.985u w=76.465u l=1u
X1933 BAT GATE DVDD DVDD pfet_06v0 ad=35.511p pd=48.245u as=43.9215p ps=95.32999u w=46.725u l=1u
X1934 BAT GATE DVDD DVDD pfet_06v0 ad=35.511p pd=48.245u as=35.511p ps=48.245u w=46.725u l=1u
X1935 BAT GATE DVDD DVDD pfet_06v0 ad=58.1134p pd=77.985u as=58.1134p ps=77.985u w=76.465u l=1u
X1936 DVDD GATE BAT DVDD pfet_06v0 ad=58.1134p pd=77.985u as=58.1134p ps=77.985u w=76.465u l=1u
X1937 BAT GATE DVDD DVDD pfet_06v0 ad=58.1134p pd=77.985u as=71.8771p ps=0.15481m w=76.465u l=1u
X1938 BAT GATE DVDD DVDD pfet_06v0 ad=58.1134p pd=77.985u as=71.8771p ps=0.15481m w=76.465u l=1u
X1939 BAT GATE DVDD DVDD pfet_06v0 ad=35.511p pd=48.245u as=35.511p ps=48.245u w=46.725u l=1u
X1940 BAT GATE DVDD DVDD pfet_06v0 ad=47.6862p pd=64.265u as=47.6862p ps=64.265u w=62.745u l=1u
X1941 DVDD GATE BAT DVDD pfet_06v0 ad=58.1134p pd=77.985u as=58.1134p ps=77.985u w=76.465u l=1u
X1942 BAT GATE DVDD DVDD pfet_06v0 ad=58.1134p pd=77.985u as=58.1134p ps=77.985u w=76.465u l=1u
X1943 DVDD GATE BAT DVDD pfet_06v0 ad=71.8771p pd=0.15481m as=58.1134p ps=77.985u w=76.465u l=1u
X1944 BAT GATE DVDD DVDD pfet_06v0 ad=58.1096p pd=77.98u as=71.8724p ps=0.1548m w=76.46u l=1u
X1945 BAT GATE DVDD DVDD pfet_06v0 ad=58.1134p pd=77.985u as=58.1134p ps=77.985u w=76.465u l=1u
X1946 BAT GATE DVDD DVDD pfet_06v0 ad=35.511p pd=48.245u as=43.9215p ps=95.32999u w=46.725u l=1u
X1947 DVDD GATE BAT DVDD pfet_06v0 ad=35.511p pd=48.245u as=35.511p ps=48.245u w=46.725u l=1u
X1948 DVDD GATE BAT DVDD pfet_06v0 ad=71.8301p pd=0.15471m as=58.0754p ps=77.935u w=76.41499u l=1u
X1949 BAT GATE DVDD DVDD pfet_06v0 ad=58.1134p pd=77.985u as=71.8771p ps=0.15481m w=76.465u l=1u
X1950 DVDD GATE BAT DVDD pfet_06v0 ad=58.1134p pd=77.985u as=58.1134p ps=77.985u w=76.465u l=1u
X1951 DVDD GATE BAT DVDD pfet_06v0 ad=58.1134p pd=77.985u as=58.1134p ps=77.985u w=76.465u l=1u
X1952 DVDD GATE BAT DVDD pfet_06v0 ad=35.511p pd=48.245u as=35.511p ps=48.245u w=46.725u l=1u
X1953 BAT GATE DVDD DVDD pfet_06v0 ad=49.3848p pd=66.5u as=49.3848p ps=66.5u w=64.98u l=1u
X1954 DVDD GATE BAT DVDD pfet_06v0 ad=71.8818p pd=0.15482m as=58.1172p ps=77.99u w=76.47u l=1u
X1955 DVDD GATE BAT DVDD pfet_06v0 ad=47.6862p pd=64.265u as=47.6862p ps=64.265u w=62.745u l=1u
X1956 BAT GATE DVDD DVDD pfet_06v0 ad=58.1134p pd=77.985u as=58.1134p ps=77.985u w=76.465u l=1u
X1957 BAT GATE DVDD DVDD pfet_06v0 ad=58.1172p pd=77.99u as=58.1172p ps=77.99u w=76.47u l=1u
X1958 BAT GATE DVDD DVDD pfet_06v0 ad=35.5072p pd=48.24u as=35.5072p ps=48.24u w=46.72u l=1u
X1959 BAT GATE DVDD DVDD pfet_06v0 ad=35.511p pd=48.245u as=35.511p ps=48.245u w=46.725u l=1u
X1960 DVDD GATE BAT DVDD pfet_06v0 ad=58.1134p pd=77.985u as=58.1134p ps=77.985u w=76.465u l=1u
X1961 BAT GATE DVDD DVDD pfet_06v0 ad=35.511p pd=48.245u as=35.511p ps=48.245u w=46.725u l=1u
X1962 DVDD GATE BAT DVDD pfet_06v0 ad=58.1096p pd=77.98u as=58.1096p ps=77.98u w=76.46u l=1u
X1963 DVDD GATE BAT DVDD pfet_06v0 ad=35.511p pd=48.245u as=35.511p ps=48.245u w=46.725u l=1u
X1964 DVDD GATE BAT DVDD pfet_06v0 ad=71.8771p pd=0.15481m as=58.1134p ps=77.985u w=76.465u l=1u
X1965 DVDD GATE BAT DVDD pfet_06v0 ad=43.9215p pd=95.32999u as=35.511p ps=48.245u w=46.725u l=1u
X1966 DVDD GATE BAT DVDD pfet_06v0 ad=58.1134p pd=77.985u as=58.1134p ps=77.985u w=76.465u l=1u
X1967 BAT GATE DVDD DVDD pfet_06v0 ad=58.1134p pd=77.985u as=58.1134p ps=77.985u w=76.465u l=1u
X1968 BAT GATE DVDD DVDD pfet_06v0 ad=58.0754p pd=77.935u as=58.0754p ps=77.935u w=76.41499u l=1u
X1969 BAT GATE DVDD DVDD pfet_06v0 ad=35.511p pd=48.245u as=35.511p ps=48.245u w=46.725u l=1u
X1970 DVDD GATE BAT DVDD pfet_06v0 ad=58.1134p pd=77.985u as=58.1134p ps=77.985u w=76.465u l=1u
X1971 DVDD GATE BAT DVDD pfet_06v0 ad=58.1134p pd=77.985u as=58.1134p ps=77.985u w=76.465u l=1u
X1972 BAT GATE DVDD DVDD pfet_06v0 ad=35.511p pd=48.245u as=35.511p ps=48.245u w=46.725u l=1u
X1973 DVDD GATE BAT DVDD pfet_06v0 ad=35.511p pd=48.245u as=35.511p ps=48.245u w=46.725u l=1u
X1974 DVDD GATE BAT DVDD pfet_06v0 ad=35.511p pd=48.245u as=35.511p ps=48.245u w=46.725u l=1u
X1975 DVDD GATE BAT DVDD pfet_06v0 ad=35.511p pd=48.245u as=35.511p ps=48.245u w=46.725u l=1u
X1976 DVDD GATE BAT DVDD pfet_06v0 ad=35.5072p pd=48.24u as=35.5072p ps=48.24u w=46.72u l=1u
X1977 BAT GATE DVDD DVDD pfet_06v0 ad=35.511p pd=48.245u as=35.511p ps=48.245u w=46.725u l=1u
X1978 DVDD GATE BAT DVDD pfet_06v0 ad=35.511p pd=48.245u as=35.511p ps=48.245u w=46.725u l=1u
X1979 DVDD GATE BAT DVDD pfet_06v0 ad=58.1096p pd=77.98u as=58.1096p ps=77.98u w=76.46u l=1u
X1980 DVDD GATE BAT DVDD pfet_06v0 ad=35.511p pd=48.245u as=35.511p ps=48.245u w=46.725u l=1u
X1981 BAT GATE DVDD DVDD pfet_06v0 ad=58.1134p pd=77.985u as=58.1134p ps=77.985u w=76.465u l=1u
X1982 BAT GATE DVDD DVDD pfet_06v0 ad=35.511p pd=48.245u as=35.511p ps=48.245u w=46.725u l=1u
X1983 BAT GATE DVDD DVDD pfet_06v0 ad=58.1096p pd=77.98u as=71.8724p ps=0.1548m w=76.46u l=1u
X1984 BAT GATE DVDD DVDD pfet_06v0 ad=47.6862p pd=64.265u as=47.6862p ps=64.265u w=62.745u l=1u
X1985 DVDD GATE BAT DVDD pfet_06v0 ad=35.5072p pd=48.24u as=35.5072p ps=48.24u w=46.72u l=1u
X1986 BAT GATE DVDD DVDD pfet_06v0 ad=58.1134p pd=77.985u as=58.1134p ps=77.985u w=76.465u l=1u
X1987 BAT GATE DVDD DVDD pfet_06v0 ad=35.511p pd=48.245u as=35.511p ps=48.245u w=46.725u l=1u
X1988 DVDD GATE BAT DVDD pfet_06v0 ad=35.511p pd=48.245u as=35.511p ps=48.245u w=46.725u l=1u
X1989 DVDD GATE BAT DVDD pfet_06v0 ad=58.1096p pd=77.98u as=58.1096p ps=77.98u w=76.46u l=1u
X1990 BAT GATE DVDD DVDD pfet_06v0 ad=35.511p pd=48.245u as=35.511p ps=48.245u w=46.725u l=1u
X1991 BAT GATE DVDD DVDD pfet_06v0 ad=35.511p pd=48.245u as=35.511p ps=48.245u w=46.725u l=1u
X1992 DVDD GATE BAT DVDD pfet_06v0 ad=58.1172p pd=77.99u as=58.1172p ps=77.99u w=76.47u l=1u
X1993 DVDD GATE BAT DVDD pfet_06v0 ad=58.0754p pd=77.935u as=58.0754p ps=77.935u w=76.41499u l=1u
X1994 BAT GATE DVDD DVDD pfet_06v0 ad=35.5072p pd=48.24u as=35.5072p ps=48.24u w=46.72u l=1u
X1995 BAT GATE DVDD DVDD pfet_06v0 ad=35.511p pd=48.245u as=35.511p ps=48.245u w=46.725u l=1u
X1996 DVDD GATE BAT DVDD pfet_06v0 ad=35.5072p pd=48.24u as=35.5072p ps=48.24u w=46.72u l=1u
X1997 BAT GATE DVDD DVDD pfet_06v0 ad=35.511p pd=48.245u as=35.511p ps=48.245u w=46.725u l=1u
X1998 BAT GATE DVDD DVDD pfet_06v0 ad=35.511p pd=48.245u as=35.511p ps=48.245u w=46.725u l=1u
X1999 BAT GATE DVDD DVDD pfet_06v0 ad=35.511p pd=48.245u as=35.511p ps=48.245u w=46.725u l=1u
X2000 BAT GATE DVDD DVDD pfet_06v0 ad=58.0754p pd=77.935u as=58.0754p ps=77.935u w=76.41499u l=1u
X2001 BAT GATE DVDD DVDD pfet_06v0 ad=35.511p pd=48.245u as=35.511p ps=48.245u w=46.725u l=1u
X2002 DVDD GATE BAT DVDD pfet_06v0 ad=35.511p pd=48.245u as=35.511p ps=48.245u w=46.725u l=1u
X2003 DVDD GATE BAT DVDD pfet_06v0 ad=47.6862p pd=64.265u as=47.6862p ps=64.265u w=62.745u l=1u
X2004 BAT GATE DVDD DVDD pfet_06v0 ad=35.5072p pd=48.24u as=35.5072p ps=48.24u w=46.72u l=1u
X2005 BAT GATE DVDD DVDD pfet_06v0 ad=35.511p pd=48.245u as=43.9215p ps=95.32999u w=46.725u l=1u
X2006 BAT GATE DVDD DVDD pfet_06v0 ad=58.1134p pd=77.985u as=58.1134p ps=77.985u w=76.465u l=1u
X2007 DVDD GATE BAT DVDD pfet_06v0 ad=58.1134p pd=77.985u as=58.1134p ps=77.985u w=76.465u l=1u
X2008 DVDD GATE BAT DVDD pfet_06v0 ad=43.9215p pd=95.32999u as=35.511p ps=48.245u w=46.725u l=1u
X2009 DVDD GATE BAT DVDD pfet_06v0 ad=58.1134p pd=77.985u as=58.1134p ps=77.985u w=76.465u l=1u
X2010 DVDD GATE BAT DVDD pfet_06v0 ad=58.1134p pd=77.985u as=58.1134p ps=77.985u w=76.465u l=1u
X2011 DVDD GATE BAT DVDD pfet_06v0 ad=35.511p pd=48.245u as=35.511p ps=48.245u w=46.725u l=1u
X2012 BAT GATE DVDD DVDD pfet_06v0 ad=58.1172p pd=77.99u as=71.8818p ps=0.15482m w=76.47u l=1u
X2013 DVDD GATE BAT DVDD pfet_06v0 ad=35.511p pd=48.245u as=35.511p ps=48.245u w=46.725u l=1u
X2014 BAT GATE DVDD DVDD pfet_06v0 ad=58.1134p pd=77.985u as=58.1134p ps=77.985u w=76.465u l=1u
X2015 BAT GATE DVDD DVDD pfet_06v0 ad=35.511p pd=48.245u as=35.511p ps=48.245u w=46.725u l=1u
X2016 DVDD GATE BAT DVDD pfet_06v0 ad=35.511p pd=48.245u as=35.511p ps=48.245u w=46.725u l=1u
X2017 DVDD GATE BAT DVDD pfet_06v0 ad=58.1096p pd=77.98u as=58.1096p ps=77.98u w=76.46u l=1u
X2018 BAT GATE DVDD DVDD pfet_06v0 ad=35.511p pd=48.245u as=43.9215p ps=95.32999u w=46.725u l=1u
X2019 DVDD GATE BAT DVDD pfet_06v0 ad=35.511p pd=48.245u as=35.511p ps=48.245u w=46.725u l=1u
X2020 BAT GATE DVDD DVDD pfet_06v0 ad=35.511p pd=48.245u as=43.9215p ps=95.32999u w=46.725u l=1u
X2021 BAT GATE DVDD DVDD pfet_06v0 ad=58.1134p pd=77.985u as=71.8771p ps=0.15481m w=76.465u l=1u
X2022 DVDD GATE BAT DVDD pfet_06v0 ad=58.1134p pd=77.985u as=58.1134p ps=77.985u w=76.465u l=1u
X2023 DVDD GATE BAT DVDD pfet_06v0 ad=58.1134p pd=77.985u as=58.1134p ps=77.985u w=76.465u l=1u
X2024 DVDD GATE BAT DVDD pfet_06v0 ad=35.511p pd=48.245u as=35.511p ps=48.245u w=46.725u l=1u
X2025 BAT GATE DVDD DVDD pfet_06v0 ad=35.511p pd=48.245u as=35.511p ps=48.245u w=46.725u l=1u
X2026 BAT GATE DVDD DVDD pfet_06v0 ad=35.511p pd=48.245u as=35.511p ps=48.245u w=46.725u l=1u
X2027 DVDD GATE BAT DVDD pfet_06v0 ad=43.9168p pd=95.32u as=35.5072p ps=48.24u w=46.72u l=1u
X2028 DVDD GATE BAT DVDD pfet_06v0 ad=35.511p pd=48.245u as=35.511p ps=48.245u w=46.725u l=1u
X2029 BAT GATE DVDD DVDD pfet_06v0 ad=58.1134p pd=77.985u as=58.1134p ps=77.985u w=76.465u l=1u
X2030 DVDD GATE BAT DVDD pfet_06v0 ad=35.511p pd=48.245u as=35.511p ps=48.245u w=46.725u l=1u
X2031 BAT GATE DVDD DVDD pfet_06v0 ad=58.1134p pd=77.985u as=58.1134p ps=77.985u w=76.465u l=1u
X2032 DVDD GATE BAT DVDD pfet_06v0 ad=58.1134p pd=77.985u as=58.1134p ps=77.985u w=76.465u l=1u
X2033 DVDD GATE BAT DVDD pfet_06v0 ad=58.1134p pd=77.985u as=58.1134p ps=77.985u w=76.465u l=1u
X2034 BAT GATE DVDD DVDD pfet_06v0 ad=35.5072p pd=48.24u as=35.5072p ps=48.24u w=46.72u l=1u
X2035 BAT GATE DVDD DVDD pfet_06v0 ad=47.6862p pd=64.265u as=58.9803p ps=0.12737m w=62.745u l=1u
X2036 DVDD GATE BAT DVDD pfet_06v0 ad=71.8771p pd=0.15481m as=58.1134p ps=77.985u w=76.465u l=1u
X2037 DVDD GATE BAT DVDD pfet_06v0 ad=47.6862p pd=64.265u as=47.6862p ps=64.265u w=62.745u l=1u
X2038 DVDD GATE BAT DVDD pfet_06v0 ad=43.9215p pd=95.32999u as=35.511p ps=48.245u w=46.725u l=1u
X2039 DVDD GATE BAT DVDD pfet_06v0 ad=58.1134p pd=77.985u as=58.1134p ps=77.985u w=76.465u l=1u
X2040 BAT GATE DVDD DVDD pfet_06v0 ad=58.1552p pd=78.04u as=58.1552p ps=78.04u w=76.52u l=1u
X2041 DVDD GATE BAT DVDD pfet_06v0 ad=43.9215p pd=95.32999u as=35.511p ps=48.245u w=46.725u l=1u
X2042 BAT GATE DVDD DVDD pfet_06v0 ad=35.511p pd=48.245u as=35.511p ps=48.245u w=46.725u l=1u
X2043 BAT GATE DVDD DVDD pfet_06v0 ad=58.1134p pd=77.985u as=58.1134p ps=77.985u w=76.465u l=1u
X2044 DVDD GATE BAT DVDD pfet_06v0 ad=58.1172p pd=77.99u as=58.1172p ps=77.99u w=76.47u l=1u
X2045 DVDD GATE BAT DVDD pfet_06v0 ad=58.1134p pd=77.985u as=58.1134p ps=77.985u w=76.465u l=1u
X2046 DVDD GATE BAT DVDD pfet_06v0 ad=58.1134p pd=77.985u as=58.1134p ps=77.985u w=76.465u l=1u
X2047 DVDD GATE BAT DVDD pfet_06v0 ad=35.511p pd=48.245u as=35.511p ps=48.245u w=46.725u l=1u
X2048 DVDD GATE BAT DVDD pfet_06v0 ad=58.1096p pd=77.98u as=58.1096p ps=77.98u w=76.46u l=1u
X2049 DVDD GATE BAT DVDD pfet_06v0 ad=58.1134p pd=77.985u as=58.1134p ps=77.985u w=76.465u l=1u
X2050 BAT GATE DVDD DVDD pfet_06v0 ad=58.1134p pd=77.985u as=71.8771p ps=0.15481m w=76.465u l=1u
X2051 BAT GATE DVDD DVDD pfet_06v0 ad=58.1172p pd=77.99u as=58.1172p ps=77.99u w=76.47u l=1u
X2052 BAT GATE DVDD DVDD pfet_06v0 ad=35.511p pd=48.245u as=35.511p ps=48.245u w=46.725u l=1u
X2053 DVDD GATE BAT DVDD pfet_06v0 ad=35.511p pd=48.245u as=35.511p ps=48.245u w=46.725u l=1u
X2054 BAT GATE DVDD DVDD pfet_06v0 ad=35.511p pd=48.245u as=35.511p ps=48.245u w=46.725u l=1u
X2055 BAT GATE DVDD DVDD pfet_06v0 ad=58.1134p pd=77.985u as=71.8771p ps=0.15481m w=76.465u l=1u
X2056 DVDD GATE BAT DVDD pfet_06v0 ad=58.0754p pd=77.935u as=58.0754p ps=77.935u w=76.41499u l=1u
X2057 DVDD GATE BAT DVDD pfet_06v0 ad=49.3848p pd=66.5u as=49.3848p ps=66.5u w=64.98u l=1u
X2058 DVDD GATE BAT DVDD pfet_06v0 ad=58.1134p pd=77.985u as=58.1134p ps=77.985u w=76.465u l=1u
X2059 DVDD GATE BAT DVDD pfet_06v0 ad=58.1552p pd=78.04u as=58.1552p ps=78.04u w=76.52u l=1u
X2060 DVDD GATE BAT DVDD pfet_06v0 ad=58.1134p pd=77.985u as=58.1134p ps=77.985u w=76.465u l=1u
X2061 BAT GATE DVDD DVDD pfet_06v0 ad=58.0754p pd=77.935u as=58.0754p ps=77.935u w=76.41499u l=1u
X2062 BAT GATE DVDD DVDD pfet_06v0 ad=47.6862p pd=64.265u as=47.6862p ps=64.265u w=62.745u l=1u
X2063 DVDD GATE BAT DVDD pfet_06v0 ad=49.3848p pd=66.5u as=49.3848p ps=66.5u w=64.98u l=1u
X2064 DVDD GATE BAT DVDD pfet_06v0 ad=35.511p pd=48.245u as=35.511p ps=48.245u w=46.725u l=1u
X2065 BAT GATE DVDD DVDD pfet_06v0 ad=58.1134p pd=77.985u as=58.1134p ps=77.985u w=76.465u l=1u
X2066 DVDD GATE BAT DVDD pfet_06v0 ad=58.1134p pd=77.985u as=58.1134p ps=77.985u w=76.465u l=1u
X2067 BAT GATE DVDD DVDD pfet_06v0 ad=58.1096p pd=77.98u as=58.1096p ps=77.98u w=76.46u l=1u
X2068 BAT GATE DVDD DVDD pfet_06v0 ad=58.1134p pd=77.985u as=58.1134p ps=77.985u w=76.465u l=1u
X2069 DVDD GATE BAT DVDD pfet_06v0 ad=58.0754p pd=77.935u as=58.0754p ps=77.935u w=76.41499u l=1u
X2070 BAT GATE DVDD DVDD pfet_06v0 ad=58.1134p pd=77.985u as=58.1134p ps=77.985u w=76.465u l=1u
X2071 DVDD GATE BAT DVDD pfet_06v0 ad=71.8771p pd=0.15481m as=58.1134p ps=77.985u w=76.465u l=1u
X2072 DVDD GATE BAT DVDD pfet_06v0 ad=35.511p pd=48.245u as=35.511p ps=48.245u w=46.725u l=1u
X2073 BAT GATE DVDD DVDD pfet_06v0 ad=58.1134p pd=77.985u as=58.1134p ps=77.985u w=76.465u l=1u
X2074 DVDD GATE BAT DVDD pfet_06v0 ad=58.1172p pd=77.99u as=58.1172p ps=77.99u w=76.47u l=1u
X2075 BAT GATE DVDD DVDD pfet_06v0 ad=58.1134p pd=77.985u as=58.1134p ps=77.985u w=76.465u l=1u
X2076 DVDD GATE BAT DVDD pfet_06v0 ad=43.9215p pd=95.32999u as=35.511p ps=48.245u w=46.725u l=1u
X2077 BAT GATE DVDD DVDD pfet_06v0 ad=35.511p pd=48.245u as=35.511p ps=48.245u w=46.725u l=1u
X2078 BAT GATE DVDD DVDD pfet_06v0 ad=35.5072p pd=48.24u as=35.5072p ps=48.24u w=46.72u l=1u
X2079 BAT GATE DVDD DVDD pfet_06v0 ad=35.511p pd=48.245u as=35.511p ps=48.245u w=46.725u l=1u
X2080 BAT GATE DVDD DVDD pfet_06v0 ad=58.1096p pd=77.98u as=58.1096p ps=77.98u w=76.46u l=1u
X2081 BAT GATE DVDD DVDD pfet_06v0 ad=58.1134p pd=77.985u as=58.1134p ps=77.985u w=76.465u l=1u
X2082 DVDD GATE BAT DVDD pfet_06v0 ad=58.1172p pd=77.99u as=58.1172p ps=77.99u w=76.47u l=1u
X2083 DVDD GATE BAT DVDD pfet_06v0 ad=35.511p pd=48.245u as=35.511p ps=48.245u w=46.725u l=1u
X2084 BAT GATE DVDD DVDD pfet_06v0 ad=35.511p pd=48.245u as=35.511p ps=48.245u w=46.725u l=1u
X2085 DVDD GATE BAT DVDD pfet_06v0 ad=71.8818p pd=0.15482m as=58.1172p ps=77.99u w=76.47u l=1u
X2086 DVDD GATE BAT DVDD pfet_06v0 ad=58.1134p pd=77.985u as=58.1134p ps=77.985u w=76.465u l=1u
X2087 BAT GATE DVDD DVDD pfet_06v0 ad=58.1096p pd=77.98u as=58.1096p ps=77.98u w=76.46u l=1u
X2088 DVDD GATE BAT DVDD pfet_06v0 ad=35.511p pd=48.245u as=35.511p ps=48.245u w=46.725u l=1u
X2089 BAT GATE DVDD DVDD pfet_06v0 ad=35.5072p pd=48.24u as=43.9168p ps=95.32u w=46.72u l=1u
X2090 BAT GATE DVDD DVDD pfet_06v0 ad=35.511p pd=48.245u as=35.511p ps=48.245u w=46.725u l=1u
X2091 DVDD GATE BAT DVDD pfet_06v0 ad=58.1096p pd=77.98u as=58.1096p ps=77.98u w=76.46u l=1u
X2092 DVDD GATE BAT DVDD pfet_06v0 ad=35.511p pd=48.245u as=35.511p ps=48.245u w=46.725u l=1u
X2093 BAT GATE DVDD DVDD pfet_06v0 ad=35.511p pd=48.245u as=35.511p ps=48.245u w=46.725u l=1u
X2094 DVDD GATE BAT DVDD pfet_06v0 ad=35.511p pd=48.245u as=35.511p ps=48.245u w=46.725u l=1u
X2095 DVDD GATE BAT DVDD pfet_06v0 ad=58.1134p pd=77.985u as=58.1134p ps=77.985u w=76.465u l=1u
X2096 DVDD GATE BAT DVDD pfet_06v0 ad=35.511p pd=48.245u as=35.511p ps=48.245u w=46.725u l=1u
X2097 DVDD GATE BAT DVDD pfet_06v0 ad=35.511p pd=48.245u as=35.511p ps=48.245u w=46.725u l=1u
X2098 BAT GATE DVDD DVDD pfet_06v0 ad=58.1134p pd=77.985u as=58.1134p ps=77.985u w=76.465u l=1u
X2099 BAT GATE DVDD DVDD pfet_06v0 ad=58.1134p pd=77.985u as=58.1134p ps=77.985u w=76.465u l=1u
X2100 DVDD GATE BAT DVDD pfet_06v0 ad=58.0754p pd=77.935u as=58.0754p ps=77.935u w=76.41499u l=1u
X2101 DVDD GATE BAT DVDD pfet_06v0 ad=43.9215p pd=95.32999u as=35.511p ps=48.245u w=46.725u l=1u
X2102 BAT GATE DVDD DVDD pfet_06v0 ad=58.1134p pd=77.985u as=58.1134p ps=77.985u w=76.465u l=1u
X2103 BAT GATE DVDD DVDD pfet_06v0 ad=35.511p pd=48.245u as=35.511p ps=48.245u w=46.725u l=1u
X2104 DVDD GATE BAT DVDD pfet_06v0 ad=47.6862p pd=64.265u as=47.6862p ps=64.265u w=62.745u l=1u
X2105 DVDD GATE BAT DVDD pfet_06v0 ad=58.1134p pd=77.985u as=58.1134p ps=77.985u w=76.465u l=1u
X2106 DVDD GATE BAT DVDD pfet_06v0 ad=71.92879p pd=0.15492m as=58.1552p ps=78.04u w=76.52u l=1u
X2107 BAT GATE DVDD DVDD pfet_06v0 ad=58.1134p pd=77.985u as=58.1134p ps=77.985u w=76.465u l=1u
X2108 DVDD GATE BAT DVDD pfet_06v0 ad=58.1172p pd=77.99u as=58.1172p ps=77.99u w=76.47u l=1u
X2109 DVDD GATE BAT DVDD pfet_06v0 ad=43.9215p pd=95.32999u as=35.511p ps=48.245u w=46.725u l=1u
X2110 DVDD GATE BAT DVDD pfet_06v0 ad=58.1134p pd=77.985u as=58.1134p ps=77.985u w=76.465u l=1u
X2111 BAT GATE DVDD DVDD pfet_06v0 ad=58.1134p pd=77.985u as=58.1134p ps=77.985u w=76.465u l=1u
X2112 DVDD GATE BAT DVDD pfet_06v0 ad=71.8771p pd=0.15481m as=58.1134p ps=77.985u w=76.465u l=1u
X2113 BAT GATE DVDD DVDD pfet_06v0 ad=35.511p pd=48.245u as=43.9215p ps=95.32999u w=46.725u l=1u
X2114 DVDD GATE BAT DVDD pfet_06v0 ad=58.1134p pd=77.985u as=58.1134p ps=77.985u w=76.465u l=1u
X2115 DVDD GATE BAT DVDD pfet_06v0 ad=43.9215p pd=95.32999u as=35.511p ps=48.245u w=46.725u l=1u
X2116 DVDD GATE BAT DVDD pfet_06v0 ad=58.1134p pd=77.985u as=58.1134p ps=77.985u w=76.465u l=1u
X2117 DVDD GATE BAT DVDD pfet_06v0 ad=35.511p pd=48.245u as=35.511p ps=48.245u w=46.725u l=1u
X2118 DVDD GATE BAT DVDD pfet_06v0 ad=58.1134p pd=77.985u as=58.1134p ps=77.985u w=76.465u l=1u
X2119 BAT GATE DVDD DVDD pfet_06v0 ad=58.1096p pd=77.98u as=58.1096p ps=77.98u w=76.46u l=1u
X2120 DVDD GATE BAT DVDD pfet_06v0 ad=43.9215p pd=95.32999u as=35.511p ps=48.245u w=46.725u l=1u
X2121 DVDD GATE BAT DVDD pfet_06v0 ad=58.1134p pd=77.985u as=58.1134p ps=77.985u w=76.465u l=1u
X2122 DVDD GATE BAT DVDD pfet_06v0 ad=58.1172p pd=77.99u as=58.1172p ps=77.99u w=76.47u l=1u
X2123 BAT GATE DVDD DVDD pfet_06v0 ad=35.511p pd=48.245u as=35.511p ps=48.245u w=46.725u l=1u
X2124 DVDD GATE BAT DVDD pfet_06v0 ad=43.9215p pd=95.32999u as=35.511p ps=48.245u w=46.725u l=1u
X2125 BAT GATE DVDD DVDD pfet_06v0 ad=58.1134p pd=77.985u as=71.8771p ps=0.15481m w=76.465u l=1u
X2126 DVDD GATE BAT DVDD pfet_06v0 ad=35.5072p pd=48.24u as=35.5072p ps=48.24u w=46.72u l=1u
X2127 DVDD GATE BAT DVDD pfet_06v0 ad=35.511p pd=48.245u as=35.511p ps=48.245u w=46.725u l=1u
X2128 BAT GATE DVDD DVDD pfet_06v0 ad=58.1552p pd=78.04u as=58.1552p ps=78.04u w=76.52u l=1u
X2129 DVDD GATE BAT DVDD pfet_06v0 ad=58.9803p pd=0.12737m as=47.6862p ps=64.265u w=62.745u l=1u
X2130 BAT GATE DVDD DVDD pfet_06v0 ad=58.1134p pd=77.985u as=58.1134p ps=77.985u w=76.465u l=1u
X2131 BAT GATE DVDD DVDD pfet_06v0 ad=35.511p pd=48.245u as=43.9215p ps=95.32999u w=46.725u l=1u
X2132 DVDD GATE BAT DVDD pfet_06v0 ad=35.511p pd=48.245u as=35.511p ps=48.245u w=46.725u l=1u
X2133 DVDD GATE BAT DVDD pfet_06v0 ad=58.1552p pd=78.04u as=58.1552p ps=78.04u w=76.52u l=1u
X2134 DVDD GATE BAT DVDD pfet_06v0 ad=35.511p pd=48.245u as=35.511p ps=48.245u w=46.725u l=1u
X2135 DVDD GATE BAT DVDD pfet_06v0 ad=58.1134p pd=77.985u as=58.1134p ps=77.985u w=76.465u l=1u
X2136 BAT GATE DVDD DVDD pfet_06v0 ad=58.1134p pd=77.985u as=58.1134p ps=77.985u w=76.465u l=1u
X2137 DVDD GATE BAT DVDD pfet_06v0 ad=35.511p pd=48.245u as=35.511p ps=48.245u w=46.725u l=1u
X2138 BAT GATE DVDD DVDD pfet_06v0 ad=58.1134p pd=77.985u as=58.1134p ps=77.985u w=76.465u l=1u
X2139 DVDD GATE BAT DVDD pfet_06v0 ad=71.8724p pd=0.1548m as=58.1096p ps=77.98u w=76.46u l=1u
X2140 BAT GATE DVDD DVDD pfet_06v0 ad=49.3848p pd=66.5u as=49.3848p ps=66.5u w=64.98u l=1u
X2141 DVDD GATE BAT DVDD pfet_06v0 ad=58.1134p pd=77.985u as=58.1134p ps=77.985u w=76.465u l=1u
X2142 DVDD GATE BAT DVDD pfet_06v0 ad=58.1134p pd=77.985u as=58.1134p ps=77.985u w=76.465u l=1u
X2143 BAT GATE DVDD DVDD pfet_06v0 ad=58.1134p pd=77.985u as=71.8771p ps=0.15481m w=76.465u l=1u
X2144 DVDD GATE BAT DVDD pfet_06v0 ad=43.9215p pd=95.32999u as=35.511p ps=48.245u w=46.725u l=1u
X2145 BAT GATE DVDD DVDD pfet_06v0 ad=58.1172p pd=77.99u as=58.1172p ps=77.99u w=76.47u l=1u
X2146 BAT GATE DVDD DVDD pfet_06v0 ad=35.511p pd=48.245u as=35.511p ps=48.245u w=46.725u l=1u
X2147 BAT GATE DVDD DVDD pfet_06v0 ad=58.1172p pd=77.99u as=58.1172p ps=77.99u w=76.47u l=1u
X2148 DVDD GATE BAT DVDD pfet_06v0 ad=71.8771p pd=0.15481m as=58.1134p ps=77.985u w=76.465u l=1u
X2149 DVDD GATE BAT DVDD pfet_06v0 ad=35.511p pd=48.245u as=35.511p ps=48.245u w=46.725u l=1u
X2150 DVDD GATE BAT DVDD pfet_06v0 ad=43.9168p pd=95.32u as=35.5072p ps=48.24u w=46.72u l=1u
X2151 DVDD GATE BAT DVDD pfet_06v0 ad=35.511p pd=48.245u as=35.511p ps=48.245u w=46.725u l=1u
X2152 DVDD GATE BAT DVDD pfet_06v0 ad=58.1134p pd=77.985u as=58.1134p ps=77.985u w=76.465u l=1u
X2153 BAT GATE DVDD DVDD pfet_06v0 ad=58.1134p pd=77.985u as=58.1134p ps=77.985u w=76.465u l=1u
X2154 DVDD GATE BAT DVDD pfet_06v0 ad=58.1134p pd=77.985u as=58.1134p ps=77.985u w=76.465u l=1u
X2155 DVDD GATE BAT DVDD pfet_06v0 ad=35.5072p pd=48.24u as=35.5072p ps=48.24u w=46.72u l=1u
X2156 BAT GATE DVDD DVDD pfet_06v0 ad=58.1134p pd=77.985u as=58.1134p ps=77.985u w=76.465u l=1u
X2157 BAT GATE DVDD DVDD pfet_06v0 ad=58.1096p pd=77.98u as=58.1096p ps=77.98u w=76.46u l=1u
X2158 BAT GATE DVDD DVDD pfet_06v0 ad=58.1134p pd=77.985u as=58.1134p ps=77.985u w=76.465u l=1u
X2159 BAT GATE DVDD DVDD pfet_06v0 ad=35.511p pd=48.245u as=35.511p ps=48.245u w=46.725u l=1u
X2160 BAT GATE DVDD DVDD pfet_06v0 ad=58.1134p pd=77.985u as=58.1134p ps=77.985u w=76.465u l=1u
X2161 DVDD GATE BAT DVDD pfet_06v0 ad=58.1172p pd=77.99u as=58.1172p ps=77.99u w=76.47u l=1u
X2162 DVDD GATE BAT DVDD pfet_06v0 ad=35.511p pd=48.245u as=35.511p ps=48.245u w=46.725u l=1u
X2163 BAT GATE DVDD DVDD pfet_06v0 ad=49.3848p pd=66.5u as=61.0812p ps=0.13184m w=64.98u l=1u
X2164 BAT GATE DVDD DVDD pfet_06v0 ad=35.511p pd=48.245u as=43.9215p ps=95.32999u w=46.725u l=1u
X2165 DVDD GATE BAT DVDD pfet_06v0 ad=35.511p pd=48.245u as=35.511p ps=48.245u w=46.725u l=1u
X2166 BAT GATE DVDD DVDD pfet_06v0 ad=58.1552p pd=78.04u as=58.1552p ps=78.04u w=76.52u l=1u
X2167 DVDD GATE BAT DVDD pfet_06v0 ad=47.6862p pd=64.265u as=47.6862p ps=64.265u w=62.745u l=1u
X2168 DVDD GATE BAT DVDD pfet_06v0 ad=58.1134p pd=77.985u as=58.1134p ps=77.985u w=76.465u l=1u
X2169 DVDD GATE BAT DVDD pfet_06v0 ad=58.1134p pd=77.985u as=58.1134p ps=77.985u w=76.465u l=1u
X2170 BAT GATE DVDD DVDD pfet_06v0 ad=58.0754p pd=77.935u as=58.0754p ps=77.935u w=76.41499u l=1u
X2171 DVDD GATE BAT DVDD pfet_06v0 ad=58.1134p pd=77.985u as=58.1134p ps=77.985u w=76.465u l=1u
X2172 DVDD GATE BAT DVDD pfet_06v0 ad=58.1134p pd=77.985u as=58.1134p ps=77.985u w=76.465u l=1u
X2173 DVDD GATE BAT DVDD pfet_06v0 ad=43.9215p pd=95.32999u as=35.511p ps=48.245u w=46.725u l=1u
X2174 DVDD GATE BAT DVDD pfet_06v0 ad=58.1096p pd=77.98u as=58.1096p ps=77.98u w=76.46u l=1u
X2175 DVDD GATE BAT DVDD pfet_06v0 ad=47.6862p pd=64.265u as=47.6862p ps=64.265u w=62.745u l=1u
X2176 BAT GATE DVDD DVDD pfet_06v0 ad=58.0754p pd=77.935u as=58.0754p ps=77.935u w=76.41499u l=1u
X2177 BAT GATE DVDD DVDD pfet_06v0 ad=35.511p pd=48.245u as=35.511p ps=48.245u w=46.725u l=1u
X2178 DVDD GATE BAT DVDD pfet_06v0 ad=43.9215p pd=95.32999u as=35.511p ps=48.245u w=46.725u l=1u
X2179 DVDD GATE BAT DVDD pfet_06v0 ad=71.8771p pd=0.15481m as=58.1134p ps=77.985u w=76.465u l=1u
X2180 DVDD GATE BAT DVDD pfet_06v0 ad=35.511p pd=48.245u as=35.511p ps=48.245u w=46.725u l=1u
X2181 BAT GATE DVDD DVDD pfet_06v0 ad=58.1134p pd=77.985u as=71.8771p ps=0.15481m w=76.465u l=1u
X2182 BAT GATE DVDD DVDD pfet_06v0 ad=58.1134p pd=77.985u as=58.1134p ps=77.985u w=76.465u l=1u
X2183 DVDD GATE BAT DVDD pfet_06v0 ad=35.5072p pd=48.24u as=35.5072p ps=48.24u w=46.72u l=1u
X2184 BAT GATE DVDD DVDD pfet_06v0 ad=35.511p pd=48.245u as=35.511p ps=48.245u w=46.725u l=1u
X2185 DVDD GATE BAT DVDD pfet_06v0 ad=58.1134p pd=77.985u as=58.1134p ps=77.985u w=76.465u l=1u
X2186 DVDD GATE BAT DVDD pfet_06v0 ad=35.511p pd=48.245u as=35.511p ps=48.245u w=46.725u l=1u
X2187 BAT GATE DVDD DVDD pfet_06v0 ad=58.1172p pd=77.99u as=58.1172p ps=77.99u w=76.47u l=1u
X2188 BAT GATE DVDD DVDD pfet_06v0 ad=58.1172p pd=77.99u as=58.1172p ps=77.99u w=76.47u l=1u
X2189 BAT GATE DVDD DVDD pfet_06v0 ad=58.1134p pd=77.985u as=58.1134p ps=77.985u w=76.465u l=1u
X2190 DVDD GATE BAT DVDD pfet_06v0 ad=49.3848p pd=66.5u as=49.3848p ps=66.5u w=64.98u l=1u
X2191 BAT GATE DVDD DVDD pfet_06v0 ad=35.511p pd=48.245u as=35.511p ps=48.245u w=46.725u l=1u
X2192 BAT GATE DVDD DVDD pfet_06v0 ad=58.1134p pd=77.985u as=58.1134p ps=77.985u w=76.465u l=1u
X2193 BAT GATE DVDD DVDD pfet_06v0 ad=58.1134p pd=77.985u as=58.1134p ps=77.985u w=76.465u l=1u
X2194 BAT GATE DVDD DVDD pfet_06v0 ad=35.511p pd=48.245u as=35.511p ps=48.245u w=46.725u l=1u
X2195 DVDD GATE BAT DVDD pfet_06v0 ad=58.1096p pd=77.98u as=58.1096p ps=77.98u w=76.46u l=1u
X2196 DVDD GATE BAT DVDD pfet_06v0 ad=58.0754p pd=77.935u as=58.0754p ps=77.935u w=76.41499u l=1u
X2197 BAT GATE DVDD DVDD pfet_06v0 ad=58.1096p pd=77.98u as=58.1096p ps=77.98u w=76.46u l=1u
X2198 DVDD GATE BAT DVDD pfet_06v0 ad=35.511p pd=48.245u as=35.511p ps=48.245u w=46.725u l=1u
X2199 DVDD GATE BAT DVDD pfet_06v0 ad=58.1172p pd=77.99u as=58.1172p ps=77.99u w=76.47u l=1u
X2200 BAT GATE DVDD DVDD pfet_06v0 ad=35.511p pd=48.245u as=35.511p ps=48.245u w=46.725u l=1u
X2201 DVDD GATE BAT DVDD pfet_06v0 ad=35.511p pd=48.245u as=35.511p ps=48.245u w=46.725u l=1u
X2202 DVDD GATE BAT DVDD pfet_06v0 ad=58.1552p pd=78.04u as=58.1552p ps=78.04u w=76.52u l=1u
X2203 BAT GATE DVDD DVDD pfet_06v0 ad=58.1134p pd=77.985u as=71.8771p ps=0.15481m w=76.465u l=1u
X2204 BAT GATE DVDD DVDD pfet_06v0 ad=35.511p pd=48.245u as=35.511p ps=48.245u w=46.725u l=1u
X2205 DVDD GATE BAT DVDD pfet_06v0 ad=58.1134p pd=77.985u as=58.1134p ps=77.985u w=76.465u l=1u
X2206 BAT GATE DVDD DVDD pfet_06v0 ad=35.511p pd=48.245u as=43.9215p ps=95.32999u w=46.725u l=1u
X2207 DVDD GATE BAT DVDD pfet_06v0 ad=35.511p pd=48.245u as=35.511p ps=48.245u w=46.725u l=1u
X2208 BAT GATE DVDD DVDD pfet_06v0 ad=58.1134p pd=77.985u as=58.1134p ps=77.985u w=76.465u l=1u
X2209 BAT GATE DVDD DVDD pfet_06v0 ad=47.6862p pd=64.265u as=47.6862p ps=64.265u w=62.745u l=1u
X2210 BAT GATE DVDD DVDD pfet_06v0 ad=58.1134p pd=77.985u as=58.1134p ps=77.985u w=76.465u l=1u
X2211 BAT GATE DVDD DVDD pfet_06v0 ad=58.1552p pd=78.04u as=58.1552p ps=78.04u w=76.52u l=1u
X2212 BAT GATE DVDD DVDD pfet_06v0 ad=35.511p pd=48.245u as=35.511p ps=48.245u w=46.725u l=1u
X2213 DVDD GATE BAT DVDD pfet_06v0 ad=35.511p pd=48.245u as=35.511p ps=48.245u w=46.725u l=1u
X2214 DVDD GATE BAT DVDD pfet_06v0 ad=71.8771p pd=0.15481m as=58.1134p ps=77.985u w=76.465u l=1u
X2215 DVDD GATE BAT DVDD pfet_06v0 ad=35.511p pd=48.245u as=35.511p ps=48.245u w=46.725u l=1u
X2216 BAT GATE DVDD DVDD pfet_06v0 ad=35.5072p pd=48.24u as=35.5072p ps=48.24u w=46.72u l=1u
X2217 BAT GATE DVDD DVDD pfet_06v0 ad=35.511p pd=48.245u as=35.511p ps=48.245u w=46.725u l=1u
X2218 BAT GATE DVDD DVDD pfet_06v0 ad=35.5072p pd=48.24u as=35.5072p ps=48.24u w=46.72u l=1u
X2219 DVDD GATE BAT DVDD pfet_06v0 ad=35.511p pd=48.245u as=35.511p ps=48.245u w=46.725u l=1u
X2220 BAT GATE DVDD DVDD pfet_06v0 ad=58.1134p pd=77.985u as=58.1134p ps=77.985u w=76.465u l=1u
X2221 DVDD GATE BAT DVDD pfet_06v0 ad=35.511p pd=48.245u as=35.511p ps=48.245u w=46.725u l=1u
X2222 DVDD GATE BAT DVDD pfet_06v0 ad=35.511p pd=48.245u as=35.511p ps=48.245u w=46.725u l=1u
X2223 DVDD GATE BAT DVDD pfet_06v0 ad=71.8724p pd=0.1548m as=58.1096p ps=77.98u w=76.46u l=1u
X2224 DVDD GATE BAT DVDD pfet_06v0 ad=43.9215p pd=95.32999u as=35.511p ps=48.245u w=46.725u l=1u
X2225 BAT GATE DVDD DVDD pfet_06v0 ad=58.1134p pd=77.985u as=58.1134p ps=77.985u w=76.465u l=1u
X2226 BAT GATE DVDD DVDD pfet_06v0 ad=58.1096p pd=77.98u as=58.1096p ps=77.98u w=76.46u l=1u
X2227 DVDD GATE BAT DVDD pfet_06v0 ad=35.511p pd=48.245u as=35.511p ps=48.245u w=46.725u l=1u
X2228 BAT GATE DVDD DVDD pfet_06v0 ad=58.1134p pd=77.985u as=71.8771p ps=0.15481m w=76.465u l=1u
X2229 DVDD GATE BAT DVDD pfet_06v0 ad=71.8771p pd=0.15481m as=58.1134p ps=77.985u w=76.465u l=1u
X2230 DVDD GATE BAT DVDD pfet_06v0 ad=35.511p pd=48.245u as=35.511p ps=48.245u w=46.725u l=1u
X2231 DVDD GATE BAT DVDD pfet_06v0 ad=58.1552p pd=78.04u as=58.1552p ps=78.04u w=76.52u l=1u
X2232 BAT GATE DVDD DVDD pfet_06v0 ad=35.511p pd=48.245u as=35.511p ps=48.245u w=46.725u l=1u
X2233 BAT GATE DVDD DVDD pfet_06v0 ad=35.511p pd=48.245u as=35.511p ps=48.245u w=46.725u l=1u
X2234 BAT GATE DVDD DVDD pfet_06v0 ad=58.1134p pd=77.985u as=58.1134p ps=77.985u w=76.465u l=1u
X2235 BAT GATE DVDD DVDD pfet_06v0 ad=58.1552p pd=78.04u as=71.92879p ps=0.15492m w=76.52u l=1u
X2236 DVDD GATE BAT DVDD pfet_06v0 ad=35.511p pd=48.245u as=35.511p ps=48.245u w=46.725u l=1u
X2237 DVDD GATE BAT DVDD pfet_06v0 ad=43.9215p pd=95.32999u as=35.511p ps=48.245u w=46.725u l=1u
X2238 BAT GATE DVDD DVDD pfet_06v0 ad=35.511p pd=48.245u as=43.9215p ps=95.32999u w=46.725u l=1u
X2239 BAT GATE DVDD DVDD pfet_06v0 ad=35.511p pd=48.245u as=35.511p ps=48.245u w=46.725u l=1u
X2240 DVDD GATE BAT DVDD pfet_06v0 ad=71.8771p pd=0.15481m as=58.1134p ps=77.985u w=76.465u l=1u
X2241 BAT GATE DVDD DVDD pfet_06v0 ad=35.511p pd=48.245u as=35.511p ps=48.245u w=46.725u l=1u
X2242 BAT GATE DVDD DVDD pfet_06v0 ad=35.511p pd=48.245u as=35.511p ps=48.245u w=46.725u l=1u
X2243 BAT GATE DVDD DVDD pfet_06v0 ad=35.511p pd=48.245u as=35.511p ps=48.245u w=46.725u l=1u
X2244 DVDD GATE BAT DVDD pfet_06v0 ad=58.9803p pd=0.12737m as=47.6862p ps=64.265u w=62.745u l=1u
X2245 BAT GATE DVDD DVDD pfet_06v0 ad=58.1134p pd=77.985u as=58.1134p ps=77.985u w=76.465u l=1u
X2246 DVDD GATE BAT DVDD pfet_06v0 ad=43.9215p pd=95.32999u as=35.511p ps=48.245u w=46.725u l=1u
X2247 DVDD GATE BAT DVDD pfet_06v0 ad=47.6862p pd=64.265u as=47.6862p ps=64.265u w=62.745u l=1u
X2248 DVDD GATE BAT DVDD pfet_06v0 ad=35.511p pd=48.245u as=35.511p ps=48.245u w=46.725u l=1u
X2249 DVDD GATE BAT DVDD pfet_06v0 ad=58.1134p pd=77.985u as=58.1134p ps=77.985u w=76.465u l=1u
X2250 DVDD GATE BAT DVDD pfet_06v0 ad=58.1552p pd=78.04u as=58.1552p ps=78.04u w=76.52u l=1u
X2251 BAT GATE DVDD DVDD pfet_06v0 ad=35.511p pd=48.245u as=35.511p ps=48.245u w=46.725u l=1u
X2252 BAT GATE DVDD DVDD pfet_06v0 ad=58.1134p pd=77.985u as=71.8771p ps=0.15481m w=76.465u l=1u
X2253 DVDD GATE BAT DVDD pfet_06v0 ad=35.511p pd=48.245u as=35.511p ps=48.245u w=46.725u l=1u
X2254 DVDD GATE BAT DVDD pfet_06v0 ad=35.511p pd=48.245u as=35.511p ps=48.245u w=46.725u l=1u
X2255 DVDD GATE BAT DVDD pfet_06v0 ad=58.1134p pd=77.985u as=58.1134p ps=77.985u w=76.465u l=1u
X2256 DVDD GATE BAT DVDD pfet_06v0 ad=58.1134p pd=77.985u as=58.1134p ps=77.985u w=76.465u l=1u
X2257 BAT GATE DVDD DVDD pfet_06v0 ad=58.1134p pd=77.985u as=58.1134p ps=77.985u w=76.465u l=1u
X2258 BAT GATE DVDD DVDD pfet_06v0 ad=35.5072p pd=48.24u as=35.5072p ps=48.24u w=46.72u l=1u
X2259 BAT GATE DVDD DVDD pfet_06v0 ad=35.5072p pd=48.24u as=35.5072p ps=48.24u w=46.72u l=1u
X2260 BAT GATE DVDD DVDD pfet_06v0 ad=49.3848p pd=66.5u as=49.3848p ps=66.5u w=64.98u l=1u
X2261 BAT GATE DVDD DVDD pfet_06v0 ad=35.511p pd=48.245u as=43.9215p ps=95.32999u w=46.725u l=1u
X2262 DVDD GATE BAT DVDD pfet_06v0 ad=58.1134p pd=77.985u as=58.1134p ps=77.985u w=76.465u l=1u
X2263 BAT GATE DVDD DVDD pfet_06v0 ad=58.1134p pd=77.985u as=58.1134p ps=77.985u w=76.465u l=1u
X2264 DVDD GATE BAT DVDD pfet_06v0 ad=35.511p pd=48.245u as=35.511p ps=48.245u w=46.725u l=1u
X2265 BAT GATE DVDD DVDD pfet_06v0 ad=58.1134p pd=77.985u as=58.1134p ps=77.985u w=76.465u l=1u
X2266 BAT GATE DVDD DVDD pfet_06v0 ad=35.511p pd=48.245u as=35.511p ps=48.245u w=46.725u l=1u
X2267 BAT GATE DVDD DVDD pfet_06v0 ad=58.1134p pd=77.985u as=71.8771p ps=0.15481m w=76.465u l=1u
X2268 BAT GATE DVDD DVDD pfet_06v0 ad=35.511p pd=48.245u as=35.511p ps=48.245u w=46.725u l=1u
X2269 BAT GATE DVDD DVDD pfet_06v0 ad=35.511p pd=48.245u as=35.511p ps=48.245u w=46.725u l=1u
X2270 BAT GATE DVDD DVDD pfet_06v0 ad=47.6862p pd=64.265u as=47.6862p ps=64.265u w=62.745u l=1u
X2271 BAT GATE DVDD DVDD pfet_06v0 ad=58.1134p pd=77.985u as=58.1134p ps=77.985u w=76.465u l=1u
X2272 BAT GATE DVDD DVDD pfet_06v0 ad=58.1134p pd=77.985u as=58.1134p ps=77.985u w=76.465u l=1u
X2273 BAT GATE DVDD DVDD pfet_06v0 ad=35.511p pd=48.245u as=35.511p ps=48.245u w=46.725u l=1u
X2274 BAT GATE DVDD DVDD pfet_06v0 ad=35.511p pd=48.245u as=35.511p ps=48.245u w=46.725u l=1u
X2275 DVDD GATE BAT DVDD pfet_06v0 ad=58.1134p pd=77.985u as=58.1134p ps=77.985u w=76.465u l=1u
X2276 BAT GATE DVDD DVDD pfet_06v0 ad=58.1134p pd=77.985u as=58.1134p ps=77.985u w=76.465u l=1u
X2277 DVDD GATE BAT DVDD pfet_06v0 ad=35.511p pd=48.245u as=35.511p ps=48.245u w=46.725u l=1u
X2278 DVDD GATE BAT DVDD pfet_06v0 ad=58.0754p pd=77.935u as=58.0754p ps=77.935u w=76.41499u l=1u
X2279 DVDD GATE BAT DVDD pfet_06v0 ad=35.511p pd=48.245u as=35.511p ps=48.245u w=46.725u l=1u
X2280 BAT GATE DVDD DVDD pfet_06v0 ad=58.1096p pd=77.98u as=71.8724p ps=0.1548m w=76.46u l=1u
X2281 DVDD GATE BAT DVDD pfet_06v0 ad=47.6862p pd=64.265u as=47.6862p ps=64.265u w=62.745u l=1u
X2282 BAT GATE DVDD DVDD pfet_06v0 ad=58.1172p pd=77.99u as=58.1172p ps=77.99u w=76.47u l=1u
X2283 DVDD GATE BAT DVDD pfet_06v0 ad=58.1552p pd=78.04u as=58.1552p ps=78.04u w=76.52u l=1u
X2284 BAT GATE DVDD DVDD pfet_06v0 ad=35.511p pd=48.245u as=35.511p ps=48.245u w=46.725u l=1u
X2285 DVDD GATE BAT DVDD pfet_06v0 ad=71.8818p pd=0.15482m as=58.1172p ps=77.99u w=76.47u l=1u
X2286 BAT GATE DVDD DVDD pfet_06v0 ad=35.5072p pd=48.24u as=35.5072p ps=48.24u w=46.72u l=1u
X2287 DVDD GATE BAT DVDD pfet_06v0 ad=58.1134p pd=77.985u as=58.1134p ps=77.985u w=76.465u l=1u
X2288 BAT GATE DVDD DVDD pfet_06v0 ad=58.1552p pd=78.04u as=58.1552p ps=78.04u w=76.52u l=1u
X2289 DVDD GATE BAT DVDD pfet_06v0 ad=58.1134p pd=77.985u as=58.1134p ps=77.985u w=76.465u l=1u
X2290 BAT GATE DVDD DVDD pfet_06v0 ad=35.511p pd=48.245u as=43.9215p ps=95.32999u w=46.725u l=1u
X2291 BAT GATE DVDD DVDD pfet_06v0 ad=35.511p pd=48.245u as=35.511p ps=48.245u w=46.725u l=1u
X2292 BAT GATE DVDD DVDD pfet_06v0 ad=35.511p pd=48.245u as=35.511p ps=48.245u w=46.725u l=1u
X2293 DVDD GATE BAT DVDD pfet_06v0 ad=58.1134p pd=77.985u as=58.1134p ps=77.985u w=76.465u l=1u
X2294 DVDD GATE BAT DVDD pfet_06v0 ad=58.1134p pd=77.985u as=58.1134p ps=77.985u w=76.465u l=1u
X2295 BAT GATE DVDD DVDD pfet_06v0 ad=58.1134p pd=77.985u as=58.1134p ps=77.985u w=76.465u l=1u
X2296 DVDD GATE BAT DVDD pfet_06v0 ad=43.9215p pd=95.32999u as=35.511p ps=48.245u w=46.725u l=1u
X2297 DVDD GATE BAT DVDD pfet_06v0 ad=58.1134p pd=77.985u as=58.1134p ps=77.985u w=76.465u l=1u
X2298 DVDD GATE BAT DVDD pfet_06v0 ad=58.1134p pd=77.985u as=58.1134p ps=77.985u w=76.465u l=1u
X2299 DVDD GATE BAT DVDD pfet_06v0 ad=35.511p pd=48.245u as=35.511p ps=48.245u w=46.725u l=1u
X2300 BAT GATE DVDD DVDD pfet_06v0 ad=35.511p pd=48.245u as=35.511p ps=48.245u w=46.725u l=1u
X2301 DVDD GATE BAT DVDD pfet_06v0 ad=35.511p pd=48.245u as=35.511p ps=48.245u w=46.725u l=1u
X2302 DVDD GATE BAT DVDD pfet_06v0 ad=35.511p pd=48.245u as=35.511p ps=48.245u w=46.725u l=1u
X2303 DVDD GATE BAT DVDD pfet_06v0 ad=35.511p pd=48.245u as=35.511p ps=48.245u w=46.725u l=1u
X2304 BAT GATE DVDD DVDD pfet_06v0 ad=47.6862p pd=64.265u as=58.9803p ps=0.12737m w=62.745u l=1u
X2305 BAT GATE DVDD DVDD pfet_06v0 ad=35.511p pd=48.245u as=43.9215p ps=95.32999u w=46.725u l=1u
X2306 DVDD GATE BAT DVDD pfet_06v0 ad=43.9215p pd=95.32999u as=35.511p ps=48.245u w=46.725u l=1u
X2307 BAT GATE DVDD DVDD pfet_06v0 ad=35.511p pd=48.245u as=35.511p ps=48.245u w=46.725u l=1u
X2308 DVDD GATE BAT DVDD pfet_06v0 ad=43.9215p pd=95.32999u as=35.511p ps=48.245u w=46.725u l=1u
X2309 DVDD GATE BAT DVDD pfet_06v0 ad=35.511p pd=48.245u as=35.511p ps=48.245u w=46.725u l=1u
X2310 BAT GATE DVDD DVDD pfet_06v0 ad=35.511p pd=48.245u as=35.511p ps=48.245u w=46.725u l=1u
X2311 BAT GATE DVDD DVDD pfet_06v0 ad=35.511p pd=48.245u as=35.511p ps=48.245u w=46.725u l=1u
X2312 DVDD GATE BAT DVDD pfet_06v0 ad=35.511p pd=48.245u as=35.511p ps=48.245u w=46.725u l=1u
X2313 DVDD GATE BAT DVDD pfet_06v0 ad=35.511p pd=48.245u as=35.511p ps=48.245u w=46.725u l=1u
X2314 DVDD GATE BAT DVDD pfet_06v0 ad=58.1134p pd=77.985u as=58.1134p ps=77.985u w=76.465u l=1u
X2315 BAT GATE DVDD DVDD pfet_06v0 ad=35.511p pd=48.245u as=35.511p ps=48.245u w=46.725u l=1u
X2316 DVDD GATE BAT DVDD pfet_06v0 ad=58.1096p pd=77.98u as=58.1096p ps=77.98u w=76.46u l=1u
X2317 DVDD GATE BAT DVDD pfet_06v0 ad=58.0754p pd=77.935u as=58.0754p ps=77.935u w=76.41499u l=1u
X2318 BAT GATE DVDD DVDD pfet_06v0 ad=58.1172p pd=77.99u as=58.1172p ps=77.99u w=76.47u l=1u
X2319 DVDD GATE BAT DVDD pfet_06v0 ad=35.5072p pd=48.24u as=35.5072p ps=48.24u w=46.72u l=1u
X2320 DVDD GATE BAT DVDD pfet_06v0 ad=35.511p pd=48.245u as=35.511p ps=48.245u w=46.725u l=1u
X2321 BAT GATE DVDD DVDD pfet_06v0 ad=35.511p pd=48.245u as=35.511p ps=48.245u w=46.725u l=1u
X2322 DVDD GATE BAT DVDD pfet_06v0 ad=58.1134p pd=77.985u as=58.1134p ps=77.985u w=76.465u l=1u
X2323 BAT GATE DVDD DVDD pfet_06v0 ad=58.0754p pd=77.935u as=71.8301p ps=0.15471m w=76.41499u l=1u
X2324 BAT GATE DVDD DVDD pfet_06v0 ad=35.511p pd=48.245u as=35.511p ps=48.245u w=46.725u l=1u
X2325 DVDD GATE BAT DVDD pfet_06v0 ad=58.1134p pd=77.985u as=58.1134p ps=77.985u w=76.465u l=1u
X2326 DVDD GATE BAT DVDD pfet_06v0 ad=35.511p pd=48.245u as=35.511p ps=48.245u w=46.725u l=1u
X2327 DVDD GATE BAT DVDD pfet_06v0 ad=58.1134p pd=77.985u as=58.1134p ps=77.985u w=76.465u l=1u
X2328 DVDD GATE BAT DVDD pfet_06v0 ad=35.511p pd=48.245u as=35.511p ps=48.245u w=46.725u l=1u
X2329 BAT GATE DVDD DVDD pfet_06v0 ad=35.511p pd=48.245u as=35.511p ps=48.245u w=46.725u l=1u
X2330 DVDD GATE BAT DVDD pfet_06v0 ad=58.1134p pd=77.985u as=58.1134p ps=77.985u w=76.465u l=1u
X2331 BAT GATE DVDD DVDD pfet_06v0 ad=35.511p pd=48.245u as=35.511p ps=48.245u w=46.725u l=1u
X2332 DVDD GATE BAT DVDD pfet_06v0 ad=71.8771p pd=0.15481m as=58.1134p ps=77.985u w=76.465u l=1u
X2333 BAT GATE DVDD DVDD pfet_06v0 ad=58.1172p pd=77.99u as=58.1172p ps=77.99u w=76.47u l=1u
X2334 BAT GATE DVDD DVDD pfet_06v0 ad=58.1134p pd=77.985u as=58.1134p ps=77.985u w=76.465u l=1u
X2335 DVDD GATE BAT DVDD pfet_06v0 ad=58.1134p pd=77.985u as=58.1134p ps=77.985u w=76.465u l=1u
X2336 DVDD GATE BAT DVDD pfet_06v0 ad=58.1134p pd=77.985u as=58.1134p ps=77.985u w=76.465u l=1u
X2337 DVDD GATE BAT DVDD pfet_06v0 ad=35.511p pd=48.245u as=35.511p ps=48.245u w=46.725u l=1u
X2338 BAT GATE DVDD DVDD pfet_06v0 ad=35.511p pd=48.245u as=35.511p ps=48.245u w=46.725u l=1u
X2339 DVDD GATE BAT DVDD pfet_06v0 ad=35.511p pd=48.245u as=35.511p ps=48.245u w=46.725u l=1u
X2340 DVDD GATE BAT DVDD pfet_06v0 ad=58.1134p pd=77.985u as=58.1134p ps=77.985u w=76.465u l=1u
X2341 DVDD GATE BAT DVDD pfet_06v0 ad=49.3848p pd=66.5u as=49.3848p ps=66.5u w=64.98u l=1u
X2342 DVDD GATE BAT DVDD pfet_06v0 ad=58.1096p pd=77.98u as=58.1096p ps=77.98u w=76.46u l=1u
X2343 DVDD GATE BAT DVDD pfet_06v0 ad=35.511p pd=48.245u as=35.511p ps=48.245u w=46.725u l=1u
X2344 BAT GATE DVDD DVDD pfet_06v0 ad=35.511p pd=48.245u as=35.511p ps=48.245u w=46.725u l=1u
X2345 DVDD GATE BAT DVDD pfet_06v0 ad=35.511p pd=48.245u as=35.511p ps=48.245u w=46.725u l=1u
X2346 DVDD GATE BAT DVDD pfet_06v0 ad=58.1134p pd=77.985u as=58.1134p ps=77.985u w=76.465u l=1u
X2347 BAT GATE DVDD DVDD pfet_06v0 ad=47.6862p pd=64.265u as=47.6862p ps=64.265u w=62.745u l=1u
X2348 BAT GATE DVDD DVDD pfet_06v0 ad=58.1552p pd=78.04u as=71.92879p ps=0.15492m w=76.52u l=1u
X2349 BAT GATE DVDD DVDD pfet_06v0 ad=35.511p pd=48.245u as=35.511p ps=48.245u w=46.725u l=1u
X2350 DVDD GATE BAT DVDD pfet_06v0 ad=35.5072p pd=48.24u as=35.5072p ps=48.24u w=46.72u l=1u
X2351 BAT GATE DVDD DVDD pfet_06v0 ad=58.1134p pd=77.985u as=58.1134p ps=77.985u w=76.465u l=1u
X2352 DVDD GATE BAT DVDD pfet_06v0 ad=58.1134p pd=77.985u as=58.1134p ps=77.985u w=76.465u l=1u
X2353 BAT GATE DVDD DVDD pfet_06v0 ad=35.511p pd=48.245u as=35.511p ps=48.245u w=46.725u l=1u
X2354 DVDD GATE BAT DVDD pfet_06v0 ad=71.92879p pd=0.15492m as=58.1552p ps=78.04u w=76.52u l=1u
X2355 BAT GATE DVDD DVDD pfet_06v0 ad=58.1134p pd=77.985u as=71.8771p ps=0.15481m w=76.465u l=1u
X2356 BAT GATE DVDD DVDD pfet_06v0 ad=58.1134p pd=77.985u as=58.1134p ps=77.985u w=76.465u l=1u
X2357 BAT GATE DVDD DVDD pfet_06v0 ad=58.1134p pd=77.985u as=58.1134p ps=77.985u w=76.465u l=1u
X2358 BAT GATE DVDD DVDD pfet_06v0 ad=58.1552p pd=78.04u as=58.1552p ps=78.04u w=76.52u l=1u
X2359 DVDD GATE BAT DVDD pfet_06v0 ad=35.511p pd=48.245u as=35.511p ps=48.245u w=46.725u l=1u
X2360 DVDD GATE BAT DVDD pfet_06v0 ad=35.511p pd=48.245u as=35.511p ps=48.245u w=46.725u l=1u
X2361 DVDD GATE BAT DVDD pfet_06v0 ad=58.0754p pd=77.935u as=58.0754p ps=77.935u w=76.41499u l=1u
X2362 BAT GATE DVDD DVDD pfet_06v0 ad=58.1134p pd=77.985u as=58.1134p ps=77.985u w=76.465u l=1u
X2363 BAT GATE DVDD DVDD pfet_06v0 ad=35.511p pd=48.245u as=35.511p ps=48.245u w=46.725u l=1u
X2364 DVDD GATE BAT DVDD pfet_06v0 ad=58.1134p pd=77.985u as=58.1134p ps=77.985u w=76.465u l=1u
X2365 DVDD GATE BAT DVDD pfet_06v0 ad=35.511p pd=48.245u as=35.511p ps=48.245u w=46.725u l=1u
X2366 DVDD GATE BAT DVDD pfet_06v0 ad=58.1134p pd=77.985u as=58.1134p ps=77.985u w=76.465u l=1u
X2367 DVDD GATE BAT DVDD pfet_06v0 ad=58.1134p pd=77.985u as=58.1134p ps=77.985u w=76.465u l=1u
X2368 BAT GATE DVDD DVDD pfet_06v0 ad=35.511p pd=48.245u as=35.511p ps=48.245u w=46.725u l=1u
X2369 DVDD GATE BAT DVDD pfet_06v0 ad=58.1134p pd=77.985u as=58.1134p ps=77.985u w=76.465u l=1u
X2370 BAT GATE DVDD DVDD pfet_06v0 ad=58.1134p pd=77.985u as=58.1134p ps=77.985u w=76.465u l=1u
X2371 DVDD GATE BAT DVDD pfet_06v0 ad=58.1172p pd=77.99u as=58.1172p ps=77.99u w=76.47u l=1u
X2372 DVDD GATE BAT DVDD pfet_06v0 ad=35.511p pd=48.245u as=35.511p ps=48.245u w=46.725u l=1u
X2373 DVDD GATE BAT DVDD pfet_06v0 ad=58.1096p pd=77.98u as=58.1096p ps=77.98u w=76.46u l=1u
X2374 DVDD GATE BAT DVDD pfet_06v0 ad=58.1134p pd=77.985u as=58.1134p ps=77.985u w=76.465u l=1u
X2375 BAT GATE DVDD DVDD pfet_06v0 ad=35.511p pd=48.245u as=35.511p ps=48.245u w=46.725u l=1u
X2376 BAT GATE DVDD DVDD pfet_06v0 ad=35.511p pd=48.245u as=43.9215p ps=95.32999u w=46.725u l=1u
X2377 DVDD GATE BAT DVDD pfet_06v0 ad=58.1134p pd=77.985u as=58.1134p ps=77.985u w=76.465u l=1u
X2378 BAT GATE DVDD DVDD pfet_06v0 ad=58.0754p pd=77.935u as=58.0754p ps=77.935u w=76.41499u l=1u
X2379 DVDD GATE BAT DVDD pfet_06v0 ad=35.511p pd=48.245u as=35.511p ps=48.245u w=46.725u l=1u
X2380 BAT GATE DVDD DVDD pfet_06v0 ad=47.6862p pd=64.265u as=47.6862p ps=64.265u w=62.745u l=1u
X2381 DVDD GATE BAT DVDD pfet_06v0 ad=49.3848p pd=66.5u as=49.3848p ps=66.5u w=64.98u l=1u
X2382 BAT GATE DVDD DVDD pfet_06v0 ad=58.1134p pd=77.985u as=71.8771p ps=0.15481m w=76.465u l=1u
X2383 BAT GATE DVDD DVDD pfet_06v0 ad=58.1134p pd=77.985u as=71.8771p ps=0.15481m w=76.465u l=1u
X2384 DVDD GATE BAT DVDD pfet_06v0 ad=58.0754p pd=77.935u as=58.0754p ps=77.935u w=76.41499u l=1u
X2385 BAT GATE DVDD DVDD pfet_06v0 ad=35.511p pd=48.245u as=43.9215p ps=95.32999u w=46.725u l=1u
X2386 DVDD GATE BAT DVDD pfet_06v0 ad=58.1134p pd=77.985u as=58.1134p ps=77.985u w=76.465u l=1u
X2387 DVDD GATE BAT DVDD pfet_06v0 ad=58.1134p pd=77.985u as=58.1134p ps=77.985u w=76.465u l=1u
X2388 BAT GATE DVDD DVDD pfet_06v0 ad=35.511p pd=48.245u as=35.511p ps=48.245u w=46.725u l=1u
X2389 BAT GATE DVDD DVDD pfet_06v0 ad=47.6862p pd=64.265u as=47.6862p ps=64.265u w=62.745u l=1u
X2390 DVDD GATE BAT DVDD pfet_06v0 ad=43.9168p pd=95.32u as=35.5072p ps=48.24u w=46.72u l=1u
X2391 DVDD GATE BAT DVDD pfet_06v0 ad=47.6862p pd=64.265u as=47.6862p ps=64.265u w=62.745u l=1u
X2392 DVDD GATE BAT DVDD pfet_06v0 ad=35.511p pd=48.245u as=35.511p ps=48.245u w=46.725u l=1u
X2393 BAT GATE DVDD DVDD pfet_06v0 ad=58.1134p pd=77.985u as=58.1134p ps=77.985u w=76.465u l=1u
X2394 DVDD GATE BAT DVDD pfet_06v0 ad=43.9215p pd=95.32999u as=35.511p ps=48.245u w=46.725u l=1u
X2395 BAT GATE DVDD DVDD pfet_06v0 ad=35.511p pd=48.245u as=35.511p ps=48.245u w=46.725u l=1u
X2396 DVDD GATE BAT DVDD pfet_06v0 ad=35.511p pd=48.245u as=35.511p ps=48.245u w=46.725u l=1u
X2397 BAT GATE DVDD DVDD pfet_06v0 ad=58.1134p pd=77.985u as=58.1134p ps=77.985u w=76.465u l=1u
X2398 BAT GATE DVDD DVDD pfet_06v0 ad=35.511p pd=48.245u as=35.511p ps=48.245u w=46.725u l=1u
X2399 DVDD GATE BAT DVDD pfet_06v0 ad=58.1172p pd=77.99u as=58.1172p ps=77.99u w=76.47u l=1u
X2400 DVDD GATE BAT DVDD pfet_06v0 ad=58.1134p pd=77.985u as=58.1134p ps=77.985u w=76.465u l=1u
X2401 BAT GATE DVDD DVDD pfet_06v0 ad=58.1096p pd=77.98u as=58.1096p ps=77.98u w=76.46u l=1u
X2402 BAT GATE DVDD DVDD pfet_06v0 ad=58.1096p pd=77.98u as=58.1096p ps=77.98u w=76.46u l=1u
X2403 DVDD GATE BAT DVDD pfet_06v0 ad=35.511p pd=48.245u as=35.511p ps=48.245u w=46.725u l=1u
X2404 BAT GATE DVDD DVDD pfet_06v0 ad=35.511p pd=48.245u as=43.9215p ps=95.32999u w=46.725u l=1u
X2405 DVDD GATE BAT DVDD pfet_06v0 ad=71.8771p pd=0.15481m as=58.1134p ps=77.985u w=76.465u l=1u
X2406 BAT GATE DVDD DVDD pfet_06v0 ad=35.511p pd=48.245u as=43.9215p ps=95.32999u w=46.725u l=1u
X2407 DVDD GATE BAT DVDD pfet_06v0 ad=35.511p pd=48.245u as=35.511p ps=48.245u w=46.725u l=1u
X2408 BAT GATE DVDD DVDD pfet_06v0 ad=58.1134p pd=77.985u as=58.1134p ps=77.985u w=76.465u l=1u
X2409 BAT GATE DVDD DVDD pfet_06v0 ad=35.511p pd=48.245u as=35.511p ps=48.245u w=46.725u l=1u
X2410 DVDD GATE BAT DVDD pfet_06v0 ad=58.1134p pd=77.985u as=58.1134p ps=77.985u w=76.465u l=1u
X2411 BAT GATE DVDD DVDD pfet_06v0 ad=35.511p pd=48.245u as=35.511p ps=48.245u w=46.725u l=1u
X2412 DVDD GATE BAT DVDD pfet_06v0 ad=35.511p pd=48.245u as=35.511p ps=48.245u w=46.725u l=1u
X2413 BAT GATE DVDD DVDD pfet_06v0 ad=35.511p pd=48.245u as=35.511p ps=48.245u w=46.725u l=1u
X2414 BAT GATE DVDD DVDD pfet_06v0 ad=35.511p pd=48.245u as=35.511p ps=48.245u w=46.725u l=1u
X2415 DVDD GATE BAT DVDD pfet_06v0 ad=35.511p pd=48.245u as=35.511p ps=48.245u w=46.725u l=1u
X2416 BAT GATE DVDD DVDD pfet_06v0 ad=58.1134p pd=77.985u as=71.8771p ps=0.15481m w=76.465u l=1u
X2417 BAT GATE DVDD DVDD pfet_06v0 ad=58.1134p pd=77.985u as=71.8771p ps=0.15481m w=76.465u l=1u
X2418 DVDD GATE BAT DVDD pfet_06v0 ad=35.511p pd=48.245u as=35.511p ps=48.245u w=46.725u l=1u
X2419 BAT GATE DVDD DVDD pfet_06v0 ad=58.1134p pd=77.985u as=58.1134p ps=77.985u w=76.465u l=1u
X2420 BAT GATE DVDD DVDD pfet_06v0 ad=58.1134p pd=77.985u as=58.1134p ps=77.985u w=76.465u l=1u
X2421 BAT GATE DVDD DVDD pfet_06v0 ad=35.511p pd=48.245u as=35.511p ps=48.245u w=46.725u l=1u
X2422 DVDD GATE BAT DVDD pfet_06v0 ad=47.6862p pd=64.265u as=47.6862p ps=64.265u w=62.745u l=1u
X2423 BAT GATE DVDD DVDD pfet_06v0 ad=58.1134p pd=77.985u as=71.8771p ps=0.15481m w=76.465u l=1u
X2424 BAT GATE DVDD DVDD pfet_06v0 ad=58.1134p pd=77.985u as=58.1134p ps=77.985u w=76.465u l=1u
X2425 DVDD GATE BAT DVDD pfet_06v0 ad=58.1552p pd=78.04u as=58.1552p ps=78.04u w=76.52u l=1u
X2426 DVDD GATE BAT DVDD pfet_06v0 ad=35.511p pd=48.245u as=35.511p ps=48.245u w=46.725u l=1u
X2427 BAT GATE DVDD DVDD pfet_06v0 ad=58.1134p pd=77.985u as=58.1134p ps=77.985u w=76.465u l=1u
X2428 DVDD GATE BAT DVDD pfet_06v0 ad=58.1172p pd=77.99u as=58.1172p ps=77.99u w=76.47u l=1u
X2429 BAT GATE DVDD DVDD pfet_06v0 ad=35.511p pd=48.245u as=43.9215p ps=95.32999u w=46.725u l=1u
X2430 DVDD GATE BAT DVDD pfet_06v0 ad=35.511p pd=48.245u as=35.511p ps=48.245u w=46.725u l=1u
X2431 DVDD GATE BAT DVDD pfet_06v0 ad=58.1134p pd=77.985u as=58.1134p ps=77.985u w=76.465u l=1u
X2432 DVDD GATE BAT DVDD pfet_06v0 ad=35.511p pd=48.245u as=35.511p ps=48.245u w=46.725u l=1u
X2433 DVDD GATE BAT DVDD pfet_06v0 ad=58.1134p pd=77.985u as=58.1134p ps=77.985u w=76.465u l=1u
X2434 DVDD GATE BAT DVDD pfet_06v0 ad=35.511p pd=48.245u as=35.511p ps=48.245u w=46.725u l=1u
X2435 DVDD GATE BAT DVDD pfet_06v0 ad=58.1134p pd=77.985u as=58.1134p ps=77.985u w=76.465u l=1u
X2436 BAT GATE DVDD DVDD pfet_06v0 ad=58.1096p pd=77.98u as=58.1096p ps=77.98u w=76.46u l=1u
X2437 BAT GATE DVDD DVDD pfet_06v0 ad=58.1096p pd=77.98u as=58.1096p ps=77.98u w=76.46u l=1u
X2438 BAT GATE DVDD DVDD pfet_06v0 ad=35.511p pd=48.245u as=35.511p ps=48.245u w=46.725u l=1u
X2439 DVDD GATE BAT DVDD pfet_06v0 ad=58.1134p pd=77.985u as=58.1134p ps=77.985u w=76.465u l=1u
X2440 DVDD GATE BAT DVDD pfet_06v0 ad=58.1172p pd=77.99u as=58.1172p ps=77.99u w=76.47u l=1u
X2441 BAT GATE DVDD DVDD pfet_06v0 ad=58.1134p pd=77.985u as=71.8771p ps=0.15481m w=76.465u l=1u
X2442 DVDD GATE BAT DVDD pfet_06v0 ad=35.511p pd=48.245u as=35.511p ps=48.245u w=46.725u l=1u
X2443 BAT GATE DVDD DVDD pfet_06v0 ad=35.511p pd=48.245u as=35.511p ps=48.245u w=46.725u l=1u
X2444 BAT GATE DVDD DVDD pfet_06v0 ad=35.511p pd=48.245u as=43.9215p ps=95.32999u w=46.725u l=1u
X2445 BAT GATE DVDD DVDD pfet_06v0 ad=58.1134p pd=77.985u as=58.1134p ps=77.985u w=76.465u l=1u
X2446 BAT GATE DVDD DVDD pfet_06v0 ad=35.511p pd=48.245u as=35.511p ps=48.245u w=46.725u l=1u
X2447 DVDD GATE BAT DVDD pfet_06v0 ad=35.5072p pd=48.24u as=35.5072p ps=48.24u w=46.72u l=1u
X2448 BAT GATE DVDD DVDD pfet_06v0 ad=58.1552p pd=78.04u as=58.1552p ps=78.04u w=76.52u l=1u
X2449 BAT GATE DVDD DVDD pfet_06v0 ad=49.3848p pd=66.5u as=49.3848p ps=66.5u w=64.98u l=1u
X2450 DVDD GATE BAT DVDD pfet_06v0 ad=47.6862p pd=64.265u as=47.6862p ps=64.265u w=62.745u l=1u
X2451 BAT GATE DVDD DVDD pfet_06v0 ad=58.1134p pd=77.985u as=58.1134p ps=77.985u w=76.465u l=1u
X2452 BAT GATE DVDD DVDD pfet_06v0 ad=35.511p pd=48.245u as=35.511p ps=48.245u w=46.725u l=1u
X2453 BAT GATE DVDD DVDD pfet_06v0 ad=58.1552p pd=78.04u as=58.1552p ps=78.04u w=76.52u l=1u
X2454 BAT GATE DVDD DVDD pfet_06v0 ad=58.1134p pd=77.985u as=58.1134p ps=77.985u w=76.465u l=1u
X2455 BAT GATE DVDD DVDD pfet_06v0 ad=49.3848p pd=66.5u as=49.3848p ps=66.5u w=64.98u l=1u
X2456 DVDD GATE BAT DVDD pfet_06v0 ad=58.1134p pd=77.985u as=58.1134p ps=77.985u w=76.465u l=1u
X2457 BAT GATE DVDD DVDD pfet_06v0 ad=58.1134p pd=77.985u as=71.8771p ps=0.15481m w=76.465u l=1u
X2458 DVDD GATE BAT DVDD pfet_06v0 ad=58.1096p pd=77.98u as=58.1096p ps=77.98u w=76.46u l=1u
X2459 BAT GATE DVDD DVDD pfet_06v0 ad=58.1134p pd=77.985u as=71.8771p ps=0.15481m w=76.465u l=1u
X2460 BAT GATE DVDD DVDD pfet_06v0 ad=58.1134p pd=77.985u as=58.1134p ps=77.985u w=76.465u l=1u
X2461 BAT GATE DVDD DVDD pfet_06v0 ad=49.3848p pd=66.5u as=49.3848p ps=66.5u w=64.98u l=1u
X2462 DVDD GATE BAT DVDD pfet_06v0 ad=58.1134p pd=77.985u as=58.1134p ps=77.985u w=76.465u l=1u
X2463 BAT GATE DVDD DVDD pfet_06v0 ad=35.511p pd=48.245u as=35.511p ps=48.245u w=46.725u l=1u
X2464 DVDD GATE BAT DVDD pfet_06v0 ad=71.8771p pd=0.15481m as=58.1134p ps=77.985u w=76.465u l=1u
X2465 BAT GATE DVDD DVDD pfet_06v0 ad=35.511p pd=48.245u as=35.511p ps=48.245u w=46.725u l=1u
X2466 BAT GATE DVDD DVDD pfet_06v0 ad=58.1172p pd=77.99u as=58.1172p ps=77.99u w=76.47u l=1u
X2467 BAT GATE DVDD DVDD pfet_06v0 ad=58.0754p pd=77.935u as=58.0754p ps=77.935u w=76.41499u l=1u
X2468 DVDD GATE BAT DVDD pfet_06v0 ad=58.1134p pd=77.985u as=58.1134p ps=77.985u w=76.465u l=1u
X2469 DVDD GATE BAT DVDD pfet_06v0 ad=43.9215p pd=95.32999u as=35.511p ps=48.245u w=46.725u l=1u
X2470 DVDD GATE BAT DVDD pfet_06v0 ad=35.5072p pd=48.24u as=35.5072p ps=48.24u w=46.72u l=1u
X2471 DVDD GATE BAT DVDD pfet_06v0 ad=58.1134p pd=77.985u as=58.1134p ps=77.985u w=76.465u l=1u
X2472 BAT GATE DVDD DVDD pfet_06v0 ad=58.1172p pd=77.99u as=58.1172p ps=77.99u w=76.47u l=1u
X2473 DVDD GATE BAT DVDD pfet_06v0 ad=35.511p pd=48.245u as=35.511p ps=48.245u w=46.725u l=1u
X2474 BAT GATE DVDD DVDD pfet_06v0 ad=58.1134p pd=77.985u as=58.1134p ps=77.985u w=76.465u l=1u
X2475 DVDD GATE BAT DVDD pfet_06v0 ad=49.3848p pd=66.5u as=49.3848p ps=66.5u w=64.98u l=1u
X2476 BAT GATE DVDD DVDD pfet_06v0 ad=58.1134p pd=77.985u as=71.8771p ps=0.15481m w=76.465u l=1u
X2477 BAT GATE DVDD DVDD pfet_06v0 ad=58.1096p pd=77.98u as=58.1096p ps=77.98u w=76.46u l=1u
X2478 BAT GATE DVDD DVDD pfet_06v0 ad=35.511p pd=48.245u as=43.9215p ps=95.32999u w=46.725u l=1u
X2479 BAT GATE DVDD DVDD pfet_06v0 ad=58.1134p pd=77.985u as=58.1134p ps=77.985u w=76.465u l=1u
X2480 DVDD GATE BAT DVDD pfet_06v0 ad=58.1172p pd=77.99u as=58.1172p ps=77.99u w=76.47u l=1u
X2481 BAT GATE DVDD DVDD pfet_06v0 ad=35.511p pd=48.245u as=35.511p ps=48.245u w=46.725u l=1u
X2482 DVDD GATE BAT DVDD pfet_06v0 ad=35.511p pd=48.245u as=35.511p ps=48.245u w=46.725u l=1u
X2483 DVDD GATE BAT DVDD pfet_06v0 ad=35.511p pd=48.245u as=35.511p ps=48.245u w=46.725u l=1u
X2484 DVDD GATE BAT DVDD pfet_06v0 ad=35.5072p pd=48.24u as=35.5072p ps=48.24u w=46.72u l=1u
X2485 DVDD GATE BAT DVDD pfet_06v0 ad=35.511p pd=48.245u as=35.511p ps=48.245u w=46.725u l=1u
X2486 DVDD GATE BAT DVDD pfet_06v0 ad=47.6862p pd=64.265u as=47.6862p ps=64.265u w=62.745u l=1u
X2487 BAT GATE DVDD DVDD pfet_06v0 ad=35.511p pd=48.245u as=43.9215p ps=95.32999u w=46.725u l=1u
X2488 DVDD GATE BAT DVDD pfet_06v0 ad=58.1134p pd=77.985u as=58.1134p ps=77.985u w=76.465u l=1u
X2489 BAT GATE DVDD DVDD pfet_06v0 ad=58.1134p pd=77.985u as=58.1134p ps=77.985u w=76.465u l=1u
X2490 BAT GATE DVDD DVDD pfet_06v0 ad=58.1134p pd=77.985u as=58.1134p ps=77.985u w=76.465u l=1u
X2491 DVDD GATE BAT DVDD pfet_06v0 ad=58.1134p pd=77.985u as=58.1134p ps=77.985u w=76.465u l=1u
X2492 BAT GATE DVDD DVDD pfet_06v0 ad=58.0754p pd=77.935u as=58.0754p ps=77.935u w=76.41499u l=1u
X2493 DVDD GATE BAT DVDD pfet_06v0 ad=35.511p pd=48.245u as=35.511p ps=48.245u w=46.725u l=1u
X2494 DVDD GATE BAT DVDD pfet_06v0 ad=35.511p pd=48.245u as=35.511p ps=48.245u w=46.725u l=1u
X2495 DVDD GATE BAT DVDD pfet_06v0 ad=47.6862p pd=64.265u as=47.6862p ps=64.265u w=62.745u l=1u
X2496 BAT GATE DVDD DVDD pfet_06v0 ad=58.0754p pd=77.935u as=58.0754p ps=77.935u w=76.41499u l=1u
X2497 DVDD GATE BAT DVDD pfet_06v0 ad=71.8771p pd=0.15481m as=58.1134p ps=77.985u w=76.465u l=1u
X2498 DVDD GATE BAT DVDD pfet_06v0 ad=47.6862p pd=64.265u as=47.6862p ps=64.265u w=62.745u l=1u
X2499 DVDD GATE BAT DVDD pfet_06v0 ad=35.511p pd=48.245u as=35.511p ps=48.245u w=46.725u l=1u
X2500 DVDD GATE BAT DVDD pfet_06v0 ad=43.9215p pd=95.32999u as=35.511p ps=48.245u w=46.725u l=1u
X2501 DVDD GATE BAT DVDD pfet_06v0 ad=35.5072p pd=48.24u as=35.5072p ps=48.24u w=46.72u l=1u
X2502 DVDD GATE BAT DVDD pfet_06v0 ad=58.1134p pd=77.985u as=58.1134p ps=77.985u w=76.465u l=1u
X2503 BAT GATE DVDD DVDD pfet_06v0 ad=58.1134p pd=77.985u as=71.8771p ps=0.15481m w=76.465u l=1u
X2504 BAT GATE DVDD DVDD pfet_06v0 ad=35.511p pd=48.245u as=43.9215p ps=95.32999u w=46.725u l=1u
X2505 BAT GATE DVDD DVDD pfet_06v0 ad=58.1134p pd=77.985u as=58.1134p ps=77.985u w=76.465u l=1u
X2506 BAT GATE DVDD DVDD pfet_06v0 ad=35.511p pd=48.245u as=35.511p ps=48.245u w=46.725u l=1u
X2507 DVDD GATE BAT DVDD pfet_06v0 ad=58.1096p pd=77.98u as=58.1096p ps=77.98u w=76.46u l=1u
X2508 BAT GATE DVDD DVDD pfet_06v0 ad=58.1134p pd=77.985u as=58.1134p ps=77.985u w=76.465u l=1u
X2509 DVDD GATE BAT DVDD pfet_06v0 ad=35.511p pd=48.245u as=35.511p ps=48.245u w=46.725u l=1u
X2510 DVDD GATE BAT DVDD pfet_06v0 ad=58.1172p pd=77.99u as=58.1172p ps=77.99u w=76.47u l=1u
X2511 BAT GATE DVDD DVDD pfet_06v0 ad=35.511p pd=48.245u as=35.511p ps=48.245u w=46.725u l=1u
X2512 DVDD GATE BAT DVDD pfet_06v0 ad=71.8771p pd=0.15481m as=58.1134p ps=77.985u w=76.465u l=1u
X2513 DVDD GATE BAT DVDD pfet_06v0 ad=58.1552p pd=78.04u as=58.1552p ps=78.04u w=76.52u l=1u
X2514 DVDD GATE BAT DVDD pfet_06v0 ad=35.511p pd=48.245u as=35.511p ps=48.245u w=46.725u l=1u
X2515 BAT GATE DVDD DVDD pfet_06v0 ad=35.511p pd=48.245u as=35.511p ps=48.245u w=46.725u l=1u
X2516 DVDD GATE BAT DVDD pfet_06v0 ad=71.8771p pd=0.15481m as=58.1134p ps=77.985u w=76.465u l=1u
X2517 BAT GATE DVDD DVDD pfet_06v0 ad=35.511p pd=48.245u as=43.9215p ps=95.32999u w=46.725u l=1u
X2518 BAT GATE DVDD DVDD pfet_06v0 ad=35.511p pd=48.245u as=35.511p ps=48.245u w=46.725u l=1u
X2519 BAT GATE DVDD DVDD pfet_06v0 ad=35.511p pd=48.245u as=35.511p ps=48.245u w=46.725u l=1u
X2520 BAT GATE DVDD DVDD pfet_06v0 ad=35.511p pd=48.245u as=35.511p ps=48.245u w=46.725u l=1u
X2521 DVDD GATE BAT DVDD pfet_06v0 ad=61.0812p pd=0.13184m as=49.3848p ps=66.5u w=64.98u l=1u
X2522 BAT GATE DVDD DVDD pfet_06v0 ad=58.1134p pd=77.985u as=58.1134p ps=77.985u w=76.465u l=1u
X2523 BAT GATE DVDD DVDD pfet_06v0 ad=47.6862p pd=64.265u as=47.6862p ps=64.265u w=62.745u l=1u
X2524 BAT GATE DVDD DVDD pfet_06v0 ad=35.511p pd=48.245u as=35.511p ps=48.245u w=46.725u l=1u
X2525 BAT GATE DVDD DVDD pfet_06v0 ad=35.511p pd=48.245u as=35.511p ps=48.245u w=46.725u l=1u
X2526 DVDD GATE BAT DVDD pfet_06v0 ad=58.1134p pd=77.985u as=58.1134p ps=77.985u w=76.465u l=1u
X2527 DVDD GATE BAT DVDD pfet_06v0 ad=35.511p pd=48.245u as=35.511p ps=48.245u w=46.725u l=1u
X2528 BAT GATE DVDD DVDD pfet_06v0 ad=35.511p pd=48.245u as=35.511p ps=48.245u w=46.725u l=1u
X2529 DVDD GATE BAT DVDD pfet_06v0 ad=35.511p pd=48.245u as=35.511p ps=48.245u w=46.725u l=1u
X2530 BAT GATE DVDD DVDD pfet_06v0 ad=35.511p pd=48.245u as=35.511p ps=48.245u w=46.725u l=1u
X2531 BAT GATE DVDD DVDD pfet_06v0 ad=35.5072p pd=48.24u as=43.9168p ps=95.32u w=46.72u l=1u
X2532 DVDD GATE BAT DVDD pfet_06v0 ad=71.8771p pd=0.15481m as=58.1134p ps=77.985u w=76.465u l=1u
X2533 BAT GATE DVDD DVDD pfet_06v0 ad=35.5072p pd=48.24u as=35.5072p ps=48.24u w=46.72u l=1u
X2534 DVDD GATE BAT DVDD pfet_06v0 ad=35.511p pd=48.245u as=35.511p ps=48.245u w=46.725u l=1u
X2535 DVDD GATE BAT DVDD pfet_06v0 ad=35.511p pd=48.245u as=35.511p ps=48.245u w=46.725u l=1u
X2536 DVDD GATE BAT DVDD pfet_06v0 ad=58.1096p pd=77.98u as=58.1096p ps=77.98u w=76.46u l=1u
X2537 DVDD GATE BAT DVDD pfet_06v0 ad=35.511p pd=48.245u as=35.511p ps=48.245u w=46.725u l=1u
X2538 DVDD GATE BAT DVDD pfet_06v0 ad=49.3848p pd=66.5u as=49.3848p ps=66.5u w=64.98u l=1u
X2539 BAT GATE DVDD DVDD pfet_06v0 ad=35.511p pd=48.245u as=35.511p ps=48.245u w=46.725u l=1u
X2540 DVDD GATE BAT DVDD pfet_06v0 ad=35.511p pd=48.245u as=35.511p ps=48.245u w=46.725u l=1u
X2541 DVDD GATE BAT DVDD pfet_06v0 ad=35.511p pd=48.245u as=35.511p ps=48.245u w=46.725u l=1u
X2542 DVDD GATE BAT DVDD pfet_06v0 ad=58.1134p pd=77.985u as=58.1134p ps=77.985u w=76.465u l=1u
X2543 DVDD GATE BAT DVDD pfet_06v0 ad=35.511p pd=48.245u as=35.511p ps=48.245u w=46.725u l=1u
X2544 DVDD GATE BAT DVDD pfet_06v0 ad=58.1552p pd=78.04u as=58.1552p ps=78.04u w=76.52u l=1u
X2545 BAT GATE DVDD DVDD pfet_06v0 ad=35.511p pd=48.245u as=35.511p ps=48.245u w=46.725u l=1u
X2546 BAT GATE DVDD DVDD pfet_06v0 ad=58.1172p pd=77.99u as=71.8818p ps=0.15482m w=76.47u l=1u
X2547 BAT GATE DVDD DVDD pfet_06v0 ad=58.1134p pd=77.985u as=58.1134p ps=77.985u w=76.465u l=1u
X2548 DVDD GATE BAT DVDD pfet_06v0 ad=49.3848p pd=66.5u as=49.3848p ps=66.5u w=64.98u l=1u
X2549 BAT GATE DVDD DVDD pfet_06v0 ad=35.511p pd=48.245u as=43.9215p ps=95.32999u w=46.725u l=1u
X2550 DVDD GATE BAT DVDD pfet_06v0 ad=43.9215p pd=95.32999u as=35.511p ps=48.245u w=46.725u l=1u
X2551 DVDD GATE BAT DVDD pfet_06v0 ad=35.511p pd=48.245u as=35.511p ps=48.245u w=46.725u l=1u
X2552 DVDD GATE BAT DVDD pfet_06v0 ad=35.511p pd=48.245u as=35.511p ps=48.245u w=46.725u l=1u
X2553 BAT GATE DVDD DVDD pfet_06v0 ad=58.1134p pd=77.985u as=58.1134p ps=77.985u w=76.465u l=1u
X2554 BAT GATE DVDD DVDD pfet_06v0 ad=49.3848p pd=66.5u as=61.0812p ps=0.13184m w=64.98u l=1u
X2555 DVDD GATE BAT DVDD pfet_06v0 ad=71.8301p pd=0.15471m as=58.0754p ps=77.935u w=76.41499u l=1u
X2556 DVDD GATE BAT DVDD pfet_06v0 ad=58.1134p pd=77.985u as=58.1134p ps=77.985u w=76.465u l=1u
X2557 DVDD GATE BAT DVDD pfet_06v0 ad=35.511p pd=48.245u as=35.511p ps=48.245u w=46.725u l=1u
X2558 BAT GATE DVDD DVDD pfet_06v0 ad=47.6862p pd=64.265u as=47.6862p ps=64.265u w=62.745u l=1u
X2559 BAT GATE DVDD DVDD pfet_06v0 ad=35.511p pd=48.245u as=35.511p ps=48.245u w=46.725u l=1u
X2560 DVDD GATE BAT DVDD pfet_06v0 ad=47.6862p pd=64.265u as=47.6862p ps=64.265u w=62.745u l=1u
X2561 BAT GATE DVDD DVDD pfet_06v0 ad=47.6862p pd=64.265u as=47.6862p ps=64.265u w=62.745u l=1u
X2562 BAT GATE DVDD DVDD pfet_06v0 ad=58.0754p pd=77.935u as=58.0754p ps=77.935u w=76.41499u l=1u
X2563 BAT GATE DVDD DVDD pfet_06v0 ad=58.1134p pd=77.985u as=58.1134p ps=77.985u w=76.465u l=1u
X2564 DVDD GATE BAT DVDD pfet_06v0 ad=58.1134p pd=77.985u as=58.1134p ps=77.985u w=76.465u l=1u
X2565 BAT GATE DVDD DVDD pfet_06v0 ad=35.511p pd=48.245u as=35.511p ps=48.245u w=46.725u l=1u
X2566 DVDD GATE BAT DVDD pfet_06v0 ad=71.8771p pd=0.15481m as=58.1134p ps=77.985u w=76.465u l=1u
X2567 DVDD GATE BAT DVDD pfet_06v0 ad=58.9803p pd=0.12737m as=47.6862p ps=64.265u w=62.745u l=1u
X2568 DVDD GATE BAT DVDD pfet_06v0 ad=58.1134p pd=77.985u as=58.1134p ps=77.985u w=76.465u l=1u
X2569 BAT GATE DVDD DVDD pfet_06v0 ad=58.1134p pd=77.985u as=58.1134p ps=77.985u w=76.465u l=1u
X2570 DVDD GATE BAT DVDD pfet_06v0 ad=35.511p pd=48.245u as=35.511p ps=48.245u w=46.725u l=1u
X2571 DVDD GATE BAT DVDD pfet_06v0 ad=58.1172p pd=77.99u as=58.1172p ps=77.99u w=76.47u l=1u
X2572 BAT GATE DVDD DVDD pfet_06v0 ad=35.5072p pd=48.24u as=35.5072p ps=48.24u w=46.72u l=1u
X2573 DVDD GATE BAT DVDD pfet_06v0 ad=58.1134p pd=77.985u as=58.1134p ps=77.985u w=76.465u l=1u
X2574 BAT GATE DVDD DVDD pfet_06v0 ad=49.3848p pd=66.5u as=49.3848p ps=66.5u w=64.98u l=1u
X2575 DVDD GATE BAT DVDD pfet_06v0 ad=35.511p pd=48.245u as=35.511p ps=48.245u w=46.725u l=1u
X2576 DVDD GATE BAT DVDD pfet_06v0 ad=58.1552p pd=78.04u as=58.1552p ps=78.04u w=76.52u l=1u
X2577 DVDD GATE BAT DVDD pfet_06v0 ad=71.8724p pd=0.1548m as=58.1096p ps=77.98u w=76.46u l=1u
X2578 BAT GATE DVDD DVDD pfet_06v0 ad=58.1172p pd=77.99u as=58.1172p ps=77.99u w=76.47u l=1u
X2579 BAT GATE DVDD DVDD pfet_06v0 ad=47.6862p pd=64.265u as=58.9803p ps=0.12737m w=62.745u l=1u
X2580 BAT GATE DVDD DVDD pfet_06v0 ad=35.511p pd=48.245u as=35.511p ps=48.245u w=46.725u l=1u
X2581 BAT GATE DVDD DVDD pfet_06v0 ad=58.1134p pd=77.985u as=71.8771p ps=0.15481m w=76.465u l=1u
X2582 DVDD GATE BAT DVDD pfet_06v0 ad=43.9215p pd=95.32999u as=35.511p ps=48.245u w=46.725u l=1u
X2583 BAT GATE DVDD DVDD pfet_06v0 ad=35.511p pd=48.245u as=35.511p ps=48.245u w=46.725u l=1u
X2584 DVDD GATE BAT DVDD pfet_06v0 ad=58.1134p pd=77.985u as=58.1134p ps=77.985u w=76.465u l=1u
X2585 DVDD GATE BAT DVDD pfet_06v0 ad=58.1134p pd=77.985u as=58.1134p ps=77.985u w=76.465u l=1u
X2586 BAT GATE DVDD DVDD pfet_06v0 ad=58.1134p pd=77.985u as=71.8771p ps=0.15481m w=76.465u l=1u
X2587 DVDD GATE BAT DVDD pfet_06v0 ad=35.511p pd=48.245u as=35.511p ps=48.245u w=46.725u l=1u
X2588 BAT GATE DVDD DVDD pfet_06v0 ad=35.511p pd=48.245u as=35.511p ps=48.245u w=46.725u l=1u
X2589 BAT GATE DVDD DVDD pfet_06v0 ad=47.6862p pd=64.265u as=58.9803p ps=0.12737m w=62.745u l=1u
X2590 BAT GATE DVDD DVDD pfet_06v0 ad=58.1134p pd=77.985u as=58.1134p ps=77.985u w=76.465u l=1u
X2591 DVDD GATE BAT DVDD pfet_06v0 ad=58.1552p pd=78.04u as=58.1552p ps=78.04u w=76.52u l=1u
X2592 BAT GATE DVDD DVDD pfet_06v0 ad=35.511p pd=48.245u as=35.511p ps=48.245u w=46.725u l=1u
X2593 DVDD GATE BAT DVDD pfet_06v0 ad=58.1172p pd=77.99u as=58.1172p ps=77.99u w=76.47u l=1u
X2594 DVDD GATE BAT DVDD pfet_06v0 ad=58.1134p pd=77.985u as=58.1134p ps=77.985u w=76.465u l=1u
X2595 BAT GATE DVDD DVDD pfet_06v0 ad=58.1552p pd=78.04u as=58.1552p ps=78.04u w=76.52u l=1u
X2596 BAT GATE DVDD DVDD pfet_06v0 ad=35.511p pd=48.245u as=35.511p ps=48.245u w=46.725u l=1u
X2597 DVDD GATE BAT DVDD pfet_06v0 ad=58.1134p pd=77.985u as=58.1134p ps=77.985u w=76.465u l=1u
X2598 BAT GATE DVDD DVDD pfet_06v0 ad=35.511p pd=48.245u as=43.9215p ps=95.32999u w=46.725u l=1u
X2599 BAT GATE DVDD DVDD pfet_06v0 ad=58.1134p pd=77.985u as=58.1134p ps=77.985u w=76.465u l=1u
X2600 DVDD GATE BAT DVDD pfet_06v0 ad=58.1134p pd=77.985u as=58.1134p ps=77.985u w=76.465u l=1u
X2601 BAT GATE DVDD DVDD pfet_06v0 ad=35.511p pd=48.245u as=35.511p ps=48.245u w=46.725u l=1u
X2602 DVDD GATE BAT DVDD pfet_06v0 ad=58.1134p pd=77.985u as=58.1134p ps=77.985u w=76.465u l=1u
X2603 DVDD GATE BAT DVDD pfet_06v0 ad=58.1134p pd=77.985u as=58.1134p ps=77.985u w=76.465u l=1u
X2604 BAT GATE DVDD DVDD pfet_06v0 ad=35.511p pd=48.245u as=35.511p ps=48.245u w=46.725u l=1u
X2605 DVDD GATE BAT DVDD pfet_06v0 ad=35.511p pd=48.245u as=35.511p ps=48.245u w=46.725u l=1u
X2606 DVDD GATE BAT DVDD pfet_06v0 ad=35.511p pd=48.245u as=35.511p ps=48.245u w=46.725u l=1u
X2607 DVDD GATE BAT DVDD pfet_06v0 ad=43.9215p pd=95.32999u as=35.511p ps=48.245u w=46.725u l=1u
X2608 DVDD GATE BAT DVDD pfet_06v0 ad=43.9215p pd=95.32999u as=35.511p ps=48.245u w=46.725u l=1u
X2609 BAT GATE DVDD DVDD pfet_06v0 ad=58.1134p pd=77.985u as=71.8771p ps=0.15481m w=76.465u l=1u
X2610 DVDD GATE BAT DVDD pfet_06v0 ad=35.511p pd=48.245u as=35.511p ps=48.245u w=46.725u l=1u
X2611 DVDD GATE BAT DVDD pfet_06v0 ad=43.9215p pd=95.32999u as=35.511p ps=48.245u w=46.725u l=1u
X2612 DVDD GATE BAT DVDD pfet_06v0 ad=35.511p pd=48.245u as=35.511p ps=48.245u w=46.725u l=1u
X2613 DVDD GATE BAT DVDD pfet_06v0 ad=43.9215p pd=95.32999u as=35.511p ps=48.245u w=46.725u l=1u
X2614 DVDD GATE BAT DVDD pfet_06v0 ad=47.6862p pd=64.265u as=47.6862p ps=64.265u w=62.745u l=1u
X2615 BAT GATE DVDD DVDD pfet_06v0 ad=35.511p pd=48.245u as=35.511p ps=48.245u w=46.725u l=1u
X2616 DVDD GATE BAT DVDD pfet_06v0 ad=35.511p pd=48.245u as=35.511p ps=48.245u w=46.725u l=1u
X2617 BAT GATE DVDD DVDD pfet_06v0 ad=58.1134p pd=77.985u as=58.1134p ps=77.985u w=76.465u l=1u
X2618 DVDD GATE BAT DVDD pfet_06v0 ad=35.511p pd=48.245u as=35.511p ps=48.245u w=46.725u l=1u
X2619 DVDD GATE BAT DVDD pfet_06v0 ad=35.511p pd=48.245u as=35.511p ps=48.245u w=46.725u l=1u
X2620 BAT GATE DVDD DVDD pfet_06v0 ad=35.511p pd=48.245u as=35.511p ps=48.245u w=46.725u l=1u
X2621 DVDD GATE BAT DVDD pfet_06v0 ad=58.1134p pd=77.985u as=58.1134p ps=77.985u w=76.465u l=1u
X2622 BAT GATE DVDD DVDD pfet_06v0 ad=58.1134p pd=77.985u as=58.1134p ps=77.985u w=76.465u l=1u
X2623 BAT GATE DVDD DVDD pfet_06v0 ad=35.511p pd=48.245u as=43.9215p ps=95.32999u w=46.725u l=1u
X2624 DVDD GATE BAT DVDD pfet_06v0 ad=58.1096p pd=77.98u as=58.1096p ps=77.98u w=76.46u l=1u
X2625 DVDD GATE BAT DVDD pfet_06v0 ad=43.9215p pd=95.32999u as=35.511p ps=48.245u w=46.725u l=1u
X2626 BAT GATE DVDD DVDD pfet_06v0 ad=58.1552p pd=78.04u as=58.1552p ps=78.04u w=76.52u l=1u
X2627 DVDD GATE BAT DVDD pfet_06v0 ad=58.0754p pd=77.935u as=58.0754p ps=77.935u w=76.41499u l=1u
X2628 BAT GATE DVDD DVDD pfet_06v0 ad=58.1172p pd=77.99u as=58.1172p ps=77.99u w=76.47u l=1u
X2629 DVDD GATE BAT DVDD pfet_06v0 ad=43.9215p pd=95.32999u as=35.511p ps=48.245u w=46.725u l=1u
X2630 DVDD GATE BAT DVDD pfet_06v0 ad=35.511p pd=48.245u as=35.511p ps=48.245u w=46.725u l=1u
X2631 BAT GATE DVDD DVDD pfet_06v0 ad=35.511p pd=48.245u as=35.511p ps=48.245u w=46.725u l=1u
X2632 DVDD GATE BAT DVDD pfet_06v0 ad=61.0812p pd=0.13184m as=49.3848p ps=66.5u w=64.98u l=1u
X2633 BAT GATE DVDD DVDD pfet_06v0 ad=35.511p pd=48.245u as=35.511p ps=48.245u w=46.725u l=1u
X2634 BAT GATE DVDD DVDD pfet_06v0 ad=35.511p pd=48.245u as=35.511p ps=48.245u w=46.725u l=1u
X2635 BAT GATE DVDD DVDD pfet_06v0 ad=49.3848p pd=66.5u as=49.3848p ps=66.5u w=64.98u l=1u
X2636 BAT GATE DVDD DVDD pfet_06v0 ad=35.511p pd=48.245u as=35.511p ps=48.245u w=46.725u l=1u
X2637 DVDD GATE BAT DVDD pfet_06v0 ad=35.511p pd=48.245u as=35.511p ps=48.245u w=46.725u l=1u
X2638 DVDD GATE BAT DVDD pfet_06v0 ad=58.1134p pd=77.985u as=58.1134p ps=77.985u w=76.465u l=1u
X2639 BAT GATE DVDD DVDD pfet_06v0 ad=58.1172p pd=77.99u as=71.8818p ps=0.15482m w=76.47u l=1u
X2640 DVDD GATE BAT DVDD pfet_06v0 ad=58.1134p pd=77.985u as=58.1134p ps=77.985u w=76.465u l=1u
X2641 DVDD GATE BAT DVDD pfet_06v0 ad=58.1134p pd=77.985u as=58.1134p ps=77.985u w=76.465u l=1u
X2642 DVDD GATE BAT DVDD pfet_06v0 ad=58.1134p pd=77.985u as=58.1134p ps=77.985u w=76.465u l=1u
X2643 DVDD GATE BAT DVDD pfet_06v0 ad=35.511p pd=48.245u as=35.511p ps=48.245u w=46.725u l=1u
X2644 BAT GATE DVDD DVDD pfet_06v0 ad=35.511p pd=48.245u as=35.511p ps=48.245u w=46.725u l=1u
X2645 DVDD GATE BAT DVDD pfet_06v0 ad=58.1096p pd=77.98u as=58.1096p ps=77.98u w=76.46u l=1u
X2646 DVDD GATE BAT DVDD pfet_06v0 ad=58.1134p pd=77.985u as=58.1134p ps=77.985u w=76.465u l=1u
X2647 DVDD GATE BAT DVDD pfet_06v0 ad=43.9215p pd=95.32999u as=35.511p ps=48.245u w=46.725u l=1u
X2648 BAT GATE DVDD DVDD pfet_06v0 ad=35.511p pd=48.245u as=35.511p ps=48.245u w=46.725u l=1u
X2649 DVDD GATE BAT DVDD pfet_06v0 ad=43.9215p pd=95.32999u as=35.511p ps=48.245u w=46.725u l=1u
X2650 BAT GATE DVDD DVDD pfet_06v0 ad=58.1134p pd=77.985u as=58.1134p ps=77.985u w=76.465u l=1u
X2651 BAT GATE DVDD DVDD pfet_06v0 ad=35.511p pd=48.245u as=35.511p ps=48.245u w=46.725u l=1u
X2652 BAT GATE DVDD DVDD pfet_06v0 ad=58.1172p pd=77.99u as=71.8818p ps=0.15482m w=76.47u l=1u
X2653 BAT GATE DVDD DVDD pfet_06v0 ad=58.1134p pd=77.985u as=71.8771p ps=0.15481m w=76.465u l=1u
X2654 BAT GATE DVDD DVDD pfet_06v0 ad=35.5072p pd=48.24u as=35.5072p ps=48.24u w=46.72u l=1u
X2655 DVDD GATE BAT DVDD pfet_06v0 ad=35.5072p pd=48.24u as=35.5072p ps=48.24u w=46.72u l=1u
X2656 DVDD GATE BAT DVDD pfet_06v0 ad=58.1096p pd=77.98u as=58.1096p ps=77.98u w=76.46u l=1u
X2657 BAT GATE DVDD DVDD pfet_06v0 ad=47.6862p pd=64.265u as=47.6862p ps=64.265u w=62.745u l=1u
X2658 BAT GATE DVDD DVDD pfet_06v0 ad=35.511p pd=48.245u as=43.9215p ps=95.32999u w=46.725u l=1u
X2659 BAT GATE DVDD DVDD pfet_06v0 ad=58.1134p pd=77.985u as=71.8771p ps=0.15481m w=76.465u l=1u
X2660 DVDD GATE BAT DVDD pfet_06v0 ad=35.5072p pd=48.24u as=35.5072p ps=48.24u w=46.72u l=1u
X2661 BAT GATE DVDD DVDD pfet_06v0 ad=58.1134p pd=77.985u as=58.1134p ps=77.985u w=76.465u l=1u
X2662 BAT GATE DVDD DVDD pfet_06v0 ad=35.511p pd=48.245u as=35.511p ps=48.245u w=46.725u l=1u
X2663 DVDD GATE BAT DVDD pfet_06v0 ad=35.511p pd=48.245u as=35.511p ps=48.245u w=46.725u l=1u
X2664 BAT GATE DVDD DVDD pfet_06v0 ad=58.1552p pd=78.04u as=71.92879p ps=0.15492m w=76.52u l=1u
X2665 BAT GATE DVDD DVDD pfet_06v0 ad=58.1134p pd=77.985u as=58.1134p ps=77.985u w=76.465u l=1u
X2666 BAT GATE DVDD DVDD pfet_06v0 ad=58.1134p pd=77.985u as=58.1134p ps=77.985u w=76.465u l=1u
X2667 BAT GATE DVDD DVDD pfet_06v0 ad=47.6862p pd=64.265u as=47.6862p ps=64.265u w=62.745u l=1u
X2668 DVDD GATE BAT DVDD pfet_06v0 ad=58.0754p pd=77.935u as=58.0754p ps=77.935u w=76.41499u l=1u
X2669 BAT GATE DVDD DVDD pfet_06v0 ad=58.1134p pd=77.985u as=58.1134p ps=77.985u w=76.465u l=1u
X2670 DVDD GATE BAT DVDD pfet_06v0 ad=35.511p pd=48.245u as=35.511p ps=48.245u w=46.725u l=1u
X2671 BAT GATE DVDD DVDD pfet_06v0 ad=35.511p pd=48.245u as=35.511p ps=48.245u w=46.725u l=1u
X2672 BAT GATE DVDD DVDD pfet_06v0 ad=58.1134p pd=77.985u as=58.1134p ps=77.985u w=76.465u l=1u
X2673 BAT GATE DVDD DVDD pfet_06v0 ad=35.511p pd=48.245u as=35.511p ps=48.245u w=46.725u l=1u
X2674 DVDD GATE BAT DVDD pfet_06v0 ad=35.511p pd=48.245u as=35.511p ps=48.245u w=46.725u l=1u
X2675 DVDD GATE BAT DVDD pfet_06v0 ad=58.1096p pd=77.98u as=58.1096p ps=77.98u w=76.46u l=1u
X2676 BAT GATE DVDD DVDD pfet_06v0 ad=58.1172p pd=77.99u as=58.1172p ps=77.99u w=76.47u l=1u
X2677 DVDD GATE BAT DVDD pfet_06v0 ad=35.511p pd=48.245u as=35.511p ps=48.245u w=46.725u l=1u
X2678 BAT GATE DVDD DVDD pfet_06v0 ad=35.511p pd=48.245u as=35.511p ps=48.245u w=46.725u l=1u
X2679 BAT GATE DVDD DVDD pfet_06v0 ad=35.5072p pd=48.24u as=35.5072p ps=48.24u w=46.72u l=1u
X2680 DVDD GATE BAT DVDD pfet_06v0 ad=35.511p pd=48.245u as=35.511p ps=48.245u w=46.725u l=1u
X2681 BAT GATE DVDD DVDD pfet_06v0 ad=58.1134p pd=77.985u as=58.1134p ps=77.985u w=76.465u l=1u
X2682 BAT GATE DVDD DVDD pfet_06v0 ad=35.511p pd=48.245u as=35.511p ps=48.245u w=46.725u l=1u
X2683 BAT GATE DVDD DVDD pfet_06v0 ad=58.0754p pd=77.935u as=58.0754p ps=77.935u w=76.41499u l=1u
X2684 DVDD GATE BAT DVDD pfet_06v0 ad=58.1134p pd=77.985u as=58.1134p ps=77.985u w=76.465u l=1u
X2685 DVDD GATE BAT DVDD pfet_06v0 ad=35.511p pd=48.245u as=35.511p ps=48.245u w=46.725u l=1u
X2686 DVDD GATE BAT DVDD pfet_06v0 ad=43.9215p pd=95.32999u as=35.511p ps=48.245u w=46.725u l=1u
X2687 BAT GATE DVDD DVDD pfet_06v0 ad=35.511p pd=48.245u as=35.511p ps=48.245u w=46.725u l=1u
X2688 DVDD GATE BAT DVDD pfet_06v0 ad=71.8771p pd=0.15481m as=58.1134p ps=77.985u w=76.465u l=1u
X2689 BAT GATE DVDD DVDD pfet_06v0 ad=58.1134p pd=77.985u as=58.1134p ps=77.985u w=76.465u l=1u
X2690 DVDD GATE BAT DVDD pfet_06v0 ad=58.0754p pd=77.935u as=58.0754p ps=77.935u w=76.41499u l=1u
X2691 DVDD GATE BAT DVDD pfet_06v0 ad=43.9215p pd=95.32999u as=35.511p ps=48.245u w=46.725u l=1u
X2692 BAT GATE DVDD DVDD pfet_06v0 ad=35.511p pd=48.245u as=35.511p ps=48.245u w=46.725u l=1u
X2693 BAT GATE DVDD DVDD pfet_06v0 ad=58.1134p pd=77.985u as=58.1134p ps=77.985u w=76.465u l=1u
X2694 DVDD GATE BAT DVDD pfet_06v0 ad=47.6862p pd=64.265u as=47.6862p ps=64.265u w=62.745u l=1u
X2695 DVDD GATE BAT DVDD pfet_06v0 ad=35.511p pd=48.245u as=35.511p ps=48.245u w=46.725u l=1u
X2696 BAT GATE DVDD DVDD pfet_06v0 ad=35.511p pd=48.245u as=35.511p ps=48.245u w=46.725u l=1u
X2697 DVDD GATE BAT DVDD pfet_06v0 ad=58.1172p pd=77.99u as=58.1172p ps=77.99u w=76.47u l=1u
X2698 BAT GATE DVDD DVDD pfet_06v0 ad=58.1134p pd=77.985u as=71.8771p ps=0.15481m w=76.465u l=1u
X2699 BAT GATE DVDD DVDD pfet_06v0 ad=35.511p pd=48.245u as=35.511p ps=48.245u w=46.725u l=1u
X2700 DVDD GATE BAT DVDD pfet_06v0 ad=58.1172p pd=77.99u as=58.1172p ps=77.99u w=76.47u l=1u
X2701 BAT GATE DVDD DVDD pfet_06v0 ad=58.1096p pd=77.98u as=71.8724p ps=0.1548m w=76.46u l=1u
X2702 DVDD GATE BAT DVDD pfet_06v0 ad=58.1134p pd=77.985u as=58.1134p ps=77.985u w=76.465u l=1u
X2703 DVDD GATE BAT DVDD pfet_06v0 ad=35.511p pd=48.245u as=35.511p ps=48.245u w=46.725u l=1u
X2704 BAT GATE DVDD DVDD pfet_06v0 ad=35.511p pd=48.245u as=35.511p ps=48.245u w=46.725u l=1u
X2705 BAT GATE DVDD DVDD pfet_06v0 ad=58.1096p pd=77.98u as=71.8724p ps=0.1548m w=76.46u l=1u
X2706 BAT GATE DVDD DVDD pfet_06v0 ad=58.1096p pd=77.98u as=58.1096p ps=77.98u w=76.46u l=1u
X2707 DVDD GATE BAT DVDD pfet_06v0 ad=35.511p pd=48.245u as=35.511p ps=48.245u w=46.725u l=1u
X2708 BAT GATE DVDD DVDD pfet_06v0 ad=35.511p pd=48.245u as=35.511p ps=48.245u w=46.725u l=1u
X2709 DVDD GATE BAT DVDD pfet_06v0 ad=58.1134p pd=77.985u as=58.1134p ps=77.985u w=76.465u l=1u
X2710 DVDD GATE BAT DVDD pfet_06v0 ad=35.511p pd=48.245u as=35.511p ps=48.245u w=46.725u l=1u
X2711 BAT GATE DVDD DVDD pfet_06v0 ad=35.511p pd=48.245u as=43.9215p ps=95.32999u w=46.725u l=1u
X2712 BAT GATE DVDD DVDD pfet_06v0 ad=58.1134p pd=77.985u as=58.1134p ps=77.985u w=76.465u l=1u
X2713 DVDD GATE BAT DVDD pfet_06v0 ad=58.1134p pd=77.985u as=58.1134p ps=77.985u w=76.465u l=1u
X2714 BAT GATE DVDD DVDD pfet_06v0 ad=35.511p pd=48.245u as=35.511p ps=48.245u w=46.725u l=1u
X2715 BAT GATE DVDD DVDD pfet_06v0 ad=35.511p pd=48.245u as=35.511p ps=48.245u w=46.725u l=1u
X2716 BAT GATE DVDD DVDD pfet_06v0 ad=35.5072p pd=48.24u as=43.9168p ps=95.32u w=46.72u l=1u
X2717 BAT GATE DVDD DVDD pfet_06v0 ad=58.1134p pd=77.985u as=58.1134p ps=77.985u w=76.465u l=1u
X2718 DVDD GATE BAT DVDD pfet_06v0 ad=71.8771p pd=0.15481m as=58.1134p ps=77.985u w=76.465u l=1u
X2719 DVDD GATE BAT DVDD pfet_06v0 ad=58.1552p pd=78.04u as=58.1552p ps=78.04u w=76.52u l=1u
X2720 BAT GATE DVDD DVDD pfet_06v0 ad=35.511p pd=48.245u as=35.511p ps=48.245u w=46.725u l=1u
X2721 BAT GATE DVDD DVDD pfet_06v0 ad=35.5072p pd=48.24u as=43.9168p ps=95.32u w=46.72u l=1u
X2722 DVDD GATE BAT DVDD pfet_06v0 ad=71.8771p pd=0.15481m as=58.1134p ps=77.985u w=76.465u l=1u
X2723 DVDD GATE BAT DVDD pfet_06v0 ad=35.511p pd=48.245u as=35.511p ps=48.245u w=46.725u l=1u
X2724 DVDD GATE BAT DVDD pfet_06v0 ad=71.8771p pd=0.15481m as=58.1134p ps=77.985u w=76.465u l=1u
X2725 BAT GATE DVDD DVDD pfet_06v0 ad=58.1134p pd=77.985u as=58.1134p ps=77.985u w=76.465u l=1u
X2726 DVDD GATE BAT DVDD pfet_06v0 ad=43.9215p pd=95.32999u as=35.511p ps=48.245u w=46.725u l=1u
X2727 BAT GATE DVDD DVDD pfet_06v0 ad=49.3848p pd=66.5u as=49.3848p ps=66.5u w=64.98u l=1u
X2728 DVDD GATE BAT DVDD pfet_06v0 ad=47.6862p pd=64.265u as=47.6862p ps=64.265u w=62.745u l=1u
X2729 BAT GATE DVDD DVDD pfet_06v0 ad=58.1134p pd=77.985u as=58.1134p ps=77.985u w=76.465u l=1u
X2730 DVDD GATE BAT DVDD pfet_06v0 ad=58.1552p pd=78.04u as=58.1552p ps=78.04u w=76.52u l=1u
X2731 DVDD GATE BAT DVDD pfet_06v0 ad=35.511p pd=48.245u as=35.511p ps=48.245u w=46.725u l=1u
X2732 BAT GATE DVDD DVDD pfet_06v0 ad=58.1134p pd=77.985u as=71.8771p ps=0.15481m w=76.465u l=1u
X2733 DVDD GATE BAT DVDD pfet_06v0 ad=35.511p pd=48.245u as=35.511p ps=48.245u w=46.725u l=1u
X2734 DVDD GATE BAT DVDD pfet_06v0 ad=43.9215p pd=95.32999u as=35.511p ps=48.245u w=46.725u l=1u
X2735 BAT GATE DVDD DVDD pfet_06v0 ad=58.1134p pd=77.985u as=58.1134p ps=77.985u w=76.465u l=1u
X2736 BAT GATE DVDD DVDD pfet_06v0 ad=58.1134p pd=77.985u as=58.1134p ps=77.985u w=76.465u l=1u
X2737 DVDD GATE BAT DVDD pfet_06v0 ad=58.1134p pd=77.985u as=58.1134p ps=77.985u w=76.465u l=1u
X2738 BAT GATE DVDD DVDD pfet_06v0 ad=58.1134p pd=77.985u as=58.1134p ps=77.985u w=76.465u l=1u
X2739 DVDD GATE BAT DVDD pfet_06v0 ad=43.9215p pd=95.32999u as=35.511p ps=48.245u w=46.725u l=1u
X2740 BAT GATE DVDD DVDD pfet_06v0 ad=58.1134p pd=77.985u as=58.1134p ps=77.985u w=76.465u l=1u
X2741 BAT GATE DVDD DVDD pfet_06v0 ad=35.511p pd=48.245u as=35.511p ps=48.245u w=46.725u l=1u
X2742 DVDD GATE BAT DVDD pfet_06v0 ad=71.8771p pd=0.15481m as=58.1134p ps=77.985u w=76.465u l=1u
X2743 BAT GATE DVDD DVDD pfet_06v0 ad=58.1096p pd=77.98u as=58.1096p ps=77.98u w=76.46u l=1u
X2744 BAT GATE DVDD DVDD pfet_06v0 ad=35.511p pd=48.245u as=35.511p ps=48.245u w=46.725u l=1u
X2745 DVDD GATE BAT DVDD pfet_06v0 ad=35.511p pd=48.245u as=35.511p ps=48.245u w=46.725u l=1u
X2746 BAT GATE DVDD DVDD pfet_06v0 ad=35.511p pd=48.245u as=43.9215p ps=95.32999u w=46.725u l=1u
X2747 DVDD GATE BAT DVDD pfet_06v0 ad=35.5072p pd=48.24u as=35.5072p ps=48.24u w=46.72u l=1u
X2748 BAT GATE DVDD DVDD pfet_06v0 ad=58.1134p pd=77.985u as=58.1134p ps=77.985u w=76.465u l=1u
X2749 BAT GATE DVDD DVDD pfet_06v0 ad=58.1134p pd=77.985u as=58.1134p ps=77.985u w=76.465u l=1u
X2750 BAT GATE DVDD DVDD pfet_06v0 ad=35.511p pd=48.245u as=43.9215p ps=95.32999u w=46.725u l=1u
X2751 BAT GATE DVDD DVDD pfet_06v0 ad=58.1552p pd=78.04u as=71.92879p ps=0.15492m w=76.52u l=1u
X2752 DVDD GATE BAT DVDD pfet_06v0 ad=47.6862p pd=64.265u as=47.6862p ps=64.265u w=62.745u l=1u
X2753 BAT GATE DVDD DVDD pfet_06v0 ad=58.1134p pd=77.985u as=58.1134p ps=77.985u w=76.465u l=1u
X2754 BAT GATE DVDD DVDD pfet_06v0 ad=49.3848p pd=66.5u as=49.3848p ps=66.5u w=64.98u l=1u
X2755 DVDD GATE BAT DVDD pfet_06v0 ad=43.9215p pd=95.32999u as=35.511p ps=48.245u w=46.725u l=1u
X2756 DVDD GATE BAT DVDD pfet_06v0 ad=58.1134p pd=77.985u as=58.1134p ps=77.985u w=76.465u l=1u
X2757 BAT GATE DVDD DVDD pfet_06v0 ad=58.1134p pd=77.985u as=58.1134p ps=77.985u w=76.465u l=1u
X2758 BAT GATE DVDD DVDD pfet_06v0 ad=49.3848p pd=66.5u as=49.3848p ps=66.5u w=64.98u l=1u
X2759 BAT GATE DVDD DVDD pfet_06v0 ad=58.0754p pd=77.935u as=58.0754p ps=77.935u w=76.41499u l=1u
X2760 DVDD GATE BAT DVDD pfet_06v0 ad=47.6862p pd=64.265u as=47.6862p ps=64.265u w=62.745u l=1u
X2761 DVDD GATE BAT DVDD pfet_06v0 ad=47.6862p pd=64.265u as=47.6862p ps=64.265u w=62.745u l=1u
X2762 BAT GATE DVDD DVDD pfet_06v0 ad=35.511p pd=48.245u as=43.9215p ps=95.32999u w=46.725u l=1u
X2763 DVDD GATE BAT DVDD pfet_06v0 ad=58.1134p pd=77.985u as=58.1134p ps=77.985u w=76.465u l=1u
X2764 BAT GATE DVDD DVDD pfet_06v0 ad=35.511p pd=48.245u as=35.511p ps=48.245u w=46.725u l=1u
X2765 DVDD GATE BAT DVDD pfet_06v0 ad=58.1134p pd=77.985u as=58.1134p ps=77.985u w=76.465u l=1u
X2766 DVDD GATE BAT DVDD pfet_06v0 ad=43.9215p pd=95.32999u as=35.511p ps=48.245u w=46.725u l=1u
X2767 DVDD GATE BAT DVDD pfet_06v0 ad=43.9215p pd=95.32999u as=35.511p ps=48.245u w=46.725u l=1u
X2768 DVDD GATE BAT DVDD pfet_06v0 ad=58.1134p pd=77.985u as=58.1134p ps=77.985u w=76.465u l=1u
X2769 BAT GATE DVDD DVDD pfet_06v0 ad=58.1172p pd=77.99u as=58.1172p ps=77.99u w=76.47u l=1u
X2770 DVDD GATE BAT DVDD pfet_06v0 ad=35.511p pd=48.245u as=35.511p ps=48.245u w=46.725u l=1u
X2771 BAT GATE DVDD DVDD pfet_06v0 ad=58.1134p pd=77.985u as=58.1134p ps=77.985u w=76.465u l=1u
X2772 BAT GATE DVDD DVDD pfet_06v0 ad=58.1134p pd=77.985u as=58.1134p ps=77.985u w=76.465u l=1u
X2773 DVDD GATE BAT DVDD pfet_06v0 ad=49.3848p pd=66.5u as=49.3848p ps=66.5u w=64.98u l=1u
X2774 DVDD GATE BAT DVDD pfet_06v0 ad=47.6862p pd=64.265u as=47.6862p ps=64.265u w=62.745u l=1u
X2775 DVDD GATE BAT DVDD pfet_06v0 ad=58.1172p pd=77.99u as=58.1172p ps=77.99u w=76.47u l=1u
X2776 BAT GATE DVDD DVDD pfet_06v0 ad=35.511p pd=48.245u as=35.511p ps=48.245u w=46.725u l=1u
X2777 DVDD GATE BAT DVDD pfet_06v0 ad=35.511p pd=48.245u as=35.511p ps=48.245u w=46.725u l=1u
X2778 DVDD GATE BAT DVDD pfet_06v0 ad=35.5072p pd=48.24u as=35.5072p ps=48.24u w=46.72u l=1u
X2779 DVDD GATE BAT DVDD pfet_06v0 ad=35.511p pd=48.245u as=35.511p ps=48.245u w=46.725u l=1u
X2780 DVDD GATE BAT DVDD pfet_06v0 ad=35.511p pd=48.245u as=35.511p ps=48.245u w=46.725u l=1u
X2781 DVDD GATE BAT DVDD pfet_06v0 ad=58.1134p pd=77.985u as=58.1134p ps=77.985u w=76.465u l=1u
X2782 DVDD GATE BAT DVDD pfet_06v0 ad=43.9215p pd=95.32999u as=35.511p ps=48.245u w=46.725u l=1u
X2783 BAT GATE DVDD DVDD pfet_06v0 ad=58.1134p pd=77.985u as=58.1134p ps=77.985u w=76.465u l=1u
X2784 DVDD GATE BAT DVDD pfet_06v0 ad=43.9168p pd=95.32u as=35.5072p ps=48.24u w=46.72u l=1u
X2785 DVDD GATE BAT DVDD pfet_06v0 ad=35.511p pd=48.245u as=35.511p ps=48.245u w=46.725u l=1u
X2786 DVDD GATE BAT DVDD pfet_06v0 ad=58.1134p pd=77.985u as=58.1134p ps=77.985u w=76.465u l=1u
X2787 BAT GATE DVDD DVDD pfet_06v0 ad=58.1134p pd=77.985u as=58.1134p ps=77.985u w=76.465u l=1u
X2788 DVDD GATE BAT DVDD pfet_06v0 ad=71.8771p pd=0.15481m as=58.1134p ps=77.985u w=76.465u l=1u
X2789 DVDD GATE BAT DVDD pfet_06v0 ad=58.1134p pd=77.985u as=58.1134p ps=77.985u w=76.465u l=1u
X2790 BAT GATE DVDD DVDD pfet_06v0 ad=58.0754p pd=77.935u as=58.0754p ps=77.935u w=76.41499u l=1u
X2791 DVDD GATE BAT DVDD pfet_06v0 ad=35.511p pd=48.245u as=35.511p ps=48.245u w=46.725u l=1u
X2792 DVDD GATE BAT DVDD pfet_06v0 ad=71.8771p pd=0.15481m as=58.1134p ps=77.985u w=76.465u l=1u
X2793 BAT GATE DVDD DVDD pfet_06v0 ad=35.511p pd=48.245u as=43.9215p ps=95.32999u w=46.725u l=1u
X2794 BAT GATE DVDD DVDD pfet_06v0 ad=58.1134p pd=77.985u as=58.1134p ps=77.985u w=76.465u l=1u
X2795 DVDD GATE BAT DVDD pfet_06v0 ad=58.1134p pd=77.985u as=58.1134p ps=77.985u w=76.465u l=1u
X2796 DVDD GATE BAT DVDD pfet_06v0 ad=35.511p pd=48.245u as=35.511p ps=48.245u w=46.725u l=1u
X2797 DVDD GATE BAT DVDD pfet_06v0 ad=58.1134p pd=77.985u as=58.1134p ps=77.985u w=76.465u l=1u
X2798 BAT GATE DVDD DVDD pfet_06v0 ad=58.1134p pd=77.985u as=58.1134p ps=77.985u w=76.465u l=1u
X2799 DVDD GATE BAT DVDD pfet_06v0 ad=35.511p pd=48.245u as=35.511p ps=48.245u w=46.725u l=1u
X2800 DVDD GATE BAT DVDD pfet_06v0 ad=35.511p pd=48.245u as=35.511p ps=48.245u w=46.725u l=1u
X2801 DVDD GATE BAT DVDD pfet_06v0 ad=35.511p pd=48.245u as=35.511p ps=48.245u w=46.725u l=1u
X2802 BAT GATE DVDD DVDD pfet_06v0 ad=35.511p pd=48.245u as=35.511p ps=48.245u w=46.725u l=1u
X2803 DVDD GATE BAT DVDD pfet_06v0 ad=71.8771p pd=0.15481m as=58.1134p ps=77.985u w=76.465u l=1u
X2804 DVDD GATE BAT DVDD pfet_06v0 ad=35.511p pd=48.245u as=35.511p ps=48.245u w=46.725u l=1u
X2805 BAT GATE DVDD DVDD pfet_06v0 ad=58.1134p pd=77.985u as=58.1134p ps=77.985u w=76.465u l=1u
X2806 BAT GATE DVDD DVDD pfet_06v0 ad=35.511p pd=48.245u as=35.511p ps=48.245u w=46.725u l=1u
X2807 BAT GATE DVDD DVDD pfet_06v0 ad=58.1134p pd=77.985u as=58.1134p ps=77.985u w=76.465u l=1u
X2808 BAT GATE DVDD DVDD pfet_06v0 ad=58.1172p pd=77.99u as=58.1172p ps=77.99u w=76.47u l=1u
X2809 DVDD GATE BAT DVDD pfet_06v0 ad=35.511p pd=48.245u as=35.511p ps=48.245u w=46.725u l=1u
X2810 DVDD GATE BAT DVDD pfet_06v0 ad=58.1134p pd=77.985u as=58.1134p ps=77.985u w=76.465u l=1u
X2811 DVDD GATE BAT DVDD pfet_06v0 ad=58.1552p pd=78.04u as=58.1552p ps=78.04u w=76.52u l=1u
X2812 BAT GATE DVDD DVDD pfet_06v0 ad=35.511p pd=48.245u as=43.9215p ps=95.32999u w=46.725u l=1u
X2813 DVDD GATE BAT DVDD pfet_06v0 ad=58.1134p pd=77.985u as=58.1134p ps=77.985u w=76.465u l=1u
X2814 DVDD GATE BAT DVDD pfet_06v0 ad=61.0812p pd=0.13184m as=49.3848p ps=66.5u w=64.98u l=1u
X2815 DVDD GATE BAT DVDD pfet_06v0 ad=43.9215p pd=95.32999u as=35.511p ps=48.245u w=46.725u l=1u
X2816 BAT GATE DVDD DVDD pfet_06v0 ad=35.511p pd=48.245u as=35.511p ps=48.245u w=46.725u l=1u
X2817 BAT GATE DVDD DVDD pfet_06v0 ad=58.1134p pd=77.985u as=58.1134p ps=77.985u w=76.465u l=1u
X2818 BAT GATE DVDD DVDD pfet_06v0 ad=58.1134p pd=77.985u as=58.1134p ps=77.985u w=76.465u l=1u
X2819 DVDD GATE BAT DVDD pfet_06v0 ad=58.1134p pd=77.985u as=58.1134p ps=77.985u w=76.465u l=1u
X2820 BAT GATE DVDD DVDD pfet_06v0 ad=35.511p pd=48.245u as=35.511p ps=48.245u w=46.725u l=1u
X2821 DVDD GATE BAT DVDD pfet_06v0 ad=49.3848p pd=66.5u as=49.3848p ps=66.5u w=64.98u l=1u
X2822 BAT GATE DVDD DVDD pfet_06v0 ad=58.1134p pd=77.985u as=58.1134p ps=77.985u w=76.465u l=1u
X2823 BAT GATE DVDD DVDD pfet_06v0 ad=47.6862p pd=64.265u as=58.9803p ps=0.12737m w=62.745u l=1u
X2824 BAT GATE DVDD DVDD pfet_06v0 ad=35.511p pd=48.245u as=35.511p ps=48.245u w=46.725u l=1u
X2825 BAT GATE DVDD DVDD pfet_06v0 ad=35.511p pd=48.245u as=43.9215p ps=95.32999u w=46.725u l=1u
X2826 DVDD GATE BAT DVDD pfet_06v0 ad=43.9215p pd=95.32999u as=35.511p ps=48.245u w=46.725u l=1u
X2827 DVDD GATE BAT DVDD pfet_06v0 ad=71.8301p pd=0.15471m as=58.0754p ps=77.935u w=76.41499u l=1u
X2828 BAT GATE DVDD DVDD pfet_06v0 ad=58.1096p pd=77.98u as=58.1096p ps=77.98u w=76.46u l=1u
X2829 BAT GATE DVDD DVDD pfet_06v0 ad=35.511p pd=48.245u as=35.511p ps=48.245u w=46.725u l=1u
X2830 BAT GATE DVDD DVDD pfet_06v0 ad=35.511p pd=48.245u as=35.511p ps=48.245u w=46.725u l=1u
X2831 DVDD GATE BAT DVDD pfet_06v0 ad=71.8771p pd=0.15481m as=58.1134p ps=77.985u w=76.465u l=1u
X2832 DVDD GATE BAT DVDD pfet_06v0 ad=58.1096p pd=77.98u as=58.1096p ps=77.98u w=76.46u l=1u
X2833 BAT GATE DVDD DVDD pfet_06v0 ad=49.3848p pd=66.5u as=49.3848p ps=66.5u w=64.98u l=1u
X2834 DVDD GATE BAT DVDD pfet_06v0 ad=35.511p pd=48.245u as=35.511p ps=48.245u w=46.725u l=1u
X2835 DVDD GATE BAT DVDD pfet_06v0 ad=35.511p pd=48.245u as=35.511p ps=48.245u w=46.725u l=1u
X2836 BAT GATE DVDD DVDD pfet_06v0 ad=58.1172p pd=77.99u as=58.1172p ps=77.99u w=76.47u l=1u
X2837 DVDD GATE BAT DVDD pfet_06v0 ad=35.511p pd=48.245u as=35.511p ps=48.245u w=46.725u l=1u
X2838 BAT GATE DVDD DVDD pfet_06v0 ad=35.511p pd=48.245u as=35.511p ps=48.245u w=46.725u l=1u
X2839 DVDD GATE BAT DVDD pfet_06v0 ad=49.3848p pd=66.5u as=49.3848p ps=66.5u w=64.98u l=1u
X2840 BAT GATE DVDD DVDD pfet_06v0 ad=58.1134p pd=77.985u as=58.1134p ps=77.985u w=76.465u l=1u
X2841 DVDD GATE BAT DVDD pfet_06v0 ad=58.9803p pd=0.12737m as=47.6862p ps=64.265u w=62.745u l=1u
X2842 DVDD GATE BAT DVDD pfet_06v0 ad=58.1134p pd=77.985u as=58.1134p ps=77.985u w=76.465u l=1u
X2843 BAT GATE DVDD DVDD pfet_06v0 ad=35.5072p pd=48.24u as=35.5072p ps=48.24u w=46.72u l=1u
X2844 BAT GATE DVDD DVDD pfet_06v0 ad=58.1134p pd=77.985u as=71.8771p ps=0.15481m w=76.465u l=1u
X2845 DVDD GATE BAT DVDD pfet_06v0 ad=58.1134p pd=77.985u as=58.1134p ps=77.985u w=76.465u l=1u
X2846 DVDD GATE BAT DVDD pfet_06v0 ad=43.9168p pd=95.32u as=35.5072p ps=48.24u w=46.72u l=1u
X2847 DVDD GATE BAT DVDD pfet_06v0 ad=35.511p pd=48.245u as=35.511p ps=48.245u w=46.725u l=1u
X2848 DVDD GATE BAT DVDD pfet_06v0 ad=35.511p pd=48.245u as=35.511p ps=48.245u w=46.725u l=1u
X2849 DVDD GATE BAT DVDD pfet_06v0 ad=35.511p pd=48.245u as=35.511p ps=48.245u w=46.725u l=1u
X2850 BAT GATE DVDD DVDD pfet_06v0 ad=58.1134p pd=77.985u as=58.1134p ps=77.985u w=76.465u l=1u
X2851 DVDD GATE BAT DVDD pfet_06v0 ad=35.5072p pd=48.24u as=35.5072p ps=48.24u w=46.72u l=1u
X2852 DVDD GATE BAT DVDD pfet_06v0 ad=58.0754p pd=77.935u as=58.0754p ps=77.935u w=76.41499u l=1u
X2853 DVDD GATE BAT DVDD pfet_06v0 ad=35.511p pd=48.245u as=35.511p ps=48.245u w=46.725u l=1u
X2854 BAT GATE DVDD DVDD pfet_06v0 ad=47.6862p pd=64.265u as=58.9803p ps=0.12737m w=62.745u l=1u
X2855 DVDD GATE BAT DVDD pfet_06v0 ad=58.1134p pd=77.985u as=58.1134p ps=77.985u w=76.465u l=1u
X2856 BAT GATE DVDD DVDD pfet_06v0 ad=35.511p pd=48.245u as=43.9215p ps=95.32999u w=46.725u l=1u
X2857 BAT GATE DVDD DVDD pfet_06v0 ad=35.511p pd=48.245u as=35.511p ps=48.245u w=46.725u l=1u
X2858 DVDD GATE BAT DVDD pfet_06v0 ad=71.8301p pd=0.15471m as=58.0754p ps=77.935u w=76.41499u l=1u
X2859 DVDD GATE BAT DVDD pfet_06v0 ad=47.6862p pd=64.265u as=47.6862p ps=64.265u w=62.745u l=1u
X2860 BAT GATE DVDD DVDD pfet_06v0 ad=47.6862p pd=64.265u as=47.6862p ps=64.265u w=62.745u l=1u
X2861 BAT GATE DVDD DVDD pfet_06v0 ad=47.6862p pd=64.265u as=47.6862p ps=64.265u w=62.745u l=1u
X2862 BAT GATE DVDD DVDD pfet_06v0 ad=58.1134p pd=77.985u as=71.8771p ps=0.15481m w=76.465u l=1u
X2863 BAT GATE DVDD DVDD pfet_06v0 ad=58.1096p pd=77.98u as=58.1096p ps=77.98u w=76.46u l=1u
X2864 DVDD GATE BAT DVDD pfet_06v0 ad=43.9168p pd=95.32u as=35.5072p ps=48.24u w=46.72u l=1u
X2865 DVDD GATE BAT DVDD pfet_06v0 ad=58.1134p pd=77.985u as=58.1134p ps=77.985u w=76.465u l=1u
X2866 BAT GATE DVDD DVDD pfet_06v0 ad=35.511p pd=48.245u as=35.511p ps=48.245u w=46.725u l=1u
X2867 BAT GATE DVDD DVDD pfet_06v0 ad=35.511p pd=48.245u as=35.511p ps=48.245u w=46.725u l=1u
X2868 BAT GATE DVDD DVDD pfet_06v0 ad=58.1134p pd=77.985u as=58.1134p ps=77.985u w=76.465u l=1u
X2869 BAT GATE DVDD DVDD pfet_06v0 ad=35.5072p pd=48.24u as=35.5072p ps=48.24u w=46.72u l=1u
X2870 DVDD GATE BAT DVDD pfet_06v0 ad=58.1134p pd=77.985u as=58.1134p ps=77.985u w=76.465u l=1u
X2871 DVDD GATE BAT DVDD pfet_06v0 ad=47.6862p pd=64.265u as=47.6862p ps=64.265u w=62.745u l=1u
X2872 DVDD GATE BAT DVDD pfet_06v0 ad=58.1134p pd=77.985u as=58.1134p ps=77.985u w=76.465u l=1u
X2873 BAT GATE DVDD DVDD pfet_06v0 ad=49.3848p pd=66.5u as=49.3848p ps=66.5u w=64.98u l=1u
X2874 DVDD GATE BAT DVDD pfet_06v0 ad=35.511p pd=48.245u as=35.511p ps=48.245u w=46.725u l=1u
X2875 DVDD GATE BAT DVDD pfet_06v0 ad=43.9215p pd=95.32999u as=35.511p ps=48.245u w=46.725u l=1u
X2876 BAT GATE DVDD DVDD pfet_06v0 ad=35.511p pd=48.245u as=35.511p ps=48.245u w=46.725u l=1u
X2877 DVDD GATE BAT DVDD pfet_06v0 ad=58.1134p pd=77.985u as=58.1134p ps=77.985u w=76.465u l=1u
X2878 BAT GATE DVDD DVDD pfet_06v0 ad=58.1172p pd=77.99u as=58.1172p ps=77.99u w=76.47u l=1u
X2879 DVDD GATE BAT DVDD pfet_06v0 ad=58.1552p pd=78.04u as=58.1552p ps=78.04u w=76.52u l=1u
X2880 BAT GATE DVDD DVDD pfet_06v0 ad=35.511p pd=48.245u as=35.511p ps=48.245u w=46.725u l=1u
X2881 DVDD GATE BAT DVDD pfet_06v0 ad=35.511p pd=48.245u as=35.511p ps=48.245u w=46.725u l=1u
X2882 BAT GATE DVDD DVDD pfet_06v0 ad=35.5072p pd=48.24u as=35.5072p ps=48.24u w=46.72u l=1u
X2883 DVDD GATE BAT DVDD pfet_06v0 ad=35.511p pd=48.245u as=35.511p ps=48.245u w=46.725u l=1u
X2884 DVDD GATE BAT DVDD pfet_06v0 ad=35.511p pd=48.245u as=35.511p ps=48.245u w=46.725u l=1u
X2885 BAT GATE DVDD DVDD pfet_06v0 ad=35.511p pd=48.245u as=43.9215p ps=95.32999u w=46.725u l=1u
X2886 BAT GATE DVDD DVDD pfet_06v0 ad=35.511p pd=48.245u as=35.511p ps=48.245u w=46.725u l=1u
X2887 DVDD GATE BAT DVDD pfet_06v0 ad=58.1134p pd=77.985u as=58.1134p ps=77.985u w=76.465u l=1u
X2888 DVDD GATE BAT DVDD pfet_06v0 ad=58.1134p pd=77.985u as=58.1134p ps=77.985u w=76.465u l=1u
X2889 BAT GATE DVDD DVDD pfet_06v0 ad=35.511p pd=48.245u as=35.511p ps=48.245u w=46.725u l=1u
X2890 BAT GATE DVDD DVDD pfet_06v0 ad=58.1134p pd=77.985u as=58.1134p ps=77.985u w=76.465u l=1u
X2891 DVDD GATE BAT DVDD pfet_06v0 ad=71.8301p pd=0.15471m as=58.0754p ps=77.935u w=76.41499u l=1u
X2892 DVDD GATE BAT DVDD pfet_06v0 ad=43.9215p pd=95.32999u as=35.511p ps=48.245u w=46.725u l=1u
X2893 BAT GATE DVDD DVDD pfet_06v0 ad=58.1172p pd=77.99u as=58.1172p ps=77.99u w=76.47u l=1u
X2894 DVDD GATE BAT DVDD pfet_06v0 ad=35.511p pd=48.245u as=35.511p ps=48.245u w=46.725u l=1u
X2895 BAT GATE DVDD DVDD pfet_06v0 ad=58.1134p pd=77.985u as=58.1134p ps=77.985u w=76.465u l=1u
X2896 BAT GATE DVDD DVDD pfet_06v0 ad=58.1134p pd=77.985u as=71.8771p ps=0.15481m w=76.465u l=1u
X2897 BAT GATE DVDD DVDD pfet_06v0 ad=35.511p pd=48.245u as=35.511p ps=48.245u w=46.725u l=1u
X2898 DVDD GATE BAT DVDD pfet_06v0 ad=35.511p pd=48.245u as=35.511p ps=48.245u w=46.725u l=1u
X2899 DVDD GATE BAT DVDD pfet_06v0 ad=58.1172p pd=77.99u as=58.1172p ps=77.99u w=76.47u l=1u
X2900 BAT GATE DVDD DVDD pfet_06v0 ad=35.511p pd=48.245u as=35.511p ps=48.245u w=46.725u l=1u
X2901 DVDD GATE BAT DVDD pfet_06v0 ad=58.1134p pd=77.985u as=58.1134p ps=77.985u w=76.465u l=1u
X2902 BAT GATE DVDD DVDD pfet_06v0 ad=58.1096p pd=77.98u as=71.8724p ps=0.1548m w=76.46u l=1u
X2903 DVDD GATE BAT DVDD pfet_06v0 ad=43.9215p pd=95.32999u as=35.511p ps=48.245u w=46.725u l=1u
X2904 BAT GATE DVDD DVDD pfet_06v0 ad=35.511p pd=48.245u as=35.511p ps=48.245u w=46.725u l=1u
X2905 DVDD GATE BAT DVDD pfet_06v0 ad=35.511p pd=48.245u as=35.511p ps=48.245u w=46.725u l=1u
X2906 BAT GATE DVDD DVDD pfet_06v0 ad=35.511p pd=48.245u as=35.511p ps=48.245u w=46.725u l=1u
X2907 BAT GATE DVDD DVDD pfet_06v0 ad=58.1134p pd=77.985u as=71.8771p ps=0.15481m w=76.465u l=1u
X2908 BAT GATE DVDD DVDD pfet_06v0 ad=58.1134p pd=77.985u as=58.1134p ps=77.985u w=76.465u l=1u
X2909 DVDD GATE BAT DVDD pfet_06v0 ad=43.9215p pd=95.32999u as=35.511p ps=48.245u w=46.725u l=1u
X2910 BAT GATE DVDD DVDD pfet_06v0 ad=35.511p pd=48.245u as=35.511p ps=48.245u w=46.725u l=1u
X2911 BAT GATE DVDD DVDD pfet_06v0 ad=35.511p pd=48.245u as=35.511p ps=48.245u w=46.725u l=1u
X2912 DVDD GATE BAT DVDD pfet_06v0 ad=58.1134p pd=77.985u as=58.1134p ps=77.985u w=76.465u l=1u
X2913 DVDD GATE BAT DVDD pfet_06v0 ad=43.9215p pd=95.32999u as=35.511p ps=48.245u w=46.725u l=1u
X2914 DVDD GATE BAT DVDD pfet_06v0 ad=35.511p pd=48.245u as=35.511p ps=48.245u w=46.725u l=1u
X2915 BAT GATE DVDD DVDD pfet_06v0 ad=58.1172p pd=77.99u as=71.8818p ps=0.15482m w=76.47u l=1u
X2916 BAT GATE DVDD DVDD pfet_06v0 ad=49.3848p pd=66.5u as=49.3848p ps=66.5u w=64.98u l=1u
X2917 DVDD GATE BAT DVDD pfet_06v0 ad=35.511p pd=48.245u as=35.511p ps=48.245u w=46.725u l=1u
X2918 BAT GATE DVDD DVDD pfet_06v0 ad=58.1552p pd=78.04u as=58.1552p ps=78.04u w=76.52u l=1u
X2919 DVDD GATE BAT DVDD pfet_06v0 ad=71.8771p pd=0.15481m as=58.1134p ps=77.985u w=76.465u l=1u
X2920 BAT GATE DVDD DVDD pfet_06v0 ad=58.1134p pd=77.985u as=58.1134p ps=77.985u w=76.465u l=1u
X2921 DVDD GATE BAT DVDD pfet_06v0 ad=35.511p pd=48.245u as=35.511p ps=48.245u w=46.725u l=1u
X2922 DVDD GATE BAT DVDD pfet_06v0 ad=47.6862p pd=64.265u as=47.6862p ps=64.265u w=62.745u l=1u
X2923 DVDD GATE BAT DVDD pfet_06v0 ad=35.511p pd=48.245u as=35.511p ps=48.245u w=46.725u l=1u
X2924 BAT GATE DVDD DVDD pfet_06v0 ad=35.511p pd=48.245u as=35.511p ps=48.245u w=46.725u l=1u
X2925 DVDD GATE BAT DVDD pfet_06v0 ad=47.6862p pd=64.265u as=47.6862p ps=64.265u w=62.745u l=1u
X2926 BAT GATE DVDD DVDD pfet_06v0 ad=58.1134p pd=77.985u as=58.1134p ps=77.985u w=76.465u l=1u
X2927 DVDD GATE BAT DVDD pfet_06v0 ad=58.1134p pd=77.985u as=58.1134p ps=77.985u w=76.465u l=1u
X2928 BAT GATE DVDD DVDD pfet_06v0 ad=58.1134p pd=77.985u as=71.8771p ps=0.15481m w=76.465u l=1u
X2929 DVDD GATE BAT DVDD pfet_06v0 ad=58.1096p pd=77.98u as=58.1096p ps=77.98u w=76.46u l=1u
X2930 BAT GATE DVDD DVDD pfet_06v0 ad=58.1134p pd=77.985u as=58.1134p ps=77.985u w=76.465u l=1u
X2931 BAT GATE DVDD DVDD pfet_06v0 ad=58.1552p pd=78.04u as=58.1552p ps=78.04u w=76.52u l=1u
X2932 BAT GATE DVDD DVDD pfet_06v0 ad=58.1172p pd=77.99u as=58.1172p ps=77.99u w=76.47u l=1u
X2933 DVDD GATE BAT DVDD pfet_06v0 ad=35.511p pd=48.245u as=35.511p ps=48.245u w=46.725u l=1u
X2934 BAT GATE DVDD DVDD pfet_06v0 ad=35.511p pd=48.245u as=35.511p ps=48.245u w=46.725u l=1u
X2935 BAT GATE DVDD DVDD pfet_06v0 ad=58.1134p pd=77.985u as=58.1134p ps=77.985u w=76.465u l=1u
X2936 BAT GATE DVDD DVDD pfet_06v0 ad=58.1134p pd=77.985u as=58.1134p ps=77.985u w=76.465u l=1u
X2937 DVDD GATE BAT DVDD pfet_06v0 ad=71.8771p pd=0.15481m as=58.1134p ps=77.985u w=76.465u l=1u
X2938 BAT GATE DVDD DVDD pfet_06v0 ad=58.1134p pd=77.985u as=58.1134p ps=77.985u w=76.465u l=1u
X2939 DVDD GATE BAT DVDD pfet_06v0 ad=49.3848p pd=66.5u as=49.3848p ps=66.5u w=64.98u l=1u
X2940 BAT GATE DVDD DVDD pfet_06v0 ad=35.511p pd=48.245u as=43.9215p ps=95.32999u w=46.725u l=1u
X2941 BAT GATE DVDD DVDD pfet_06v0 ad=58.1134p pd=77.985u as=58.1134p ps=77.985u w=76.465u l=1u
X2942 DVDD GATE BAT DVDD pfet_06v0 ad=49.3848p pd=66.5u as=49.3848p ps=66.5u w=64.98u l=1u
X2943 BAT GATE DVDD DVDD pfet_06v0 ad=49.3848p pd=66.5u as=61.0812p ps=0.13184m w=64.98u l=1u
X2944 BAT GATE DVDD DVDD pfet_06v0 ad=35.511p pd=48.245u as=43.9215p ps=95.32999u w=46.725u l=1u
X2945 DVDD GATE BAT DVDD pfet_06v0 ad=35.511p pd=48.245u as=35.511p ps=48.245u w=46.725u l=1u
X2946 BAT GATE DVDD DVDD pfet_06v0 ad=58.1552p pd=78.04u as=58.1552p ps=78.04u w=76.52u l=1u
X2947 DVDD GATE BAT DVDD pfet_06v0 ad=58.1134p pd=77.985u as=58.1134p ps=77.985u w=76.465u l=1u
X2948 BAT GATE DVDD DVDD pfet_06v0 ad=35.511p pd=48.245u as=35.511p ps=48.245u w=46.725u l=1u
X2949 BAT GATE DVDD DVDD pfet_06v0 ad=35.511p pd=48.245u as=35.511p ps=48.245u w=46.725u l=1u
X2950 BAT GATE DVDD DVDD pfet_06v0 ad=35.511p pd=48.245u as=35.511p ps=48.245u w=46.725u l=1u
X2951 DVDD GATE BAT DVDD pfet_06v0 ad=58.1134p pd=77.985u as=58.1134p ps=77.985u w=76.465u l=1u
X2952 DVDD GATE BAT DVDD pfet_06v0 ad=35.511p pd=48.245u as=35.511p ps=48.245u w=46.725u l=1u
X2953 BAT GATE DVDD DVDD pfet_06v0 ad=35.5072p pd=48.24u as=35.5072p ps=48.24u w=46.72u l=1u
X2954 DVDD GATE BAT DVDD pfet_06v0 ad=35.511p pd=48.245u as=35.511p ps=48.245u w=46.725u l=1u
X2955 DVDD GATE BAT DVDD pfet_06v0 ad=35.511p pd=48.245u as=35.511p ps=48.245u w=46.725u l=1u
X2956 BAT GATE DVDD DVDD pfet_06v0 ad=35.511p pd=48.245u as=35.511p ps=48.245u w=46.725u l=1u
X2957 BAT GATE DVDD DVDD pfet_06v0 ad=58.1134p pd=77.985u as=58.1134p ps=77.985u w=76.465u l=1u
X2958 BAT GATE DVDD DVDD pfet_06v0 ad=35.5072p pd=48.24u as=43.9168p ps=95.32u w=46.72u l=1u
X2959 DVDD GATE BAT DVDD pfet_06v0 ad=58.1096p pd=77.98u as=58.1096p ps=77.98u w=76.46u l=1u
X2960 DVDD GATE BAT DVDD pfet_06v0 ad=47.6862p pd=64.265u as=47.6862p ps=64.265u w=62.745u l=1u
X2961 DVDD GATE BAT DVDD pfet_06v0 ad=58.1134p pd=77.985u as=58.1134p ps=77.985u w=76.465u l=1u
X2962 DVDD GATE BAT DVDD pfet_06v0 ad=43.9215p pd=95.32999u as=35.511p ps=48.245u w=46.725u l=1u
X2963 BAT GATE DVDD DVDD pfet_06v0 ad=58.1134p pd=77.985u as=58.1134p ps=77.985u w=76.465u l=1u
X2964 BAT GATE DVDD DVDD pfet_06v0 ad=58.1134p pd=77.985u as=58.1134p ps=77.985u w=76.465u l=1u
X2965 BAT GATE DVDD DVDD pfet_06v0 ad=58.1134p pd=77.985u as=58.1134p ps=77.985u w=76.465u l=1u
X2966 DVDD GATE BAT DVDD pfet_06v0 ad=71.8724p pd=0.1548m as=58.1096p ps=77.98u w=76.46u l=1u
X2967 BAT GATE DVDD DVDD pfet_06v0 ad=35.511p pd=48.245u as=35.511p ps=48.245u w=46.725u l=1u
X2968 DVDD GATE BAT DVDD pfet_06v0 ad=35.511p pd=48.245u as=35.511p ps=48.245u w=46.725u l=1u
X2969 DVDD GATE BAT DVDD pfet_06v0 ad=71.8771p pd=0.15481m as=58.1134p ps=77.985u w=76.465u l=1u
X2970 BAT GATE DVDD DVDD pfet_06v0 ad=58.1134p pd=77.985u as=58.1134p ps=77.985u w=76.465u l=1u
X2971 BAT GATE DVDD DVDD pfet_06v0 ad=47.6862p pd=64.265u as=47.6862p ps=64.265u w=62.745u l=1u
X2972 DVDD GATE BAT DVDD pfet_06v0 ad=43.9215p pd=95.32999u as=35.511p ps=48.245u w=46.725u l=1u
X2973 DVDD GATE BAT DVDD pfet_06v0 ad=58.0754p pd=77.935u as=58.0754p ps=77.935u w=76.41499u l=1u
X2974 BAT GATE DVDD DVDD pfet_06v0 ad=58.1134p pd=77.985u as=58.1134p ps=77.985u w=76.465u l=1u
X2975 DVDD GATE BAT DVDD pfet_06v0 ad=71.8301p pd=0.15471m as=58.0754p ps=77.935u w=76.41499u l=1u
X2976 BAT GATE DVDD DVDD pfet_06v0 ad=35.511p pd=48.245u as=35.511p ps=48.245u w=46.725u l=1u
X2977 BAT GATE DVDD DVDD pfet_06v0 ad=58.1134p pd=77.985u as=58.1134p ps=77.985u w=76.465u l=1u
X2978 DVDD GATE BAT DVDD pfet_06v0 ad=58.1134p pd=77.985u as=58.1134p ps=77.985u w=76.465u l=1u
X2979 BAT GATE DVDD DVDD pfet_06v0 ad=35.511p pd=48.245u as=35.511p ps=48.245u w=46.725u l=1u
X2980 DVDD GATE BAT DVDD pfet_06v0 ad=35.511p pd=48.245u as=35.511p ps=48.245u w=46.725u l=1u
X2981 BAT GATE DVDD DVDD pfet_06v0 ad=58.1172p pd=77.99u as=58.1172p ps=77.99u w=76.47u l=1u
X2982 BAT GATE DVDD DVDD pfet_06v0 ad=47.6862p pd=64.265u as=47.6862p ps=64.265u w=62.745u l=1u
X2983 BAT GATE DVDD DVDD pfet_06v0 ad=35.511p pd=48.245u as=35.511p ps=48.245u w=46.725u l=1u
X2984 DVDD GATE BAT DVDD pfet_06v0 ad=35.511p pd=48.245u as=35.511p ps=48.245u w=46.725u l=1u
X2985 BAT GATE DVDD DVDD pfet_06v0 ad=35.511p pd=48.245u as=35.511p ps=48.245u w=46.725u l=1u
X2986 BAT GATE DVDD DVDD pfet_06v0 ad=35.5072p pd=48.24u as=43.9168p ps=95.32u w=46.72u l=1u
X2987 DVDD GATE BAT DVDD pfet_06v0 ad=58.1172p pd=77.99u as=58.1172p ps=77.99u w=76.47u l=1u
X2988 BAT GATE DVDD DVDD pfet_06v0 ad=35.511p pd=48.245u as=35.511p ps=48.245u w=46.725u l=1u
X2989 DVDD GATE BAT DVDD pfet_06v0 ad=71.8771p pd=0.15481m as=58.1134p ps=77.985u w=76.465u l=1u
X2990 BAT GATE DVDD DVDD pfet_06v0 ad=58.1134p pd=77.985u as=58.1134p ps=77.985u w=76.465u l=1u
X2991 DVDD GATE BAT DVDD pfet_06v0 ad=58.1134p pd=77.985u as=58.1134p ps=77.985u w=76.465u l=1u
X2992 DVDD GATE BAT DVDD pfet_06v0 ad=35.511p pd=48.245u as=35.511p ps=48.245u w=46.725u l=1u
X2993 DVDD GATE BAT DVDD pfet_06v0 ad=71.8818p pd=0.15482m as=58.1172p ps=77.99u w=76.47u l=1u
X2994 DVDD GATE BAT DVDD pfet_06v0 ad=35.511p pd=48.245u as=35.511p ps=48.245u w=46.725u l=1u
X2995 DVDD GATE BAT DVDD pfet_06v0 ad=58.1552p pd=78.04u as=58.1552p ps=78.04u w=76.52u l=1u
X2996 DVDD GATE BAT DVDD pfet_06v0 ad=58.1134p pd=77.985u as=58.1134p ps=77.985u w=76.465u l=1u
X2997 BAT GATE DVDD DVDD pfet_06v0 ad=35.511p pd=48.245u as=35.511p ps=48.245u w=46.725u l=1u
X2998 BAT GATE DVDD DVDD pfet_06v0 ad=58.1134p pd=77.985u as=58.1134p ps=77.985u w=76.465u l=1u
X2999 BAT GATE DVDD DVDD pfet_06v0 ad=58.1172p pd=77.99u as=58.1172p ps=77.99u w=76.47u l=1u
X3000 BAT GATE DVDD DVDD pfet_06v0 ad=58.1134p pd=77.985u as=58.1134p ps=77.985u w=76.465u l=1u
X3001 DVDD GATE BAT DVDD pfet_06v0 ad=35.511p pd=48.245u as=35.511p ps=48.245u w=46.725u l=1u
X3002 BAT GATE DVDD DVDD pfet_06v0 ad=58.1134p pd=77.985u as=58.1134p ps=77.985u w=76.465u l=1u
X3003 DVDD GATE BAT DVDD pfet_06v0 ad=35.511p pd=48.245u as=35.511p ps=48.245u w=46.725u l=1u
X3004 BAT GATE DVDD DVDD pfet_06v0 ad=35.511p pd=48.245u as=35.511p ps=48.245u w=46.725u l=1u
X3005 DVDD GATE BAT DVDD pfet_06v0 ad=58.1134p pd=77.985u as=58.1134p ps=77.985u w=76.465u l=1u
X3006 DVDD GATE BAT DVDD pfet_06v0 ad=35.511p pd=48.245u as=35.511p ps=48.245u w=46.725u l=1u
X3007 BAT GATE DVDD DVDD pfet_06v0 ad=58.1134p pd=77.985u as=58.1134p ps=77.985u w=76.465u l=1u
X3008 BAT GATE DVDD DVDD pfet_06v0 ad=35.511p pd=48.245u as=35.511p ps=48.245u w=46.725u l=1u
X3009 BAT GATE DVDD DVDD pfet_06v0 ad=35.511p pd=48.245u as=35.511p ps=48.245u w=46.725u l=1u
X3010 BAT GATE DVDD DVDD pfet_06v0 ad=58.1134p pd=77.985u as=58.1134p ps=77.985u w=76.465u l=1u
X3011 BAT GATE DVDD DVDD pfet_06v0 ad=35.511p pd=48.245u as=35.511p ps=48.245u w=46.725u l=1u
X3012 DVDD GATE BAT DVDD pfet_06v0 ad=58.1172p pd=77.99u as=58.1172p ps=77.99u w=76.47u l=1u
X3013 BAT GATE DVDD DVDD pfet_06v0 ad=35.511p pd=48.245u as=35.511p ps=48.245u w=46.725u l=1u
X3014 DVDD GATE BAT DVDD pfet_06v0 ad=58.1552p pd=78.04u as=58.1552p ps=78.04u w=76.52u l=1u
X3015 BAT GATE DVDD DVDD pfet_06v0 ad=58.1134p pd=77.985u as=58.1134p ps=77.985u w=76.465u l=1u
X3016 BAT GATE DVDD DVDD pfet_06v0 ad=58.1134p pd=77.985u as=58.1134p ps=77.985u w=76.465u l=1u
X3017 DVDD GATE BAT DVDD pfet_06v0 ad=58.1134p pd=77.985u as=58.1134p ps=77.985u w=76.465u l=1u
X3018 DVDD GATE BAT DVDD pfet_06v0 ad=35.511p pd=48.245u as=35.511p ps=48.245u w=46.725u l=1u
X3019 BAT GATE DVDD DVDD pfet_06v0 ad=35.511p pd=48.245u as=35.511p ps=48.245u w=46.725u l=1u
X3020 DVDD GATE BAT DVDD pfet_06v0 ad=35.511p pd=48.245u as=35.511p ps=48.245u w=46.725u l=1u
X3021 DVDD GATE BAT DVDD pfet_06v0 ad=43.9215p pd=95.32999u as=35.511p ps=48.245u w=46.725u l=1u
X3022 DVDD GATE BAT DVDD pfet_06v0 ad=58.1134p pd=77.985u as=58.1134p ps=77.985u w=76.465u l=1u
X3023 DVDD GATE BAT DVDD pfet_06v0 ad=43.9215p pd=95.32999u as=35.511p ps=48.245u w=46.725u l=1u
X3024 DVDD GATE BAT DVDD pfet_06v0 ad=58.1172p pd=77.99u as=58.1172p ps=77.99u w=76.47u l=1u
X3025 DVDD GATE BAT DVDD pfet_06v0 ad=35.5072p pd=48.24u as=35.5072p ps=48.24u w=46.72u l=1u
X3026 BAT GATE DVDD DVDD pfet_06v0 ad=58.1134p pd=77.985u as=71.8771p ps=0.15481m w=76.465u l=1u
X3027 DVDD GATE BAT DVDD pfet_06v0 ad=35.511p pd=48.245u as=35.511p ps=48.245u w=46.725u l=1u
X3028 BAT GATE DVDD DVDD pfet_06v0 ad=35.511p pd=48.245u as=43.9215p ps=95.32999u w=46.725u l=1u
X3029 BAT GATE DVDD DVDD pfet_06v0 ad=58.1096p pd=77.98u as=58.1096p ps=77.98u w=76.46u l=1u
X3030 DVDD GATE BAT DVDD pfet_06v0 ad=58.9803p pd=0.12737m as=47.6862p ps=64.265u w=62.745u l=1u
X3031 BAT GATE DVDD DVDD pfet_06v0 ad=35.511p pd=48.245u as=35.511p ps=48.245u w=46.725u l=1u
X3032 DVDD GATE BAT DVDD pfet_06v0 ad=58.1134p pd=77.985u as=58.1134p ps=77.985u w=76.465u l=1u
X3033 DVDD GATE BAT DVDD pfet_06v0 ad=58.1552p pd=78.04u as=58.1552p ps=78.04u w=76.52u l=1u
X3034 BAT GATE DVDD DVDD pfet_06v0 ad=35.511p pd=48.245u as=35.511p ps=48.245u w=46.725u l=1u
X3035 DVDD GATE BAT DVDD pfet_06v0 ad=58.1134p pd=77.985u as=58.1134p ps=77.985u w=76.465u l=1u
X3036 DVDD GATE BAT DVDD pfet_06v0 ad=58.1134p pd=77.985u as=58.1134p ps=77.985u w=76.465u l=1u
X3037 BAT GATE DVDD DVDD pfet_06v0 ad=35.511p pd=48.245u as=43.9215p ps=95.32999u w=46.725u l=1u
X3038 DVDD GATE BAT DVDD pfet_06v0 ad=71.8724p pd=0.1548m as=58.1096p ps=77.98u w=76.46u l=1u
X3039 DVDD GATE BAT DVDD pfet_06v0 ad=58.1134p pd=77.985u as=58.1134p ps=77.985u w=76.465u l=1u
X3040 DVDD GATE BAT DVDD pfet_06v0 ad=43.9215p pd=95.32999u as=35.511p ps=48.245u w=46.725u l=1u
X3041 BAT GATE DVDD DVDD pfet_06v0 ad=49.3848p pd=66.5u as=49.3848p ps=66.5u w=64.98u l=1u
X3042 DVDD GATE BAT DVDD pfet_06v0 ad=58.1134p pd=77.985u as=58.1134p ps=77.985u w=76.465u l=1u
X3043 DVDD GATE BAT DVDD pfet_06v0 ad=58.1096p pd=77.98u as=58.1096p ps=77.98u w=76.46u l=1u
X3044 BAT GATE DVDD DVDD pfet_06v0 ad=58.1134p pd=77.985u as=71.8771p ps=0.15481m w=76.465u l=1u
X3045 DVDD GATE BAT DVDD pfet_06v0 ad=58.1552p pd=78.04u as=58.1552p ps=78.04u w=76.52u l=1u
X3046 DVDD GATE BAT DVDD pfet_06v0 ad=35.511p pd=48.245u as=35.511p ps=48.245u w=46.725u l=1u
X3047 DVDD GATE BAT DVDD pfet_06v0 ad=58.9803p pd=0.12737m as=47.6862p ps=64.265u w=62.745u l=1u
X3048 BAT GATE DVDD DVDD pfet_06v0 ad=35.511p pd=48.245u as=35.511p ps=48.245u w=46.725u l=1u
X3049 BAT GATE DVDD DVDD pfet_06v0 ad=58.0754p pd=77.935u as=58.0754p ps=77.935u w=76.41499u l=1u
X3050 DVDD GATE BAT DVDD pfet_06v0 ad=35.511p pd=48.245u as=35.511p ps=48.245u w=46.725u l=1u
X3051 DVDD GATE BAT DVDD pfet_06v0 ad=71.8724p pd=0.1548m as=58.1096p ps=77.98u w=76.46u l=1u
X3052 BAT GATE DVDD DVDD pfet_06v0 ad=58.1134p pd=77.985u as=58.1134p ps=77.985u w=76.465u l=1u
X3053 BAT GATE DVDD DVDD pfet_06v0 ad=58.1134p pd=77.985u as=58.1134p ps=77.985u w=76.465u l=1u
X3054 DVDD GATE BAT DVDD pfet_06v0 ad=35.511p pd=48.245u as=35.511p ps=48.245u w=46.725u l=1u
X3055 BAT GATE DVDD DVDD pfet_06v0 ad=35.511p pd=48.245u as=35.511p ps=48.245u w=46.725u l=1u
X3056 BAT GATE DVDD DVDD pfet_06v0 ad=47.6862p pd=64.265u as=58.9803p ps=0.12737m w=62.745u l=1u
X3057 BAT GATE DVDD DVDD pfet_06v0 ad=58.1096p pd=77.98u as=58.1096p ps=77.98u w=76.46u l=1u
X3058 BAT GATE DVDD DVDD pfet_06v0 ad=35.511p pd=48.245u as=35.511p ps=48.245u w=46.725u l=1u
X3059 DVDD GATE BAT DVDD pfet_06v0 ad=58.1134p pd=77.985u as=58.1134p ps=77.985u w=76.465u l=1u
X3060 DVDD GATE BAT DVDD pfet_06v0 ad=58.1172p pd=77.99u as=58.1172p ps=77.99u w=76.47u l=1u
X3061 BAT GATE DVDD DVDD pfet_06v0 ad=35.511p pd=48.245u as=35.511p ps=48.245u w=46.725u l=1u
X3062 DVDD GATE BAT DVDD pfet_06v0 ad=35.5072p pd=48.24u as=35.5072p ps=48.24u w=46.72u l=1u
X3063 DVDD GATE BAT DVDD pfet_06v0 ad=35.511p pd=48.245u as=35.511p ps=48.245u w=46.725u l=1u
X3064 BAT GATE DVDD DVDD pfet_06v0 ad=47.6862p pd=64.265u as=47.6862p ps=64.265u w=62.745u l=1u
X3065 BAT GATE DVDD DVDD pfet_06v0 ad=58.1134p pd=77.985u as=58.1134p ps=77.985u w=76.465u l=1u
X3066 BAT GATE DVDD DVDD pfet_06v0 ad=58.1134p pd=77.985u as=58.1134p ps=77.985u w=76.465u l=1u
X3067 DVDD GATE BAT DVDD pfet_06v0 ad=61.0812p pd=0.13184m as=49.3848p ps=66.5u w=64.98u l=1u
X3068 BAT GATE DVDD DVDD pfet_06v0 ad=35.511p pd=48.245u as=35.511p ps=48.245u w=46.725u l=1u
X3069 BAT GATE DVDD DVDD pfet_06v0 ad=58.1134p pd=77.985u as=71.8771p ps=0.15481m w=76.465u l=1u
X3070 DVDD GATE BAT DVDD pfet_06v0 ad=58.1134p pd=77.985u as=58.1134p ps=77.985u w=76.465u l=1u
X3071 DVDD GATE BAT DVDD pfet_06v0 ad=58.1134p pd=77.985u as=58.1134p ps=77.985u w=76.465u l=1u
X3072 BAT GATE DVDD DVDD pfet_06v0 ad=49.3848p pd=66.5u as=49.3848p ps=66.5u w=64.98u l=1u
X3073 DVDD GATE BAT DVDD pfet_06v0 ad=71.8818p pd=0.15482m as=58.1172p ps=77.99u w=76.47u l=1u
X3074 BAT GATE DVDD DVDD pfet_06v0 ad=58.1134p pd=77.985u as=58.1134p ps=77.985u w=76.465u l=1u
X3075 DVDD GATE BAT DVDD pfet_06v0 ad=35.511p pd=48.245u as=35.511p ps=48.245u w=46.725u l=1u
X3076 BAT GATE DVDD DVDD pfet_06v0 ad=58.1134p pd=77.985u as=58.1134p ps=77.985u w=76.465u l=1u
X3077 DVDD GATE BAT DVDD pfet_06v0 ad=35.511p pd=48.245u as=35.511p ps=48.245u w=46.725u l=1u
X3078 DVDD GATE BAT DVDD pfet_06v0 ad=43.9215p pd=95.32999u as=35.511p ps=48.245u w=46.725u l=1u
X3079 BAT GATE DVDD DVDD pfet_06v0 ad=58.1096p pd=77.98u as=58.1096p ps=77.98u w=76.46u l=1u
X3080 DVDD GATE BAT DVDD pfet_06v0 ad=58.1134p pd=77.985u as=58.1134p ps=77.985u w=76.465u l=1u
X3081 BAT GATE DVDD DVDD pfet_06v0 ad=58.0754p pd=77.935u as=58.0754p ps=77.935u w=76.41499u l=1u
X3082 DVDD GATE BAT DVDD pfet_06v0 ad=58.1134p pd=77.985u as=58.1134p ps=77.985u w=76.465u l=1u
X3083 BAT GATE DVDD DVDD pfet_06v0 ad=58.1096p pd=77.98u as=58.1096p ps=77.98u w=76.46u l=1u
X3084 BAT GATE DVDD DVDD pfet_06v0 ad=49.3848p pd=66.5u as=61.0812p ps=0.13184m w=64.98u l=1u
X3085 DVDD GATE BAT DVDD pfet_06v0 ad=58.1134p pd=77.985u as=58.1134p ps=77.985u w=76.465u l=1u
X3086 DVDD GATE BAT DVDD pfet_06v0 ad=58.1134p pd=77.985u as=58.1134p ps=77.985u w=76.465u l=1u
X3087 DVDD GATE BAT DVDD pfet_06v0 ad=71.8771p pd=0.15481m as=58.1134p ps=77.985u w=76.465u l=1u
X3088 DVDD GATE BAT DVDD pfet_06v0 ad=35.511p pd=48.245u as=35.511p ps=48.245u w=46.725u l=1u
X3089 BAT GATE DVDD DVDD pfet_06v0 ad=35.5072p pd=48.24u as=35.5072p ps=48.24u w=46.72u l=1u
X3090 BAT GATE DVDD DVDD pfet_06v0 ad=58.1134p pd=77.985u as=58.1134p ps=77.985u w=76.465u l=1u
X3091 DVDD GATE BAT DVDD pfet_06v0 ad=35.511p pd=48.245u as=35.511p ps=48.245u w=46.725u l=1u
X3092 BAT GATE DVDD DVDD pfet_06v0 ad=58.1134p pd=77.985u as=71.8771p ps=0.15481m w=76.465u l=1u
X3093 DVDD GATE BAT DVDD pfet_06v0 ad=35.511p pd=48.245u as=35.511p ps=48.245u w=46.725u l=1u
X3094 BAT GATE DVDD DVDD pfet_06v0 ad=58.1134p pd=77.985u as=58.1134p ps=77.985u w=76.465u l=1u
X3095 DVDD GATE BAT DVDD pfet_06v0 ad=35.511p pd=48.245u as=35.511p ps=48.245u w=46.725u l=1u
X3096 BAT GATE DVDD DVDD pfet_06v0 ad=35.5072p pd=48.24u as=35.5072p ps=48.24u w=46.72u l=1u
X3097 DVDD GATE BAT DVDD pfet_06v0 ad=58.1134p pd=77.985u as=58.1134p ps=77.985u w=76.465u l=1u
X3098 BAT GATE DVDD DVDD pfet_06v0 ad=58.1172p pd=77.99u as=58.1172p ps=77.99u w=76.47u l=1u
X3099 BAT GATE DVDD DVDD pfet_06v0 ad=58.1134p pd=77.985u as=58.1134p ps=77.985u w=76.465u l=1u
X3100 BAT GATE DVDD DVDD pfet_06v0 ad=35.511p pd=48.245u as=35.511p ps=48.245u w=46.725u l=1u
X3101 BAT GATE DVDD DVDD pfet_06v0 ad=35.511p pd=48.245u as=35.511p ps=48.245u w=46.725u l=1u
X3102 DVDD GATE BAT DVDD pfet_06v0 ad=47.6862p pd=64.265u as=47.6862p ps=64.265u w=62.745u l=1u
X3103 DVDD GATE BAT DVDD pfet_06v0 ad=58.1172p pd=77.99u as=58.1172p ps=77.99u w=76.47u l=1u
X3104 BAT GATE DVDD DVDD pfet_06v0 ad=35.511p pd=48.245u as=35.511p ps=48.245u w=46.725u l=1u
X3105 DVDD GATE BAT DVDD pfet_06v0 ad=35.511p pd=48.245u as=35.511p ps=48.245u w=46.725u l=1u
X3106 DVDD GATE BAT DVDD pfet_06v0 ad=58.1134p pd=77.985u as=58.1134p ps=77.985u w=76.465u l=1u
X3107 BAT GATE DVDD DVDD pfet_06v0 ad=58.1134p pd=77.985u as=58.1134p ps=77.985u w=76.465u l=1u
X3108 DVDD GATE BAT DVDD pfet_06v0 ad=35.511p pd=48.245u as=35.511p ps=48.245u w=46.725u l=1u
X3109 BAT GATE DVDD DVDD pfet_06v0 ad=35.511p pd=48.245u as=35.511p ps=48.245u w=46.725u l=1u
X3110 BAT GATE DVDD DVDD pfet_06v0 ad=58.1552p pd=78.04u as=58.1552p ps=78.04u w=76.52u l=1u
X3111 DVDD GATE BAT DVDD pfet_06v0 ad=35.5072p pd=48.24u as=35.5072p ps=48.24u w=46.72u l=1u
X3112 DVDD GATE BAT DVDD pfet_06v0 ad=35.5072p pd=48.24u as=35.5072p ps=48.24u w=46.72u l=1u
X3113 BAT GATE DVDD DVDD pfet_06v0 ad=58.1172p pd=77.99u as=58.1172p ps=77.99u w=76.47u l=1u
X3114 DVDD GATE BAT DVDD pfet_06v0 ad=58.1172p pd=77.99u as=58.1172p ps=77.99u w=76.47u l=1u
X3115 BAT GATE DVDD DVDD pfet_06v0 ad=35.511p pd=48.245u as=35.511p ps=48.245u w=46.725u l=1u
X3116 BAT GATE DVDD DVDD pfet_06v0 ad=58.1134p pd=77.985u as=58.1134p ps=77.985u w=76.465u l=1u
X3117 BAT GATE DVDD DVDD pfet_06v0 ad=58.1134p pd=77.985u as=71.8771p ps=0.15481m w=76.465u l=1u
X3118 DVDD GATE BAT DVDD pfet_06v0 ad=58.1134p pd=77.985u as=58.1134p ps=77.985u w=76.465u l=1u
X3119 DVDD GATE BAT DVDD pfet_06v0 ad=58.1134p pd=77.985u as=58.1134p ps=77.985u w=76.465u l=1u
X3120 BAT GATE DVDD DVDD pfet_06v0 ad=58.1552p pd=78.04u as=58.1552p ps=78.04u w=76.52u l=1u
X3121 BAT GATE DVDD DVDD pfet_06v0 ad=35.511p pd=48.245u as=35.511p ps=48.245u w=46.725u l=1u
X3122 BAT GATE DVDD DVDD pfet_06v0 ad=58.1552p pd=78.04u as=58.1552p ps=78.04u w=76.52u l=1u
X3123 BAT GATE DVDD DVDD pfet_06v0 ad=35.511p pd=48.245u as=35.511p ps=48.245u w=46.725u l=1u
X3124 DVDD GATE BAT DVDD pfet_06v0 ad=35.511p pd=48.245u as=35.511p ps=48.245u w=46.725u l=1u
X3125 DVDD GATE BAT DVDD pfet_06v0 ad=58.1552p pd=78.04u as=58.1552p ps=78.04u w=76.52u l=1u
X3126 DVDD GATE BAT DVDD pfet_06v0 ad=35.511p pd=48.245u as=35.511p ps=48.245u w=46.725u l=1u
X3127 BAT GATE DVDD DVDD pfet_06v0 ad=35.511p pd=48.245u as=35.511p ps=48.245u w=46.725u l=1u
X3128 DVDD GATE BAT DVDD pfet_06v0 ad=35.511p pd=48.245u as=35.511p ps=48.245u w=46.725u l=1u
X3129 BAT GATE DVDD DVDD pfet_06v0 ad=35.511p pd=48.245u as=35.511p ps=48.245u w=46.725u l=1u
X3130 BAT GATE DVDD DVDD pfet_06v0 ad=35.511p pd=48.245u as=35.511p ps=48.245u w=46.725u l=1u
X3131 DVDD GATE BAT DVDD pfet_06v0 ad=58.1134p pd=77.985u as=58.1134p ps=77.985u w=76.465u l=1u
X3132 BAT GATE DVDD DVDD pfet_06v0 ad=58.1134p pd=77.985u as=58.1134p ps=77.985u w=76.465u l=1u
X3133 DVDD GATE BAT DVDD pfet_06v0 ad=43.9215p pd=95.32999u as=35.511p ps=48.245u w=46.725u l=1u
X3134 BAT GATE DVDD DVDD pfet_06v0 ad=35.511p pd=48.245u as=35.511p ps=48.245u w=46.725u l=1u
X3135 BAT GATE DVDD DVDD pfet_06v0 ad=58.1172p pd=77.99u as=58.1172p ps=77.99u w=76.47u l=1u
X3136 DVDD GATE BAT DVDD pfet_06v0 ad=71.8771p pd=0.15481m as=58.1134p ps=77.985u w=76.465u l=1u
X3137 DVDD GATE BAT DVDD pfet_06v0 ad=35.511p pd=48.245u as=35.511p ps=48.245u w=46.725u l=1u
X3138 DVDD GATE BAT DVDD pfet_06v0 ad=71.8771p pd=0.15481m as=58.1134p ps=77.985u w=76.465u l=1u
X3139 BAT GATE DVDD DVDD pfet_06v0 ad=47.6862p pd=64.265u as=47.6862p ps=64.265u w=62.745u l=1u
X3140 BAT GATE DVDD DVDD pfet_06v0 ad=58.1134p pd=77.985u as=58.1134p ps=77.985u w=76.465u l=1u
X3141 DVDD GATE BAT DVDD pfet_06v0 ad=35.511p pd=48.245u as=35.511p ps=48.245u w=46.725u l=1u
X3142 BAT GATE DVDD DVDD pfet_06v0 ad=35.511p pd=48.245u as=35.511p ps=48.245u w=46.725u l=1u
X3143 DVDD GATE BAT DVDD pfet_06v0 ad=35.511p pd=48.245u as=35.511p ps=48.245u w=46.725u l=1u
X3144 DVDD GATE BAT DVDD pfet_06v0 ad=49.3848p pd=66.5u as=49.3848p ps=66.5u w=64.98u l=1u
X3145 BAT GATE DVDD DVDD pfet_06v0 ad=58.1134p pd=77.985u as=58.1134p ps=77.985u w=76.465u l=1u
X3146 DVDD GATE BAT DVDD pfet_06v0 ad=43.9215p pd=95.32999u as=35.511p ps=48.245u w=46.725u l=1u
X3147 BAT GATE DVDD DVDD pfet_06v0 ad=58.1134p pd=77.985u as=58.1134p ps=77.985u w=76.465u l=1u
X3148 BAT GATE DVDD DVDD pfet_06v0 ad=58.1134p pd=77.985u as=58.1134p ps=77.985u w=76.465u l=1u
X3149 BAT GATE DVDD DVDD pfet_06v0 ad=35.511p pd=48.245u as=43.9215p ps=95.32999u w=46.725u l=1u
X3150 DVDD GATE BAT DVDD pfet_06v0 ad=58.1134p pd=77.985u as=58.1134p ps=77.985u w=76.465u l=1u
X3151 BAT GATE DVDD DVDD pfet_06v0 ad=58.1134p pd=77.985u as=71.8771p ps=0.15481m w=76.465u l=1u
X3152 BAT GATE DVDD DVDD pfet_06v0 ad=35.511p pd=48.245u as=35.511p ps=48.245u w=46.725u l=1u
X3153 DVDD GATE BAT DVDD pfet_06v0 ad=49.3848p pd=66.5u as=49.3848p ps=66.5u w=64.98u l=1u
X3154 DVDD GATE BAT DVDD pfet_06v0 ad=71.8771p pd=0.15481m as=58.1134p ps=77.985u w=76.465u l=1u
X3155 BAT GATE DVDD DVDD pfet_06v0 ad=47.6862p pd=64.265u as=47.6862p ps=64.265u w=62.745u l=1u
X3156 BAT GATE DVDD DVDD pfet_06v0 ad=58.1134p pd=77.985u as=71.8771p ps=0.15481m w=76.465u l=1u
X3157 BAT GATE DVDD DVDD pfet_06v0 ad=35.511p pd=48.245u as=35.511p ps=48.245u w=46.725u l=1u
X3158 BAT GATE DVDD DVDD pfet_06v0 ad=58.1096p pd=77.98u as=58.1096p ps=77.98u w=76.46u l=1u
X3159 DVDD GATE BAT DVDD pfet_06v0 ad=43.9168p pd=95.32u as=35.5072p ps=48.24u w=46.72u l=1u
X3160 DVDD GATE BAT DVDD pfet_06v0 ad=58.9803p pd=0.12737m as=47.6862p ps=64.265u w=62.745u l=1u
X3161 BAT GATE DVDD DVDD pfet_06v0 ad=47.6862p pd=64.265u as=47.6862p ps=64.265u w=62.745u l=1u
X3162 DVDD GATE BAT DVDD pfet_06v0 ad=35.511p pd=48.245u as=35.511p ps=48.245u w=46.725u l=1u
X3163 BAT GATE DVDD DVDD pfet_06v0 ad=58.1134p pd=77.985u as=58.1134p ps=77.985u w=76.465u l=1u
X3164 BAT GATE DVDD DVDD pfet_06v0 ad=58.1096p pd=77.98u as=71.8724p ps=0.1548m w=76.46u l=1u
X3165 BAT GATE DVDD DVDD pfet_06v0 ad=35.511p pd=48.245u as=35.511p ps=48.245u w=46.725u l=1u
X3166 BAT GATE DVDD DVDD pfet_06v0 ad=35.511p pd=48.245u as=43.9215p ps=95.32999u w=46.725u l=1u
X3167 BAT GATE DVDD DVDD pfet_06v0 ad=35.511p pd=48.245u as=35.511p ps=48.245u w=46.725u l=1u
X3168 DVDD GATE BAT DVDD pfet_06v0 ad=58.1134p pd=77.985u as=58.1134p ps=77.985u w=76.465u l=1u
X3169 BAT GATE DVDD DVDD pfet_06v0 ad=49.3848p pd=66.5u as=49.3848p ps=66.5u w=64.98u l=1u
X3170 BAT GATE DVDD DVDD pfet_06v0 ad=49.3848p pd=66.5u as=49.3848p ps=66.5u w=64.98u l=1u
X3171 DVDD GATE BAT DVDD pfet_06v0 ad=35.511p pd=48.245u as=35.511p ps=48.245u w=46.725u l=1u
X3172 BAT GATE DVDD DVDD pfet_06v0 ad=58.1172p pd=77.99u as=58.1172p ps=77.99u w=76.47u l=1u
X3173 DVDD GATE BAT DVDD pfet_06v0 ad=58.1134p pd=77.985u as=58.1134p ps=77.985u w=76.465u l=1u
X3174 BAT GATE DVDD DVDD pfet_06v0 ad=35.511p pd=48.245u as=35.511p ps=48.245u w=46.725u l=1u
X3175 DVDD GATE BAT DVDD pfet_06v0 ad=71.8771p pd=0.15481m as=58.1134p ps=77.985u w=76.465u l=1u
X3176 BAT GATE DVDD DVDD pfet_06v0 ad=35.5072p pd=48.24u as=35.5072p ps=48.24u w=46.72u l=1u
X3177 BAT GATE DVDD DVDD pfet_06v0 ad=58.1134p pd=77.985u as=71.8771p ps=0.15481m w=76.465u l=1u
X3178 DVDD GATE BAT DVDD pfet_06v0 ad=47.6862p pd=64.265u as=47.6862p ps=64.265u w=62.745u l=1u
X3179 DVDD GATE BAT DVDD pfet_06v0 ad=58.1134p pd=77.985u as=58.1134p ps=77.985u w=76.465u l=1u
X3180 DVDD GATE BAT DVDD pfet_06v0 ad=71.8771p pd=0.15481m as=58.1134p ps=77.985u w=76.465u l=1u
X3181 DVDD GATE BAT DVDD pfet_06v0 ad=35.511p pd=48.245u as=35.511p ps=48.245u w=46.725u l=1u
X3182 BAT GATE DVDD DVDD pfet_06v0 ad=35.511p pd=48.245u as=35.511p ps=48.245u w=46.725u l=1u
X3183 BAT GATE DVDD DVDD pfet_06v0 ad=58.1134p pd=77.985u as=58.1134p ps=77.985u w=76.465u l=1u
X3184 BAT GATE DVDD DVDD pfet_06v0 ad=58.1134p pd=77.985u as=58.1134p ps=77.985u w=76.465u l=1u
X3185 DVDD GATE BAT DVDD pfet_06v0 ad=35.5072p pd=48.24u as=35.5072p ps=48.24u w=46.72u l=1u
X3186 DVDD GATE BAT DVDD pfet_06v0 ad=71.8771p pd=0.15481m as=58.1134p ps=77.985u w=76.465u l=1u
X3187 DVDD GATE BAT DVDD pfet_06v0 ad=35.511p pd=48.245u as=35.511p ps=48.245u w=46.725u l=1u
X3188 DVDD GATE BAT DVDD pfet_06v0 ad=58.1134p pd=77.985u as=58.1134p ps=77.985u w=76.465u l=1u
X3189 DVDD GATE BAT DVDD pfet_06v0 ad=58.0754p pd=77.935u as=58.0754p ps=77.935u w=76.41499u l=1u
X3190 BAT GATE DVDD DVDD pfet_06v0 ad=35.511p pd=48.245u as=35.511p ps=48.245u w=46.725u l=1u
X3191 BAT GATE DVDD DVDD pfet_06v0 ad=58.1134p pd=77.985u as=71.8771p ps=0.15481m w=76.465u l=1u
X3192 BAT GATE DVDD DVDD pfet_06v0 ad=35.511p pd=48.245u as=35.511p ps=48.245u w=46.725u l=1u
X3193 BAT GATE DVDD DVDD pfet_06v0 ad=58.1134p pd=77.985u as=58.1134p ps=77.985u w=76.465u l=1u
X3194 DVDD GATE BAT DVDD pfet_06v0 ad=58.0754p pd=77.935u as=58.0754p ps=77.935u w=76.41499u l=1u
X3195 BAT GATE DVDD DVDD pfet_06v0 ad=58.1096p pd=77.98u as=71.8724p ps=0.1548m w=76.46u l=1u
X3196 BAT GATE DVDD DVDD pfet_06v0 ad=47.6862p pd=64.265u as=47.6862p ps=64.265u w=62.745u l=1u
X3197 BAT GATE DVDD DVDD pfet_06v0 ad=35.511p pd=48.245u as=35.511p ps=48.245u w=46.725u l=1u
X3198 BAT GATE DVDD DVDD pfet_06v0 ad=35.511p pd=48.245u as=35.511p ps=48.245u w=46.725u l=1u
X3199 BAT GATE DVDD DVDD pfet_06v0 ad=35.511p pd=48.245u as=35.511p ps=48.245u w=46.725u l=1u
X3200 BAT GATE DVDD DVDD pfet_06v0 ad=58.1134p pd=77.985u as=58.1134p ps=77.985u w=76.465u l=1u
X3201 BAT GATE DVDD DVDD pfet_06v0 ad=35.5072p pd=48.24u as=35.5072p ps=48.24u w=46.72u l=1u
X3202 DVDD GATE BAT DVDD pfet_06v0 ad=58.1134p pd=77.985u as=58.1134p ps=77.985u w=76.465u l=1u
X3203 DVDD GATE BAT DVDD pfet_06v0 ad=58.1134p pd=77.985u as=58.1134p ps=77.985u w=76.465u l=1u
X3204 BAT GATE DVDD DVDD pfet_06v0 ad=35.511p pd=48.245u as=35.511p ps=48.245u w=46.725u l=1u
X3205 DVDD GATE BAT DVDD pfet_06v0 ad=35.511p pd=48.245u as=35.511p ps=48.245u w=46.725u l=1u
X3206 DVDD GATE BAT DVDD pfet_06v0 ad=35.511p pd=48.245u as=35.511p ps=48.245u w=46.725u l=1u
X3207 BAT GATE DVDD DVDD pfet_06v0 ad=35.511p pd=48.245u as=35.511p ps=48.245u w=46.725u l=1u
X3208 BAT GATE DVDD DVDD pfet_06v0 ad=35.511p pd=48.245u as=43.9215p ps=95.32999u w=46.725u l=1u
X3209 BAT GATE DVDD DVDD pfet_06v0 ad=35.511p pd=48.245u as=35.511p ps=48.245u w=46.725u l=1u
X3210 DVDD GATE BAT DVDD pfet_06v0 ad=58.1552p pd=78.04u as=58.1552p ps=78.04u w=76.52u l=1u
X3211 DVDD GATE BAT DVDD pfet_06v0 ad=35.511p pd=48.245u as=35.511p ps=48.245u w=46.725u l=1u
X3212 BAT GATE DVDD DVDD pfet_06v0 ad=35.5072p pd=48.24u as=35.5072p ps=48.24u w=46.72u l=1u
X3213 DVDD GATE BAT DVDD pfet_06v0 ad=35.511p pd=48.245u as=35.511p ps=48.245u w=46.725u l=1u
X3214 DVDD GATE BAT DVDD pfet_06v0 ad=35.511p pd=48.245u as=35.511p ps=48.245u w=46.725u l=1u
X3215 BAT GATE DVDD DVDD pfet_06v0 ad=35.5072p pd=48.24u as=35.5072p ps=48.24u w=46.72u l=1u
X3216 BAT GATE DVDD DVDD pfet_06v0 ad=58.1134p pd=77.985u as=58.1134p ps=77.985u w=76.465u l=1u
X3217 DVDD GATE BAT DVDD pfet_06v0 ad=35.511p pd=48.245u as=35.511p ps=48.245u w=46.725u l=1u
X3218 BAT GATE DVDD DVDD pfet_06v0 ad=35.511p pd=48.245u as=43.9215p ps=95.32999u w=46.725u l=1u
X3219 DVDD GATE BAT DVDD pfet_06v0 ad=58.1134p pd=77.985u as=58.1134p ps=77.985u w=76.465u l=1u
X3220 BAT GATE DVDD DVDD pfet_06v0 ad=58.1134p pd=77.985u as=58.1134p ps=77.985u w=76.465u l=1u
X3221 DVDD GATE BAT DVDD pfet_06v0 ad=35.511p pd=48.245u as=35.511p ps=48.245u w=46.725u l=1u
X3222 BAT GATE DVDD DVDD pfet_06v0 ad=58.1134p pd=77.985u as=58.1134p ps=77.985u w=76.465u l=1u
X3223 DVDD GATE BAT DVDD pfet_06v0 ad=43.9215p pd=95.32999u as=35.511p ps=48.245u w=46.725u l=1u
X3224 DVDD GATE BAT DVDD pfet_06v0 ad=58.0754p pd=77.935u as=58.0754p ps=77.935u w=76.41499u l=1u
X3225 DVDD GATE BAT DVDD pfet_06v0 ad=43.9215p pd=95.32999u as=35.511p ps=48.245u w=46.725u l=1u
X3226 BAT GATE DVDD DVDD pfet_06v0 ad=58.1172p pd=77.99u as=71.8818p ps=0.15482m w=76.47u l=1u
X3227 DVDD GATE BAT DVDD pfet_06v0 ad=35.511p pd=48.245u as=35.511p ps=48.245u w=46.725u l=1u
X3228 BAT GATE DVDD DVDD pfet_06v0 ad=58.1134p pd=77.985u as=58.1134p ps=77.985u w=76.465u l=1u
X3229 BAT GATE DVDD DVDD pfet_06v0 ad=58.1172p pd=77.99u as=58.1172p ps=77.99u w=76.47u l=1u
X3230 DVDD GATE BAT DVDD pfet_06v0 ad=58.1096p pd=77.98u as=58.1096p ps=77.98u w=76.46u l=1u
X3231 BAT GATE DVDD DVDD pfet_06v0 ad=35.511p pd=48.245u as=35.511p ps=48.245u w=46.725u l=1u
X3232 DVDD GATE BAT DVDD pfet_06v0 ad=58.1134p pd=77.985u as=58.1134p ps=77.985u w=76.465u l=1u
X3233 BAT GATE DVDD DVDD pfet_06v0 ad=35.511p pd=48.245u as=43.9215p ps=95.32999u w=46.725u l=1u
X3234 DVDD GATE BAT DVDD pfet_06v0 ad=35.511p pd=48.245u as=35.511p ps=48.245u w=46.725u l=1u
X3235 BAT GATE DVDD DVDD pfet_06v0 ad=58.1134p pd=77.985u as=71.8771p ps=0.15481m w=76.465u l=1u
X3236 BAT GATE DVDD DVDD pfet_06v0 ad=35.511p pd=48.245u as=35.511p ps=48.245u w=46.725u l=1u
X3237 BAT GATE DVDD DVDD pfet_06v0 ad=35.511p pd=48.245u as=35.511p ps=48.245u w=46.725u l=1u
X3238 BAT GATE DVDD DVDD pfet_06v0 ad=58.1096p pd=77.98u as=58.1096p ps=77.98u w=76.46u l=1u
X3239 DVDD GATE BAT DVDD pfet_06v0 ad=35.511p pd=48.245u as=35.511p ps=48.245u w=46.725u l=1u
X3240 BAT GATE DVDD DVDD pfet_06v0 ad=35.511p pd=48.245u as=35.511p ps=48.245u w=46.725u l=1u
X3241 DVDD GATE BAT DVDD pfet_06v0 ad=35.511p pd=48.245u as=35.511p ps=48.245u w=46.725u l=1u
X3242 DVDD GATE BAT DVDD pfet_06v0 ad=71.8771p pd=0.15481m as=58.1134p ps=77.985u w=76.465u l=1u
X3243 BAT GATE DVDD DVDD pfet_06v0 ad=35.511p pd=48.245u as=35.511p ps=48.245u w=46.725u l=1u
X3244 DVDD GATE BAT DVDD pfet_06v0 ad=43.9168p pd=95.32u as=35.5072p ps=48.24u w=46.72u l=1u
X3245 BAT GATE DVDD DVDD pfet_06v0 ad=58.1134p pd=77.985u as=58.1134p ps=77.985u w=76.465u l=1u
X3246 BAT GATE DVDD DVDD pfet_06v0 ad=58.1134p pd=77.985u as=58.1134p ps=77.985u w=76.465u l=1u
X3247 BAT GATE DVDD DVDD pfet_06v0 ad=35.511p pd=48.245u as=35.511p ps=48.245u w=46.725u l=1u
X3248 DVDD GATE BAT DVDD pfet_06v0 ad=58.1134p pd=77.985u as=58.1134p ps=77.985u w=76.465u l=1u
X3249 DVDD GATE BAT DVDD pfet_06v0 ad=58.1134p pd=77.985u as=58.1134p ps=77.985u w=76.465u l=1u
X3250 BAT GATE DVDD DVDD pfet_06v0 ad=35.511p pd=48.245u as=35.511p ps=48.245u w=46.725u l=1u
X3251 BAT GATE DVDD DVDD pfet_06v0 ad=35.5072p pd=48.24u as=35.5072p ps=48.24u w=46.72u l=1u
X3252 DVDD GATE BAT DVDD pfet_06v0 ad=35.511p pd=48.245u as=35.511p ps=48.245u w=46.725u l=1u
X3253 DVDD GATE BAT DVDD pfet_06v0 ad=58.1134p pd=77.985u as=58.1134p ps=77.985u w=76.465u l=1u
X3254 BAT GATE DVDD DVDD pfet_06v0 ad=58.1552p pd=78.04u as=58.1552p ps=78.04u w=76.52u l=1u
X3255 BAT GATE DVDD DVDD pfet_06v0 ad=35.511p pd=48.245u as=35.511p ps=48.245u w=46.725u l=1u
X3256 DVDD GATE BAT DVDD pfet_06v0 ad=58.1134p pd=77.985u as=58.1134p ps=77.985u w=76.465u l=1u
X3257 DVDD GATE BAT DVDD pfet_06v0 ad=35.511p pd=48.245u as=35.511p ps=48.245u w=46.725u l=1u
X3258 DVDD GATE BAT DVDD pfet_06v0 ad=43.9215p pd=95.32999u as=35.511p ps=48.245u w=46.725u l=1u
X3259 DVDD GATE BAT DVDD pfet_06v0 ad=58.1134p pd=77.985u as=58.1134p ps=77.985u w=76.465u l=1u
X3260 BAT GATE DVDD DVDD pfet_06v0 ad=35.511p pd=48.245u as=35.511p ps=48.245u w=46.725u l=1u
X3261 DVDD GATE BAT DVDD pfet_06v0 ad=47.6862p pd=64.265u as=47.6862p ps=64.265u w=62.745u l=1u
X3262 BAT GATE DVDD DVDD pfet_06v0 ad=47.6862p pd=64.265u as=47.6862p ps=64.265u w=62.745u l=1u
X3263 DVDD GATE BAT DVDD pfet_06v0 ad=43.9215p pd=95.32999u as=35.511p ps=48.245u w=46.725u l=1u
X3264 DVDD GATE BAT DVDD pfet_06v0 ad=58.9803p pd=0.12737m as=47.6862p ps=64.265u w=62.745u l=1u
X3265 BAT GATE DVDD DVDD pfet_06v0 ad=58.1134p pd=77.985u as=58.1134p ps=77.985u w=76.465u l=1u
X3266 BAT GATE DVDD DVDD pfet_06v0 ad=35.511p pd=48.245u as=35.511p ps=48.245u w=46.725u l=1u
X3267 DVDD GATE BAT DVDD pfet_06v0 ad=58.1096p pd=77.98u as=58.1096p ps=77.98u w=76.46u l=1u
X3268 BAT GATE DVDD DVDD pfet_06v0 ad=35.511p pd=48.245u as=35.511p ps=48.245u w=46.725u l=1u
X3269 DVDD GATE BAT DVDD pfet_06v0 ad=35.511p pd=48.245u as=35.511p ps=48.245u w=46.725u l=1u
X3270 DVDD GATE BAT DVDD pfet_06v0 ad=35.511p pd=48.245u as=35.511p ps=48.245u w=46.725u l=1u
X3271 BAT GATE DVDD DVDD pfet_06v0 ad=58.1172p pd=77.99u as=58.1172p ps=77.99u w=76.47u l=1u
X3272 BAT GATE DVDD DVDD pfet_06v0 ad=58.1134p pd=77.985u as=58.1134p ps=77.985u w=76.465u l=1u
X3273 BAT GATE DVDD DVDD pfet_06v0 ad=58.1552p pd=78.04u as=71.92879p ps=0.15492m w=76.52u l=1u
X3274 BAT GATE DVDD DVDD pfet_06v0 ad=58.1134p pd=77.985u as=71.8771p ps=0.15481m w=76.465u l=1u
X3275 DVDD GATE BAT DVDD pfet_06v0 ad=35.511p pd=48.245u as=35.511p ps=48.245u w=46.725u l=1u
X3276 DVDD GATE BAT DVDD pfet_06v0 ad=58.1134p pd=77.985u as=58.1134p ps=77.985u w=76.465u l=1u
X3277 BAT GATE DVDD DVDD pfet_06v0 ad=58.1134p pd=77.985u as=58.1134p ps=77.985u w=76.465u l=1u
X3278 DVDD GATE BAT DVDD pfet_06v0 ad=49.3848p pd=66.5u as=49.3848p ps=66.5u w=64.98u l=1u
X3279 BAT GATE DVDD DVDD pfet_06v0 ad=35.511p pd=48.245u as=35.511p ps=48.245u w=46.725u l=1u
X3280 BAT GATE DVDD DVDD pfet_06v0 ad=58.1134p pd=77.985u as=71.8771p ps=0.15481m w=76.465u l=1u
X3281 DVDD GATE BAT DVDD pfet_06v0 ad=35.511p pd=48.245u as=35.511p ps=48.245u w=46.725u l=1u
X3282 DVDD GATE BAT DVDD pfet_06v0 ad=58.0754p pd=77.935u as=58.0754p ps=77.935u w=76.41499u l=1u
X3283 BAT GATE DVDD DVDD pfet_06v0 ad=58.1134p pd=77.985u as=58.1134p ps=77.985u w=76.465u l=1u
X3284 BAT GATE DVDD DVDD pfet_06v0 ad=58.1552p pd=78.04u as=58.1552p ps=78.04u w=76.52u l=1u
X3285 BAT GATE DVDD DVDD pfet_06v0 ad=35.511p pd=48.245u as=43.9215p ps=95.32999u w=46.725u l=1u
X3286 BAT GATE DVDD DVDD pfet_06v0 ad=58.0754p pd=77.935u as=71.8301p ps=0.15471m w=76.41499u l=1u
X3287 BAT GATE DVDD DVDD pfet_06v0 ad=58.1096p pd=77.98u as=58.1096p ps=77.98u w=76.46u l=1u
X3288 DVDD GATE BAT DVDD pfet_06v0 ad=35.511p pd=48.245u as=35.511p ps=48.245u w=46.725u l=1u
X3289 DVDD GATE BAT DVDD pfet_06v0 ad=58.1134p pd=77.985u as=58.1134p ps=77.985u w=76.465u l=1u
X3290 BAT GATE DVDD DVDD pfet_06v0 ad=35.5072p pd=48.24u as=35.5072p ps=48.24u w=46.72u l=1u
X3291 DVDD GATE BAT DVDD pfet_06v0 ad=35.511p pd=48.245u as=35.511p ps=48.245u w=46.725u l=1u
X3292 BAT GATE DVDD DVDD pfet_06v0 ad=58.1134p pd=77.985u as=58.1134p ps=77.985u w=76.465u l=1u
X3293 BAT GATE DVDD DVDD pfet_06v0 ad=35.511p pd=48.245u as=43.9215p ps=95.32999u w=46.725u l=1u
X3294 BAT GATE DVDD DVDD pfet_06v0 ad=58.1134p pd=77.985u as=58.1134p ps=77.985u w=76.465u l=1u
X3295 DVDD GATE BAT DVDD pfet_06v0 ad=35.511p pd=48.245u as=35.511p ps=48.245u w=46.725u l=1u
X3296 DVDD GATE BAT DVDD pfet_06v0 ad=58.1172p pd=77.99u as=58.1172p ps=77.99u w=76.47u l=1u
X3297 DVDD GATE BAT DVDD pfet_06v0 ad=35.511p pd=48.245u as=35.511p ps=48.245u w=46.725u l=1u
X3298 DVDD GATE BAT DVDD pfet_06v0 ad=58.1134p pd=77.985u as=58.1134p ps=77.985u w=76.465u l=1u
X3299 DVDD GATE BAT DVDD pfet_06v0 ad=35.511p pd=48.245u as=35.511p ps=48.245u w=46.725u l=1u
X3300 BAT GATE DVDD DVDD pfet_06v0 ad=58.1134p pd=77.985u as=58.1134p ps=77.985u w=76.465u l=1u
X3301 BAT GATE DVDD DVDD pfet_06v0 ad=58.1172p pd=77.99u as=58.1172p ps=77.99u w=76.47u l=1u
X3302 BAT GATE DVDD DVDD pfet_06v0 ad=35.511p pd=48.245u as=43.9215p ps=95.32999u w=46.725u l=1u
X3303 BAT GATE DVDD DVDD pfet_06v0 ad=58.1134p pd=77.985u as=58.1134p ps=77.985u w=76.465u l=1u
X3304 DVDD GATE BAT DVDD pfet_06v0 ad=49.3848p pd=66.5u as=49.3848p ps=66.5u w=64.98u l=1u
X3305 BAT GATE DVDD DVDD pfet_06v0 ad=35.5072p pd=48.24u as=43.9168p ps=95.32u w=46.72u l=1u
X3306 BAT GATE DVDD DVDD pfet_06v0 ad=35.511p pd=48.245u as=35.511p ps=48.245u w=46.725u l=1u
X3307 BAT GATE DVDD DVDD pfet_06v0 ad=58.1134p pd=77.985u as=71.8771p ps=0.15481m w=76.465u l=1u
X3308 DVDD GATE BAT DVDD pfet_06v0 ad=58.1096p pd=77.98u as=58.1096p ps=77.98u w=76.46u l=1u
X3309 DVDD GATE BAT DVDD pfet_06v0 ad=58.1096p pd=77.98u as=58.1096p ps=77.98u w=76.46u l=1u
X3310 BAT GATE DVDD DVDD pfet_06v0 ad=35.511p pd=48.245u as=35.511p ps=48.245u w=46.725u l=1u
X3311 DVDD GATE BAT DVDD pfet_06v0 ad=35.511p pd=48.245u as=35.511p ps=48.245u w=46.725u l=1u
X3312 DVDD GATE BAT DVDD pfet_06v0 ad=58.1134p pd=77.985u as=58.1134p ps=77.985u w=76.465u l=1u
X3313 BAT GATE DVDD DVDD pfet_06v0 ad=58.1134p pd=77.985u as=58.1134p ps=77.985u w=76.465u l=1u
X3314 DVDD GATE BAT DVDD pfet_06v0 ad=35.511p pd=48.245u as=35.511p ps=48.245u w=46.725u l=1u
X3315 BAT GATE DVDD DVDD pfet_06v0 ad=58.0754p pd=77.935u as=58.0754p ps=77.935u w=76.41499u l=1u
X3316 BAT GATE DVDD DVDD pfet_06v0 ad=47.6862p pd=64.265u as=47.6862p ps=64.265u w=62.745u l=1u
X3317 DVDD GATE BAT DVDD pfet_06v0 ad=58.0754p pd=77.935u as=58.0754p ps=77.935u w=76.41499u l=1u
X3318 DVDD GATE BAT DVDD pfet_06v0 ad=43.9215p pd=95.32999u as=35.511p ps=48.245u w=46.725u l=1u
X3319 BAT GATE DVDD DVDD pfet_06v0 ad=58.1134p pd=77.985u as=58.1134p ps=77.985u w=76.465u l=1u
X3320 BAT GATE DVDD DVDD pfet_06v0 ad=35.511p pd=48.245u as=35.511p ps=48.245u w=46.725u l=1u
X3321 BAT GATE DVDD DVDD pfet_06v0 ad=58.1134p pd=77.985u as=58.1134p ps=77.985u w=76.465u l=1u
X3322 DVDD GATE BAT DVDD pfet_06v0 ad=58.1172p pd=77.99u as=58.1172p ps=77.99u w=76.47u l=1u
X3323 BAT GATE DVDD DVDD pfet_06v0 ad=35.511p pd=48.245u as=43.9215p ps=95.32999u w=46.725u l=1u
X3324 DVDD GATE BAT DVDD pfet_06v0 ad=58.1134p pd=77.985u as=58.1134p ps=77.985u w=76.465u l=1u
X3325 BAT GATE DVDD DVDD pfet_06v0 ad=35.511p pd=48.245u as=35.511p ps=48.245u w=46.725u l=1u
X3326 DVDD GATE BAT DVDD pfet_06v0 ad=71.92879p pd=0.15492m as=58.1552p ps=78.04u w=76.52u l=1u
X3327 DVDD GATE BAT DVDD pfet_06v0 ad=58.1134p pd=77.985u as=58.1134p ps=77.985u w=76.465u l=1u
X3328 BAT GATE DVDD DVDD pfet_06v0 ad=47.6862p pd=64.265u as=47.6862p ps=64.265u w=62.745u l=1u
X3329 BAT GATE DVDD DVDD pfet_06v0 ad=35.511p pd=48.245u as=35.511p ps=48.245u w=46.725u l=1u
X3330 BAT GATE DVDD DVDD pfet_06v0 ad=35.511p pd=48.245u as=35.511p ps=48.245u w=46.725u l=1u
X3331 BAT GATE DVDD DVDD pfet_06v0 ad=35.511p pd=48.245u as=43.9215p ps=95.32999u w=46.725u l=1u
X3332 DVDD GATE BAT DVDD pfet_06v0 ad=71.8771p pd=0.15481m as=58.1134p ps=77.985u w=76.465u l=1u
X3333 BAT GATE DVDD DVDD pfet_06v0 ad=35.511p pd=48.245u as=43.9215p ps=95.32999u w=46.725u l=1u
X3334 DVDD GATE BAT DVDD pfet_06v0 ad=58.1134p pd=77.985u as=58.1134p ps=77.985u w=76.465u l=1u
X3335 DVDD GATE BAT DVDD pfet_06v0 ad=58.1134p pd=77.985u as=58.1134p ps=77.985u w=76.465u l=1u
X3336 BAT GATE DVDD DVDD pfet_06v0 ad=35.511p pd=48.245u as=35.511p ps=48.245u w=46.725u l=1u
X3337 BAT GATE DVDD DVDD pfet_06v0 ad=58.1134p pd=77.985u as=58.1134p ps=77.985u w=76.465u l=1u
X3338 DVDD GATE BAT DVDD pfet_06v0 ad=58.1134p pd=77.985u as=58.1134p ps=77.985u w=76.465u l=1u
X3339 DVDD GATE BAT DVDD pfet_06v0 ad=43.9215p pd=95.32999u as=35.511p ps=48.245u w=46.725u l=1u
X3340 DVDD GATE BAT DVDD pfet_06v0 ad=58.1134p pd=77.985u as=58.1134p ps=77.985u w=76.465u l=1u
X3341 DVDD GATE BAT DVDD pfet_06v0 ad=58.1552p pd=78.04u as=58.1552p ps=78.04u w=76.52u l=1u
X3342 DVDD GATE BAT DVDD pfet_06v0 ad=58.1134p pd=77.985u as=58.1134p ps=77.985u w=76.465u l=1u
X3343 DVDD GATE BAT DVDD pfet_06v0 ad=58.1172p pd=77.99u as=58.1172p ps=77.99u w=76.47u l=1u
X3344 BAT GATE DVDD DVDD pfet_06v0 ad=35.511p pd=48.245u as=35.511p ps=48.245u w=46.725u l=1u
X3345 BAT GATE DVDD DVDD pfet_06v0 ad=58.1134p pd=77.985u as=71.8771p ps=0.15481m w=76.465u l=1u
X3346 DVDD GATE BAT DVDD pfet_06v0 ad=58.1134p pd=77.985u as=58.1134p ps=77.985u w=76.465u l=1u
X3347 BAT GATE DVDD DVDD pfet_06v0 ad=58.1172p pd=77.99u as=71.8818p ps=0.15482m w=76.47u l=1u
X3348 BAT GATE DVDD DVDD pfet_06v0 ad=35.511p pd=48.245u as=35.511p ps=48.245u w=46.725u l=1u
X3349 BAT GATE DVDD DVDD pfet_06v0 ad=58.1134p pd=77.985u as=71.8771p ps=0.15481m w=76.465u l=1u
X3350 DVDD GATE BAT DVDD pfet_06v0 ad=35.511p pd=48.245u as=35.511p ps=48.245u w=46.725u l=1u
X3351 BAT GATE DVDD DVDD pfet_06v0 ad=35.511p pd=48.245u as=43.9215p ps=95.32999u w=46.725u l=1u
X3352 BAT GATE DVDD DVDD pfet_06v0 ad=58.1134p pd=77.985u as=71.8771p ps=0.15481m w=76.465u l=1u
X3353 BAT GATE DVDD DVDD pfet_06v0 ad=58.1134p pd=77.985u as=58.1134p ps=77.985u w=76.465u l=1u
X3354 BAT GATE DVDD DVDD pfet_06v0 ad=35.511p pd=48.245u as=35.511p ps=48.245u w=46.725u l=1u
X3355 DVDD GATE BAT DVDD pfet_06v0 ad=58.1552p pd=78.04u as=58.1552p ps=78.04u w=76.52u l=1u
X3356 BAT GATE DVDD DVDD pfet_06v0 ad=47.6862p pd=64.265u as=47.6862p ps=64.265u w=62.745u l=1u
X3357 DVDD GATE BAT DVDD pfet_06v0 ad=71.8724p pd=0.1548m as=58.1096p ps=77.98u w=76.46u l=1u
X3358 BAT GATE DVDD DVDD pfet_06v0 ad=58.1134p pd=77.985u as=58.1134p ps=77.985u w=76.465u l=1u
X3359 DVDD GATE BAT DVDD pfet_06v0 ad=35.511p pd=48.245u as=35.511p ps=48.245u w=46.725u l=1u
X3360 DVDD GATE BAT DVDD pfet_06v0 ad=35.511p pd=48.245u as=35.511p ps=48.245u w=46.725u l=1u
X3361 BAT GATE DVDD DVDD pfet_06v0 ad=35.511p pd=48.245u as=43.9215p ps=95.32999u w=46.725u l=1u
X3362 BAT GATE DVDD DVDD pfet_06v0 ad=35.511p pd=48.245u as=35.511p ps=48.245u w=46.725u l=1u
X3363 BAT GATE DVDD DVDD pfet_06v0 ad=58.1134p pd=77.985u as=58.1134p ps=77.985u w=76.465u l=1u
X3364 BAT GATE DVDD DVDD pfet_06v0 ad=35.511p pd=48.245u as=43.9215p ps=95.32999u w=46.725u l=1u
X3365 DVDD GATE BAT DVDD pfet_06v0 ad=35.511p pd=48.245u as=35.511p ps=48.245u w=46.725u l=1u
X3366 DVDD GATE BAT DVDD pfet_06v0 ad=43.9215p pd=95.32999u as=35.511p ps=48.245u w=46.725u l=1u
X3367 BAT GATE DVDD DVDD pfet_06v0 ad=35.511p pd=48.245u as=43.9215p ps=95.32999u w=46.725u l=1u
X3368 BAT GATE DVDD DVDD pfet_06v0 ad=58.1134p pd=77.985u as=71.8771p ps=0.15481m w=76.465u l=1u
X3369 DVDD GATE BAT DVDD pfet_06v0 ad=58.1552p pd=78.04u as=58.1552p ps=78.04u w=76.52u l=1u
X3370 BAT GATE DVDD DVDD pfet_06v0 ad=58.1134p pd=77.985u as=58.1134p ps=77.985u w=76.465u l=1u
X3371 BAT GATE DVDD DVDD pfet_06v0 ad=35.511p pd=48.245u as=35.511p ps=48.245u w=46.725u l=1u
X3372 BAT GATE DVDD DVDD pfet_06v0 ad=58.1134p pd=77.985u as=71.8771p ps=0.15481m w=76.465u l=1u
X3373 DVDD GATE BAT DVDD pfet_06v0 ad=35.511p pd=48.245u as=35.511p ps=48.245u w=46.725u l=1u
X3374 BAT GATE DVDD DVDD pfet_06v0 ad=35.511p pd=48.245u as=35.511p ps=48.245u w=46.725u l=1u
X3375 DVDD GATE BAT DVDD pfet_06v0 ad=58.1134p pd=77.985u as=58.1134p ps=77.985u w=76.465u l=1u
X3376 DVDD GATE BAT DVDD pfet_06v0 ad=35.511p pd=48.245u as=35.511p ps=48.245u w=46.725u l=1u
X3377 DVDD GATE BAT DVDD pfet_06v0 ad=58.1172p pd=77.99u as=58.1172p ps=77.99u w=76.47u l=1u
X3378 DVDD GATE BAT DVDD pfet_06v0 ad=35.511p pd=48.245u as=35.511p ps=48.245u w=46.725u l=1u
X3379 DVDD GATE BAT DVDD pfet_06v0 ad=35.5072p pd=48.24u as=35.5072p ps=48.24u w=46.72u l=1u
X3380 BAT GATE DVDD DVDD pfet_06v0 ad=35.511p pd=48.245u as=35.511p ps=48.245u w=46.725u l=1u
X3381 BAT GATE DVDD DVDD pfet_06v0 ad=58.1096p pd=77.98u as=58.1096p ps=77.98u w=76.46u l=1u
X3382 BAT GATE DVDD DVDD pfet_06v0 ad=47.6862p pd=64.265u as=47.6862p ps=64.265u w=62.745u l=1u
X3383 DVDD GATE BAT DVDD pfet_06v0 ad=58.1134p pd=77.985u as=58.1134p ps=77.985u w=76.465u l=1u
X3384 DVDD GATE BAT DVDD pfet_06v0 ad=58.1134p pd=77.985u as=58.1134p ps=77.985u w=76.465u l=1u
X3385 DVDD GATE BAT DVDD pfet_06v0 ad=58.1096p pd=77.98u as=58.1096p ps=77.98u w=76.46u l=1u
X3386 DVDD GATE BAT DVDD pfet_06v0 ad=35.511p pd=48.245u as=35.511p ps=48.245u w=46.725u l=1u
X3387 BAT GATE DVDD DVDD pfet_06v0 ad=49.3848p pd=66.5u as=49.3848p ps=66.5u w=64.98u l=1u
X3388 DVDD GATE BAT DVDD pfet_06v0 ad=58.1096p pd=77.98u as=58.1096p ps=77.98u w=76.46u l=1u
X3389 BAT GATE DVDD DVDD pfet_06v0 ad=35.511p pd=48.245u as=35.511p ps=48.245u w=46.725u l=1u
X3390 BAT GATE DVDD DVDD pfet_06v0 ad=35.5072p pd=48.24u as=35.5072p ps=48.24u w=46.72u l=1u
X3391 DVDD GATE BAT DVDD pfet_06v0 ad=58.1552p pd=78.04u as=58.1552p ps=78.04u w=76.52u l=1u
X3392 BAT GATE DVDD DVDD pfet_06v0 ad=58.0754p pd=77.935u as=71.8301p ps=0.15471m w=76.41499u l=1u
X3393 DVDD GATE BAT DVDD pfet_06v0 ad=47.6862p pd=64.265u as=47.6862p ps=64.265u w=62.745u l=1u
X3394 BAT GATE DVDD DVDD pfet_06v0 ad=35.511p pd=48.245u as=35.511p ps=48.245u w=46.725u l=1u
X3395 BAT GATE DVDD DVDD pfet_06v0 ad=58.0754p pd=77.935u as=58.0754p ps=77.935u w=76.41499u l=1u
X3396 DVDD GATE BAT DVDD pfet_06v0 ad=43.9215p pd=95.32999u as=35.511p ps=48.245u w=46.725u l=1u
X3397 DVDD GATE BAT DVDD pfet_06v0 ad=47.6862p pd=64.265u as=47.6862p ps=64.265u w=62.745u l=1u
X3398 DVDD GATE BAT DVDD pfet_06v0 ad=35.5072p pd=48.24u as=35.5072p ps=48.24u w=46.72u l=1u
X3399 DVDD GATE BAT DVDD pfet_06v0 ad=35.511p pd=48.245u as=35.511p ps=48.245u w=46.725u l=1u
X3400 BAT GATE DVDD DVDD pfet_06v0 ad=58.1134p pd=77.985u as=71.8771p ps=0.15481m w=76.465u l=1u
X3401 BAT GATE DVDD DVDD pfet_06v0 ad=58.1134p pd=77.985u as=58.1134p ps=77.985u w=76.465u l=1u
X3402 BAT GATE DVDD DVDD pfet_06v0 ad=58.1134p pd=77.985u as=58.1134p ps=77.985u w=76.465u l=1u
X3403 BAT GATE DVDD DVDD pfet_06v0 ad=35.511p pd=48.245u as=35.511p ps=48.245u w=46.725u l=1u
X3404 BAT GATE DVDD DVDD pfet_06v0 ad=35.511p pd=48.245u as=35.511p ps=48.245u w=46.725u l=1u
X3405 DVDD GATE BAT DVDD pfet_06v0 ad=58.1134p pd=77.985u as=58.1134p ps=77.985u w=76.465u l=1u
X3406 BAT GATE DVDD DVDD pfet_06v0 ad=58.1096p pd=77.98u as=58.1096p ps=77.98u w=76.46u l=1u
X3407 DVDD GATE BAT DVDD pfet_06v0 ad=58.1134p pd=77.985u as=58.1134p ps=77.985u w=76.465u l=1u
X3408 DVDD GATE BAT DVDD pfet_06v0 ad=58.9803p pd=0.12737m as=47.6862p ps=64.265u w=62.745u l=1u
X3409 DVDD GATE BAT DVDD pfet_06v0 ad=58.1172p pd=77.99u as=58.1172p ps=77.99u w=76.47u l=1u
X3410 DVDD GATE BAT DVDD pfet_06v0 ad=35.511p pd=48.245u as=35.511p ps=48.245u w=46.725u l=1u
X3411 DVDD GATE BAT DVDD pfet_06v0 ad=35.511p pd=48.245u as=35.511p ps=48.245u w=46.725u l=1u
X3412 BAT GATE DVDD DVDD pfet_06v0 ad=47.6862p pd=64.265u as=47.6862p ps=64.265u w=62.745u l=1u
X3413 BAT GATE DVDD DVDD pfet_06v0 ad=58.1134p pd=77.985u as=58.1134p ps=77.985u w=76.465u l=1u
X3414 DVDD GATE BAT DVDD pfet_06v0 ad=35.5072p pd=48.24u as=35.5072p ps=48.24u w=46.72u l=1u
X3415 BAT GATE DVDD DVDD pfet_06v0 ad=58.1172p pd=77.99u as=58.1172p ps=77.99u w=76.47u l=1u
X3416 DVDD GATE BAT DVDD pfet_06v0 ad=71.8771p pd=0.15481m as=58.1134p ps=77.985u w=76.465u l=1u
X3417 BAT GATE DVDD DVDD pfet_06v0 ad=58.1134p pd=77.985u as=58.1134p ps=77.985u w=76.465u l=1u
X3418 BAT GATE DVDD DVDD pfet_06v0 ad=58.1134p pd=77.985u as=58.1134p ps=77.985u w=76.465u l=1u
X3419 DVDD GATE BAT DVDD pfet_06v0 ad=58.1134p pd=77.985u as=58.1134p ps=77.985u w=76.465u l=1u
X3420 BAT GATE DVDD DVDD pfet_06v0 ad=35.511p pd=48.245u as=35.511p ps=48.245u w=46.725u l=1u
X3421 DVDD GATE BAT DVDD pfet_06v0 ad=58.1172p pd=77.99u as=58.1172p ps=77.99u w=76.47u l=1u
X3422 BAT GATE DVDD DVDD pfet_06v0 ad=58.1134p pd=77.985u as=58.1134p ps=77.985u w=76.465u l=1u
X3423 DVDD GATE BAT DVDD pfet_06v0 ad=35.511p pd=48.245u as=35.511p ps=48.245u w=46.725u l=1u
X3424 BAT GATE DVDD DVDD pfet_06v0 ad=49.3848p pd=66.5u as=61.0812p ps=0.13184m w=64.98u l=1u
X3425 DVDD GATE BAT DVDD pfet_06v0 ad=35.511p pd=48.245u as=35.511p ps=48.245u w=46.725u l=1u
X3426 DVDD GATE BAT DVDD pfet_06v0 ad=58.1134p pd=77.985u as=58.1134p ps=77.985u w=76.465u l=1u
X3427 BAT GATE DVDD DVDD pfet_06v0 ad=58.1096p pd=77.98u as=58.1096p ps=77.98u w=76.46u l=1u
X3428 BAT GATE DVDD DVDD pfet_06v0 ad=58.1096p pd=77.98u as=58.1096p ps=77.98u w=76.46u l=1u
X3429 DVDD GATE BAT DVDD pfet_06v0 ad=58.1134p pd=77.985u as=58.1134p ps=77.985u w=76.465u l=1u
X3430 DVDD GATE BAT DVDD pfet_06v0 ad=58.1172p pd=77.99u as=58.1172p ps=77.99u w=76.47u l=1u
X3431 BAT GATE DVDD DVDD pfet_06v0 ad=35.511p pd=48.245u as=35.511p ps=48.245u w=46.725u l=1u
X3432 DVDD GATE BAT DVDD pfet_06v0 ad=58.1552p pd=78.04u as=58.1552p ps=78.04u w=76.52u l=1u
X3433 DVDD GATE BAT DVDD pfet_06v0 ad=58.1134p pd=77.985u as=58.1134p ps=77.985u w=76.465u l=1u
X3434 DVDD GATE BAT DVDD pfet_06v0 ad=35.511p pd=48.245u as=35.511p ps=48.245u w=46.725u l=1u
X3435 BAT GATE DVDD DVDD pfet_06v0 ad=58.1134p pd=77.985u as=58.1134p ps=77.985u w=76.465u l=1u
X3436 BAT GATE DVDD DVDD pfet_06v0 ad=35.511p pd=48.245u as=35.511p ps=48.245u w=46.725u l=1u
X3437 BAT GATE DVDD DVDD pfet_06v0 ad=35.5072p pd=48.24u as=35.5072p ps=48.24u w=46.72u l=1u
X3438 BAT GATE DVDD DVDD pfet_06v0 ad=58.1134p pd=77.985u as=58.1134p ps=77.985u w=76.465u l=1u
X3439 DVDD GATE BAT DVDD pfet_06v0 ad=35.511p pd=48.245u as=35.511p ps=48.245u w=46.725u l=1u
X3440 DVDD GATE BAT DVDD pfet_06v0 ad=35.511p pd=48.245u as=35.511p ps=48.245u w=46.725u l=1u
X3441 BAT GATE DVDD DVDD pfet_06v0 ad=58.1134p pd=77.985u as=71.8771p ps=0.15481m w=76.465u l=1u
X3442 DVDD GATE BAT DVDD pfet_06v0 ad=71.92879p pd=0.15492m as=58.1552p ps=78.04u w=76.52u l=1u
X3443 DVDD GATE BAT DVDD pfet_06v0 ad=58.1134p pd=77.985u as=58.1134p ps=77.985u w=76.465u l=1u
X3444 BAT GATE DVDD DVDD pfet_06v0 ad=58.1172p pd=77.99u as=58.1172p ps=77.99u w=76.47u l=1u
X3445 BAT GATE DVDD DVDD pfet_06v0 ad=58.1134p pd=77.985u as=58.1134p ps=77.985u w=76.465u l=1u
X3446 BAT GATE DVDD DVDD pfet_06v0 ad=58.1552p pd=78.04u as=58.1552p ps=78.04u w=76.52u l=1u
X3447 BAT GATE DVDD DVDD pfet_06v0 ad=35.511p pd=48.245u as=35.511p ps=48.245u w=46.725u l=1u
X3448 BAT GATE DVDD DVDD pfet_06v0 ad=35.511p pd=48.245u as=43.9215p ps=95.32999u w=46.725u l=1u
X3449 DVDD GATE BAT DVDD pfet_06v0 ad=47.6862p pd=64.265u as=47.6862p ps=64.265u w=62.745u l=1u
X3450 DVDD GATE BAT DVDD pfet_06v0 ad=58.1134p pd=77.985u as=58.1134p ps=77.985u w=76.465u l=1u
X3451 DVDD GATE BAT DVDD pfet_06v0 ad=71.8771p pd=0.15481m as=58.1134p ps=77.985u w=76.465u l=1u
X3452 BAT GATE DVDD DVDD pfet_06v0 ad=35.511p pd=48.245u as=35.511p ps=48.245u w=46.725u l=1u
X3453 BAT GATE DVDD DVDD pfet_06v0 ad=35.511p pd=48.245u as=35.511p ps=48.245u w=46.725u l=1u
X3454 BAT GATE DVDD DVDD pfet_06v0 ad=58.1134p pd=77.985u as=58.1134p ps=77.985u w=76.465u l=1u
X3455 DVDD GATE BAT DVDD pfet_06v0 ad=58.1134p pd=77.985u as=58.1134p ps=77.985u w=76.465u l=1u
X3456 BAT GATE DVDD DVDD pfet_06v0 ad=58.1134p pd=77.985u as=58.1134p ps=77.985u w=76.465u l=1u
X3457 DVDD GATE BAT DVDD pfet_06v0 ad=71.8724p pd=0.1548m as=58.1096p ps=77.98u w=76.46u l=1u
X3458 BAT GATE DVDD DVDD pfet_06v0 ad=35.511p pd=48.245u as=35.511p ps=48.245u w=46.725u l=1u
X3459 BAT GATE DVDD DVDD pfet_06v0 ad=35.511p pd=48.245u as=43.9215p ps=95.32999u w=46.725u l=1u
X3460 DVDD GATE BAT DVDD pfet_06v0 ad=58.1134p pd=77.985u as=58.1134p ps=77.985u w=76.465u l=1u
X3461 DVDD GATE BAT DVDD pfet_06v0 ad=35.5072p pd=48.24u as=35.5072p ps=48.24u w=46.72u l=1u
X3462 BAT GATE DVDD DVDD pfet_06v0 ad=58.1134p pd=77.985u as=58.1134p ps=77.985u w=76.465u l=1u
X3463 BAT GATE DVDD DVDD pfet_06v0 ad=58.1172p pd=77.99u as=58.1172p ps=77.99u w=76.47u l=1u
X3464 BAT GATE DVDD DVDD pfet_06v0 ad=58.1552p pd=78.04u as=58.1552p ps=78.04u w=76.52u l=1u
X3465 DVDD GATE BAT DVDD pfet_06v0 ad=43.9215p pd=95.32999u as=35.511p ps=48.245u w=46.725u l=1u
X3466 BAT GATE DVDD DVDD pfet_06v0 ad=35.511p pd=48.245u as=43.9215p ps=95.32999u w=46.725u l=1u
X3467 BAT GATE DVDD DVDD pfet_06v0 ad=58.1134p pd=77.985u as=58.1134p ps=77.985u w=76.465u l=1u
X3468 DVDD GATE BAT DVDD pfet_06v0 ad=35.511p pd=48.245u as=35.511p ps=48.245u w=46.725u l=1u
X3469 BAT GATE DVDD DVDD pfet_06v0 ad=58.1134p pd=77.985u as=58.1134p ps=77.985u w=76.465u l=1u
X3470 DVDD GATE BAT DVDD pfet_06v0 ad=43.9215p pd=95.32999u as=35.511p ps=48.245u w=46.725u l=1u
X3471 DVDD GATE BAT DVDD pfet_06v0 ad=61.0812p pd=0.13184m as=49.3848p ps=66.5u w=64.98u l=1u
X3472 DVDD GATE BAT DVDD pfet_06v0 ad=58.1134p pd=77.985u as=58.1134p ps=77.985u w=76.465u l=1u
X3473 BAT GATE DVDD DVDD pfet_06v0 ad=58.1552p pd=78.04u as=71.92879p ps=0.15492m w=76.52u l=1u
X3474 BAT GATE DVDD DVDD pfet_06v0 ad=35.511p pd=48.245u as=35.511p ps=48.245u w=46.725u l=1u
X3475 BAT GATE DVDD DVDD pfet_06v0 ad=58.1552p pd=78.04u as=58.1552p ps=78.04u w=76.52u l=1u
X3476 BAT GATE DVDD DVDD pfet_06v0 ad=35.511p pd=48.245u as=35.511p ps=48.245u w=46.725u l=1u
X3477 BAT GATE DVDD DVDD pfet_06v0 ad=35.511p pd=48.245u as=35.511p ps=48.245u w=46.725u l=1u
X3478 DVDD GATE BAT DVDD pfet_06v0 ad=58.1172p pd=77.99u as=58.1172p ps=77.99u w=76.47u l=1u
X3479 DVDD GATE BAT DVDD pfet_06v0 ad=71.8771p pd=0.15481m as=58.1134p ps=77.985u w=76.465u l=1u
X3480 BAT GATE DVDD DVDD pfet_06v0 ad=35.511p pd=48.245u as=35.511p ps=48.245u w=46.725u l=1u
X3481 BAT GATE DVDD DVDD pfet_06v0 ad=58.1134p pd=77.985u as=71.8771p ps=0.15481m w=76.465u l=1u
X3482 DVDD GATE BAT DVDD pfet_06v0 ad=47.6862p pd=64.265u as=47.6862p ps=64.265u w=62.745u l=1u
X3483 DVDD GATE BAT DVDD pfet_06v0 ad=43.9215p pd=95.32999u as=35.511p ps=48.245u w=46.725u l=1u
X3484 DVDD GATE BAT DVDD pfet_06v0 ad=35.511p pd=48.245u as=35.511p ps=48.245u w=46.725u l=1u
X3485 DVDD GATE BAT DVDD pfet_06v0 ad=58.1096p pd=77.98u as=58.1096p ps=77.98u w=76.46u l=1u
X3486 BAT GATE DVDD DVDD pfet_06v0 ad=58.1134p pd=77.985u as=58.1134p ps=77.985u w=76.465u l=1u
X3487 BAT GATE DVDD DVDD pfet_06v0 ad=35.511p pd=48.245u as=35.511p ps=48.245u w=46.725u l=1u
X3488 DVDD GATE BAT DVDD pfet_06v0 ad=35.511p pd=48.245u as=35.511p ps=48.245u w=46.725u l=1u
X3489 BAT GATE DVDD DVDD pfet_06v0 ad=35.5072p pd=48.24u as=35.5072p ps=48.24u w=46.72u l=1u
X3490 DVDD GATE BAT DVDD pfet_06v0 ad=58.1134p pd=77.985u as=58.1134p ps=77.985u w=76.465u l=1u
X3491 DVDD GATE BAT DVDD pfet_06v0 ad=58.1134p pd=77.985u as=58.1134p ps=77.985u w=76.465u l=1u
X3492 DVDD GATE BAT DVDD pfet_06v0 ad=58.1134p pd=77.985u as=58.1134p ps=77.985u w=76.465u l=1u
X3493 DVDD GATE BAT DVDD pfet_06v0 ad=35.511p pd=48.245u as=35.511p ps=48.245u w=46.725u l=1u
X3494 BAT GATE DVDD DVDD pfet_06v0 ad=58.1134p pd=77.985u as=58.1134p ps=77.985u w=76.465u l=1u
X3495 DVDD GATE BAT DVDD pfet_06v0 ad=58.0754p pd=77.935u as=58.0754p ps=77.935u w=76.41499u l=1u
X3496 DVDD GATE BAT DVDD pfet_06v0 ad=43.9215p pd=95.32999u as=35.511p ps=48.245u w=46.725u l=1u
X3497 DVDD GATE BAT DVDD pfet_06v0 ad=49.3848p pd=66.5u as=49.3848p ps=66.5u w=64.98u l=1u
X3498 DVDD GATE BAT DVDD pfet_06v0 ad=35.5072p pd=48.24u as=35.5072p ps=48.24u w=46.72u l=1u
X3499 DVDD GATE BAT DVDD pfet_06v0 ad=35.511p pd=48.245u as=35.511p ps=48.245u w=46.725u l=1u
X3500 BAT GATE DVDD DVDD pfet_06v0 ad=58.1134p pd=77.985u as=71.8771p ps=0.15481m w=76.465u l=1u
X3501 DVDD GATE BAT DVDD pfet_06v0 ad=49.3848p pd=66.5u as=49.3848p ps=66.5u w=64.98u l=1u
X3502 BAT GATE DVDD DVDD pfet_06v0 ad=58.1134p pd=77.985u as=58.1134p ps=77.985u w=76.465u l=1u
X3503 BAT GATE DVDD DVDD pfet_06v0 ad=35.511p pd=48.245u as=35.511p ps=48.245u w=46.725u l=1u
X3504 BAT GATE DVDD DVDD pfet_06v0 ad=58.1134p pd=77.985u as=58.1134p ps=77.985u w=76.465u l=1u
X3505 BAT GATE DVDD DVDD pfet_06v0 ad=47.6862p pd=64.265u as=47.6862p ps=64.265u w=62.745u l=1u
X3506 BAT GATE DVDD DVDD pfet_06v0 ad=58.1096p pd=77.98u as=58.1096p ps=77.98u w=76.46u l=1u
X3507 DVDD GATE BAT DVDD pfet_06v0 ad=35.511p pd=48.245u as=35.511p ps=48.245u w=46.725u l=1u
X3508 BAT GATE DVDD DVDD pfet_06v0 ad=58.1134p pd=77.985u as=58.1134p ps=77.985u w=76.465u l=1u
X3509 BAT GATE DVDD DVDD pfet_06v0 ad=35.511p pd=48.245u as=35.511p ps=48.245u w=46.725u l=1u
X3510 DVDD GATE BAT DVDD pfet_06v0 ad=58.1172p pd=77.99u as=58.1172p ps=77.99u w=76.47u l=1u
X3511 BAT GATE DVDD DVDD pfet_06v0 ad=35.511p pd=48.245u as=35.511p ps=48.245u w=46.725u l=1u
X3512 DVDD GATE BAT DVDD pfet_06v0 ad=71.8771p pd=0.15481m as=58.1134p ps=77.985u w=76.465u l=1u
X3513 BAT GATE DVDD DVDD pfet_06v0 ad=58.1134p pd=77.985u as=58.1134p ps=77.985u w=76.465u l=1u
X3514 BAT GATE DVDD DVDD pfet_06v0 ad=49.3848p pd=66.5u as=61.0812p ps=0.13184m w=64.98u l=1u
X3515 DVDD GATE BAT DVDD pfet_06v0 ad=58.1134p pd=77.985u as=58.1134p ps=77.985u w=76.465u l=1u
X3516 BAT GATE DVDD DVDD pfet_06v0 ad=58.1096p pd=77.98u as=71.8724p ps=0.1548m w=76.46u l=1u
X3517 BAT GATE DVDD DVDD pfet_06v0 ad=47.6862p pd=64.265u as=47.6862p ps=64.265u w=62.745u l=1u
X3518 BAT GATE DVDD DVDD pfet_06v0 ad=58.1172p pd=77.99u as=58.1172p ps=77.99u w=76.47u l=1u
X3519 BAT GATE DVDD DVDD pfet_06v0 ad=35.511p pd=48.245u as=43.9215p ps=95.32999u w=46.725u l=1u
X3520 BAT GATE DVDD DVDD pfet_06v0 ad=35.5072p pd=48.24u as=35.5072p ps=48.24u w=46.72u l=1u
X3521 DVDD GATE BAT DVDD pfet_06v0 ad=58.1134p pd=77.985u as=58.1134p ps=77.985u w=76.465u l=1u
X3522 DVDD GATE BAT DVDD pfet_06v0 ad=47.6862p pd=64.265u as=47.6862p ps=64.265u w=62.745u l=1u
X3523 DVDD GATE BAT DVDD pfet_06v0 ad=58.1134p pd=77.985u as=58.1134p ps=77.985u w=76.465u l=1u
X3524 BAT GATE DVDD DVDD pfet_06v0 ad=58.1134p pd=77.985u as=58.1134p ps=77.985u w=76.465u l=1u
X3525 BAT GATE DVDD DVDD pfet_06v0 ad=35.511p pd=48.245u as=43.9215p ps=95.32999u w=46.725u l=1u
X3526 DVDD GATE BAT DVDD pfet_06v0 ad=58.1134p pd=77.985u as=58.1134p ps=77.985u w=76.465u l=1u
X3527 BAT GATE DVDD DVDD pfet_06v0 ad=35.511p pd=48.245u as=35.511p ps=48.245u w=46.725u l=1u
X3528 BAT GATE DVDD DVDD pfet_06v0 ad=35.5072p pd=48.24u as=35.5072p ps=48.24u w=46.72u l=1u
X3529 DVDD GATE BAT DVDD pfet_06v0 ad=35.511p pd=48.245u as=35.511p ps=48.245u w=46.725u l=1u
X3530 DVDD GATE BAT DVDD pfet_06v0 ad=43.9215p pd=95.32999u as=35.511p ps=48.245u w=46.725u l=1u
X3531 BAT GATE DVDD DVDD pfet_06v0 ad=58.1134p pd=77.985u as=71.8771p ps=0.15481m w=76.465u l=1u
X3532 BAT GATE DVDD DVDD pfet_06v0 ad=58.1172p pd=77.99u as=58.1172p ps=77.99u w=76.47u l=1u
X3533 DVDD GATE BAT DVDD pfet_06v0 ad=58.1134p pd=77.985u as=58.1134p ps=77.985u w=76.465u l=1u
X3534 DVDD GATE BAT DVDD pfet_06v0 ad=35.5072p pd=48.24u as=35.5072p ps=48.24u w=46.72u l=1u
X3535 DVDD GATE BAT DVDD pfet_06v0 ad=35.511p pd=48.245u as=35.511p ps=48.245u w=46.725u l=1u
X3536 DVDD GATE BAT DVDD pfet_06v0 ad=58.1134p pd=77.985u as=58.1134p ps=77.985u w=76.465u l=1u
X3537 BAT GATE DVDD DVDD pfet_06v0 ad=58.1134p pd=77.985u as=58.1134p ps=77.985u w=76.465u l=1u
X3538 DVDD GATE BAT DVDD pfet_06v0 ad=58.1552p pd=78.04u as=58.1552p ps=78.04u w=76.52u l=1u
X3539 DVDD GATE BAT DVDD pfet_06v0 ad=58.0754p pd=77.935u as=58.0754p ps=77.935u w=76.41499u l=1u
X3540 BAT GATE DVDD DVDD pfet_06v0 ad=47.6862p pd=64.265u as=58.9803p ps=0.12737m w=62.745u l=1u
X3541 BAT GATE DVDD DVDD pfet_06v0 ad=35.511p pd=48.245u as=35.511p ps=48.245u w=46.725u l=1u
X3542 DVDD GATE BAT DVDD pfet_06v0 ad=43.9215p pd=95.32999u as=35.511p ps=48.245u w=46.725u l=1u
X3543 BAT GATE DVDD DVDD pfet_06v0 ad=58.1552p pd=78.04u as=58.1552p ps=78.04u w=76.52u l=1u
X3544 BAT GATE DVDD DVDD pfet_06v0 ad=35.511p pd=48.245u as=35.511p ps=48.245u w=46.725u l=1u
X3545 BAT GATE DVDD DVDD pfet_06v0 ad=58.1134p pd=77.985u as=71.8771p ps=0.15481m w=76.465u l=1u
X3546 DVDD GATE BAT DVDD pfet_06v0 ad=35.511p pd=48.245u as=35.511p ps=48.245u w=46.725u l=1u
X3547 BAT GATE DVDD DVDD pfet_06v0 ad=35.511p pd=48.245u as=35.511p ps=48.245u w=46.725u l=1u
X3548 DVDD GATE BAT DVDD pfet_06v0 ad=35.511p pd=48.245u as=35.511p ps=48.245u w=46.725u l=1u
X3549 DVDD GATE BAT DVDD pfet_06v0 ad=35.511p pd=48.245u as=35.511p ps=48.245u w=46.725u l=1u
X3550 BAT GATE DVDD DVDD pfet_06v0 ad=58.1134p pd=77.985u as=58.1134p ps=77.985u w=76.465u l=1u
X3551 BAT GATE DVDD DVDD pfet_06v0 ad=58.1134p pd=77.985u as=58.1134p ps=77.985u w=76.465u l=1u
X3552 BAT GATE DVDD DVDD pfet_06v0 ad=35.511p pd=48.245u as=43.9215p ps=95.32999u w=46.725u l=1u
X3553 DVDD GATE BAT DVDD pfet_06v0 ad=58.1172p pd=77.99u as=58.1172p ps=77.99u w=76.47u l=1u
X3554 BAT GATE DVDD DVDD pfet_06v0 ad=35.511p pd=48.245u as=35.511p ps=48.245u w=46.725u l=1u
X3555 DVDD GATE BAT DVDD pfet_06v0 ad=47.6862p pd=64.265u as=47.6862p ps=64.265u w=62.745u l=1u
X3556 DVDD GATE BAT DVDD pfet_06v0 ad=58.1172p pd=77.99u as=58.1172p ps=77.99u w=76.47u l=1u
X3557 BAT GATE DVDD DVDD pfet_06v0 ad=35.5072p pd=48.24u as=43.9168p ps=95.32u w=46.72u l=1u
X3558 DVDD GATE BAT DVDD pfet_06v0 ad=35.511p pd=48.245u as=35.511p ps=48.245u w=46.725u l=1u
X3559 DVDD GATE BAT DVDD pfet_06v0 ad=58.1134p pd=77.985u as=58.1134p ps=77.985u w=76.465u l=1u
X3560 DVDD GATE BAT DVDD pfet_06v0 ad=58.1134p pd=77.985u as=58.1134p ps=77.985u w=76.465u l=1u
X3561 DVDD GATE BAT DVDD pfet_06v0 ad=71.92879p pd=0.15492m as=58.1552p ps=78.04u w=76.52u l=1u
X3562 DVDD GATE BAT DVDD pfet_06v0 ad=35.511p pd=48.245u as=35.511p ps=48.245u w=46.725u l=1u
X3563 DVDD GATE BAT DVDD pfet_06v0 ad=35.511p pd=48.245u as=35.511p ps=48.245u w=46.725u l=1u
X3564 BAT GATE DVDD DVDD pfet_06v0 ad=58.1134p pd=77.985u as=71.8771p ps=0.15481m w=76.465u l=1u
X3565 DVDD GATE BAT DVDD pfet_06v0 ad=58.1134p pd=77.985u as=58.1134p ps=77.985u w=76.465u l=1u
X3566 BAT GATE DVDD DVDD pfet_06v0 ad=35.511p pd=48.245u as=35.511p ps=48.245u w=46.725u l=1u
X3567 DVDD GATE BAT DVDD pfet_06v0 ad=35.511p pd=48.245u as=35.511p ps=48.245u w=46.725u l=1u
X3568 DVDD GATE BAT DVDD pfet_06v0 ad=71.8771p pd=0.15481m as=58.1134p ps=77.985u w=76.465u l=1u
X3569 DVDD GATE BAT DVDD pfet_06v0 ad=71.8771p pd=0.15481m as=58.1134p ps=77.985u w=76.465u l=1u
X3570 BAT GATE DVDD DVDD pfet_06v0 ad=35.511p pd=48.245u as=35.511p ps=48.245u w=46.725u l=1u
X3571 BAT GATE DVDD DVDD pfet_06v0 ad=58.1134p pd=77.985u as=58.1134p ps=77.985u w=76.465u l=1u
X3572 DVDD GATE BAT DVDD pfet_06v0 ad=35.511p pd=48.245u as=35.511p ps=48.245u w=46.725u l=1u
X3573 BAT GATE DVDD DVDD pfet_06v0 ad=49.3848p pd=66.5u as=49.3848p ps=66.5u w=64.98u l=1u
X3574 DVDD GATE BAT DVDD pfet_06v0 ad=58.0754p pd=77.935u as=58.0754p ps=77.935u w=76.41499u l=1u
X3575 DVDD GATE BAT DVDD pfet_06v0 ad=47.6862p pd=64.265u as=47.6862p ps=64.265u w=62.745u l=1u
X3576 DVDD GATE BAT DVDD pfet_06v0 ad=35.511p pd=48.245u as=35.511p ps=48.245u w=46.725u l=1u
X3577 BAT GATE DVDD DVDD pfet_06v0 ad=58.1134p pd=77.985u as=58.1134p ps=77.985u w=76.465u l=1u
X3578 DVDD GATE BAT DVDD pfet_06v0 ad=35.511p pd=48.245u as=35.511p ps=48.245u w=46.725u l=1u
X3579 DVDD GATE BAT DVDD pfet_06v0 ad=58.1134p pd=77.985u as=58.1134p ps=77.985u w=76.465u l=1u
X3580 BAT GATE DVDD DVDD pfet_06v0 ad=58.1172p pd=77.99u as=58.1172p ps=77.99u w=76.47u l=1u
X3581 BAT GATE DVDD DVDD pfet_06v0 ad=35.511p pd=48.245u as=43.9215p ps=95.32999u w=46.725u l=1u
X3582 DVDD GATE BAT DVDD pfet_06v0 ad=58.1096p pd=77.98u as=58.1096p ps=77.98u w=76.46u l=1u
X3583 DVDD GATE BAT DVDD pfet_06v0 ad=43.9215p pd=95.32999u as=35.511p ps=48.245u w=46.725u l=1u
X3584 DVDD GATE BAT DVDD pfet_06v0 ad=35.511p pd=48.245u as=35.511p ps=48.245u w=46.725u l=1u
X3585 DVDD GATE BAT DVDD pfet_06v0 ad=35.511p pd=48.245u as=35.511p ps=48.245u w=46.725u l=1u
X3586 DVDD GATE BAT DVDD pfet_06v0 ad=35.511p pd=48.245u as=35.511p ps=48.245u w=46.725u l=1u
X3587 BAT GATE DVDD DVDD pfet_06v0 ad=35.511p pd=48.245u as=35.511p ps=48.245u w=46.725u l=1u
X3588 BAT GATE DVDD DVDD pfet_06v0 ad=58.1096p pd=77.98u as=71.8724p ps=0.1548m w=76.46u l=1u
X3589 BAT GATE DVDD DVDD pfet_06v0 ad=35.511p pd=48.245u as=35.511p ps=48.245u w=46.725u l=1u
X3590 DVDD GATE BAT DVDD pfet_06v0 ad=35.511p pd=48.245u as=35.511p ps=48.245u w=46.725u l=1u
X3591 DVDD GATE BAT DVDD pfet_06v0 ad=47.6862p pd=64.265u as=47.6862p ps=64.265u w=62.745u l=1u
X3592 BAT GATE DVDD DVDD pfet_06v0 ad=35.511p pd=48.245u as=43.9215p ps=95.32999u w=46.725u l=1u
X3593 DVDD GATE BAT DVDD pfet_06v0 ad=35.5072p pd=48.24u as=35.5072p ps=48.24u w=46.72u l=1u
X3594 BAT GATE DVDD DVDD pfet_06v0 ad=58.1096p pd=77.98u as=58.1096p ps=77.98u w=76.46u l=1u
X3595 DVDD GATE BAT DVDD pfet_06v0 ad=58.1134p pd=77.985u as=58.1134p ps=77.985u w=76.465u l=1u
X3596 BAT GATE DVDD DVDD pfet_06v0 ad=58.1134p pd=77.985u as=58.1134p ps=77.985u w=76.465u l=1u
X3597 DVDD GATE BAT DVDD pfet_06v0 ad=35.511p pd=48.245u as=35.511p ps=48.245u w=46.725u l=1u
X3598 BAT GATE DVDD DVDD pfet_06v0 ad=35.511p pd=48.245u as=35.511p ps=48.245u w=46.725u l=1u
X3599 BAT GATE DVDD DVDD pfet_06v0 ad=35.5072p pd=48.24u as=43.9168p ps=95.32u w=46.72u l=1u
X3600 DVDD GATE BAT DVDD pfet_06v0 ad=71.8771p pd=0.15481m as=58.1134p ps=77.985u w=76.465u l=1u
X3601 BAT GATE DVDD DVDD pfet_06v0 ad=58.1552p pd=78.04u as=58.1552p ps=78.04u w=76.52u l=1u
X3602 DVDD GATE BAT DVDD pfet_06v0 ad=58.1134p pd=77.985u as=58.1134p ps=77.985u w=76.465u l=1u
X3603 DVDD GATE BAT DVDD pfet_06v0 ad=35.511p pd=48.245u as=35.511p ps=48.245u w=46.725u l=1u
X3604 DVDD GATE BAT DVDD pfet_06v0 ad=35.511p pd=48.245u as=35.511p ps=48.245u w=46.725u l=1u
X3605 BAT GATE DVDD DVDD pfet_06v0 ad=58.0754p pd=77.935u as=58.0754p ps=77.935u w=76.41499u l=1u
X3606 DVDD GATE BAT DVDD pfet_06v0 ad=58.1134p pd=77.985u as=58.1134p ps=77.985u w=76.465u l=1u
X3607 BAT GATE DVDD DVDD pfet_06v0 ad=35.511p pd=48.245u as=35.511p ps=48.245u w=46.725u l=1u
X3608 DVDD GATE BAT DVDD pfet_06v0 ad=43.9215p pd=95.32999u as=35.511p ps=48.245u w=46.725u l=1u
X3609 DVDD GATE BAT DVDD pfet_06v0 ad=58.1134p pd=77.985u as=58.1134p ps=77.985u w=76.465u l=1u
X3610 DVDD GATE BAT DVDD pfet_06v0 ad=35.511p pd=48.245u as=35.511p ps=48.245u w=46.725u l=1u
X3611 BAT GATE DVDD DVDD pfet_06v0 ad=35.511p pd=48.245u as=35.511p ps=48.245u w=46.725u l=1u
X3612 DVDD GATE BAT DVDD pfet_06v0 ad=58.1134p pd=77.985u as=58.1134p ps=77.985u w=76.465u l=1u
X3613 DVDD GATE BAT DVDD pfet_06v0 ad=58.1134p pd=77.985u as=58.1134p ps=77.985u w=76.465u l=1u
X3614 BAT GATE DVDD DVDD pfet_06v0 ad=58.0754p pd=77.935u as=58.0754p ps=77.935u w=76.41499u l=1u
X3615 DVDD GATE BAT DVDD pfet_06v0 ad=43.9215p pd=95.32999u as=35.511p ps=48.245u w=46.725u l=1u
X3616 BAT GATE DVDD DVDD pfet_06v0 ad=35.511p pd=48.245u as=43.9215p ps=95.32999u w=46.725u l=1u
X3617 DVDD GATE BAT DVDD pfet_06v0 ad=35.511p pd=48.245u as=35.511p ps=48.245u w=46.725u l=1u
X3618 DVDD GATE BAT DVDD pfet_06v0 ad=58.1096p pd=77.98u as=58.1096p ps=77.98u w=76.46u l=1u
X3619 DVDD GATE BAT DVDD pfet_06v0 ad=43.9215p pd=95.32999u as=35.511p ps=48.245u w=46.725u l=1u
X3620 DVDD GATE BAT DVDD pfet_06v0 ad=43.9215p pd=95.32999u as=35.511p ps=48.245u w=46.725u l=1u
X3621 DVDD GATE BAT DVDD pfet_06v0 ad=58.1134p pd=77.985u as=58.1134p ps=77.985u w=76.465u l=1u
X3622 BAT GATE DVDD DVDD pfet_06v0 ad=58.1134p pd=77.985u as=58.1134p ps=77.985u w=76.465u l=1u
X3623 DVDD GATE BAT DVDD pfet_06v0 ad=43.9215p pd=95.32999u as=35.511p ps=48.245u w=46.725u l=1u
X3624 BAT GATE DVDD DVDD pfet_06v0 ad=35.511p pd=48.245u as=35.511p ps=48.245u w=46.725u l=1u
X3625 DVDD GATE BAT DVDD pfet_06v0 ad=35.511p pd=48.245u as=35.511p ps=48.245u w=46.725u l=1u
X3626 BAT GATE DVDD DVDD pfet_06v0 ad=49.3848p pd=66.5u as=49.3848p ps=66.5u w=64.98u l=1u
X3627 DVDD GATE BAT DVDD pfet_06v0 ad=58.0754p pd=77.935u as=58.0754p ps=77.935u w=76.41499u l=1u
X3628 DVDD GATE BAT DVDD pfet_06v0 ad=35.5072p pd=48.24u as=35.5072p ps=48.24u w=46.72u l=1u
X3629 BAT GATE DVDD DVDD pfet_06v0 ad=35.511p pd=48.245u as=35.511p ps=48.245u w=46.725u l=1u
X3630 DVDD GATE BAT DVDD pfet_06v0 ad=43.9168p pd=95.32u as=35.5072p ps=48.24u w=46.72u l=1u
X3631 BAT GATE DVDD DVDD pfet_06v0 ad=35.511p pd=48.245u as=35.511p ps=48.245u w=46.725u l=1u
X3632 BAT GATE DVDD DVDD pfet_06v0 ad=47.6862p pd=64.265u as=47.6862p ps=64.265u w=62.745u l=1u
X3633 BAT GATE DVDD DVDD pfet_06v0 ad=58.1096p pd=77.98u as=58.1096p ps=77.98u w=76.46u l=1u
X3634 BAT GATE DVDD DVDD pfet_06v0 ad=35.511p pd=48.245u as=35.511p ps=48.245u w=46.725u l=1u
X3635 DVDD GATE BAT DVDD pfet_06v0 ad=58.1134p pd=77.985u as=58.1134p ps=77.985u w=76.465u l=1u
X3636 BAT GATE DVDD DVDD pfet_06v0 ad=35.5072p pd=48.24u as=35.5072p ps=48.24u w=46.72u l=1u
X3637 DVDD GATE BAT DVDD pfet_06v0 ad=35.511p pd=48.245u as=35.511p ps=48.245u w=46.725u l=1u
X3638 DVDD GATE BAT DVDD pfet_06v0 ad=35.511p pd=48.245u as=35.511p ps=48.245u w=46.725u l=1u
X3639 BAT GATE DVDD DVDD pfet_06v0 ad=58.1134p pd=77.985u as=58.1134p ps=77.985u w=76.465u l=1u
X3640 BAT GATE DVDD DVDD pfet_06v0 ad=58.1134p pd=77.985u as=58.1134p ps=77.985u w=76.465u l=1u
X3641 DVDD GATE BAT DVDD pfet_06v0 ad=71.8771p pd=0.15481m as=58.1134p ps=77.985u w=76.465u l=1u
X3642 BAT GATE DVDD DVDD pfet_06v0 ad=35.511p pd=48.245u as=35.511p ps=48.245u w=46.725u l=1u
X3643 DVDD GATE BAT DVDD pfet_06v0 ad=58.1172p pd=77.99u as=58.1172p ps=77.99u w=76.47u l=1u
X3644 DVDD GATE BAT DVDD pfet_06v0 ad=35.511p pd=48.245u as=35.511p ps=48.245u w=46.725u l=1u
X3645 DVDD GATE BAT DVDD pfet_06v0 ad=71.8818p pd=0.15482m as=58.1172p ps=77.99u w=76.47u l=1u
X3646 DVDD GATE BAT DVDD pfet_06v0 ad=35.511p pd=48.245u as=35.511p ps=48.245u w=46.725u l=1u
X3647 BAT GATE DVDD DVDD pfet_06v0 ad=58.1134p pd=77.985u as=58.1134p ps=77.985u w=76.465u l=1u
X3648 BAT GATE DVDD DVDD pfet_06v0 ad=58.1134p pd=77.985u as=58.1134p ps=77.985u w=76.465u l=1u
X3649 BAT GATE DVDD DVDD pfet_06v0 ad=58.1134p pd=77.985u as=58.1134p ps=77.985u w=76.465u l=1u
X3650 BAT GATE DVDD DVDD pfet_06v0 ad=58.1134p pd=77.985u as=58.1134p ps=77.985u w=76.465u l=1u
X3651 DVDD GATE BAT DVDD pfet_06v0 ad=58.1096p pd=77.98u as=58.1096p ps=77.98u w=76.46u l=1u
X3652 DVDD GATE BAT DVDD pfet_06v0 ad=49.3848p pd=66.5u as=49.3848p ps=66.5u w=64.98u l=1u
X3653 BAT GATE DVDD DVDD pfet_06v0 ad=35.511p pd=48.245u as=35.511p ps=48.245u w=46.725u l=1u
X3654 DVDD GATE BAT DVDD pfet_06v0 ad=71.8771p pd=0.15481m as=58.1134p ps=77.985u w=76.465u l=1u
X3655 BAT GATE DVDD DVDD pfet_06v0 ad=35.511p pd=48.245u as=43.9215p ps=95.32999u w=46.725u l=1u
X3656 DVDD GATE BAT DVDD pfet_06v0 ad=58.1134p pd=77.985u as=58.1134p ps=77.985u w=76.465u l=1u
X3657 DVDD GATE BAT DVDD pfet_06v0 ad=71.8771p pd=0.15481m as=58.1134p ps=77.985u w=76.465u l=1u
X3658 BAT GATE DVDD DVDD pfet_06v0 ad=35.511p pd=48.245u as=35.511p ps=48.245u w=46.725u l=1u
X3659 BAT GATE DVDD DVDD pfet_06v0 ad=58.1552p pd=78.04u as=71.92879p ps=0.15492m w=76.52u l=1u
X3660 BAT GATE DVDD DVDD pfet_06v0 ad=58.1134p pd=77.985u as=58.1134p ps=77.985u w=76.465u l=1u
X3661 DVDD GATE BAT DVDD pfet_06v0 ad=35.511p pd=48.245u as=35.511p ps=48.245u w=46.725u l=1u
X3662 BAT GATE DVDD DVDD pfet_06v0 ad=58.0754p pd=77.935u as=58.0754p ps=77.935u w=76.41499u l=1u
X3663 BAT GATE DVDD DVDD pfet_06v0 ad=47.6862p pd=64.265u as=58.9803p ps=0.12737m w=62.745u l=1u
X3664 DVDD GATE BAT DVDD pfet_06v0 ad=35.511p pd=48.245u as=35.511p ps=48.245u w=46.725u l=1u
X3665 DVDD GATE BAT DVDD pfet_06v0 ad=58.1134p pd=77.985u as=58.1134p ps=77.985u w=76.465u l=1u
X3666 DVDD GATE BAT DVDD pfet_06v0 ad=35.511p pd=48.245u as=35.511p ps=48.245u w=46.725u l=1u
X3667 BAT GATE DVDD DVDD pfet_06v0 ad=58.1134p pd=77.985u as=58.1134p ps=77.985u w=76.465u l=1u
X3668 DVDD GATE BAT DVDD pfet_06v0 ad=43.9215p pd=95.32999u as=35.511p ps=48.245u w=46.725u l=1u
X3669 BAT GATE DVDD DVDD pfet_06v0 ad=58.1552p pd=78.04u as=58.1552p ps=78.04u w=76.52u l=1u
X3670 BAT GATE DVDD DVDD pfet_06v0 ad=35.511p pd=48.245u as=35.511p ps=48.245u w=46.725u l=1u
X3671 BAT GATE DVDD DVDD pfet_06v0 ad=58.1134p pd=77.985u as=58.1134p ps=77.985u w=76.465u l=1u
X3672 BAT GATE DVDD DVDD pfet_06v0 ad=35.511p pd=48.245u as=35.511p ps=48.245u w=46.725u l=1u
X3673 DVDD GATE BAT DVDD pfet_06v0 ad=35.511p pd=48.245u as=35.511p ps=48.245u w=46.725u l=1u
X3674 DVDD GATE BAT DVDD pfet_06v0 ad=58.1172p pd=77.99u as=58.1172p ps=77.99u w=76.47u l=1u
X3675 BAT GATE DVDD DVDD pfet_06v0 ad=58.1134p pd=77.985u as=58.1134p ps=77.985u w=76.465u l=1u
X3676 DVDD GATE BAT DVDD pfet_06v0 ad=58.1552p pd=78.04u as=58.1552p ps=78.04u w=76.52u l=1u
X3677 BAT GATE DVDD DVDD pfet_06v0 ad=58.1134p pd=77.985u as=58.1134p ps=77.985u w=76.465u l=1u
X3678 BAT GATE DVDD DVDD pfet_06v0 ad=47.6862p pd=64.265u as=47.6862p ps=64.265u w=62.745u l=1u
X3679 BAT GATE DVDD DVDD pfet_06v0 ad=35.511p pd=48.245u as=43.9215p ps=95.32999u w=46.725u l=1u
X3680 DVDD GATE BAT DVDD pfet_06v0 ad=43.9215p pd=95.32999u as=35.511p ps=48.245u w=46.725u l=1u
X3681 BAT GATE DVDD DVDD pfet_06v0 ad=58.1134p pd=77.985u as=58.1134p ps=77.985u w=76.465u l=1u
X3682 DVDD GATE BAT DVDD pfet_06v0 ad=58.1134p pd=77.985u as=58.1134p ps=77.985u w=76.465u l=1u
X3683 BAT GATE DVDD DVDD pfet_06v0 ad=35.511p pd=48.245u as=43.9215p ps=95.32999u w=46.725u l=1u
X3684 BAT GATE DVDD DVDD pfet_06v0 ad=35.511p pd=48.245u as=43.9215p ps=95.32999u w=46.725u l=1u
X3685 DVDD GATE BAT DVDD pfet_06v0 ad=35.511p pd=48.245u as=35.511p ps=48.245u w=46.725u l=1u
X3686 BAT GATE DVDD DVDD pfet_06v0 ad=58.1134p pd=77.985u as=58.1134p ps=77.985u w=76.465u l=1u
X3687 DVDD GATE BAT DVDD pfet_06v0 ad=58.1134p pd=77.985u as=58.1134p ps=77.985u w=76.465u l=1u
X3688 BAT GATE DVDD DVDD pfet_06v0 ad=35.511p pd=48.245u as=35.511p ps=48.245u w=46.725u l=1u
X3689 DVDD GATE BAT DVDD pfet_06v0 ad=35.511p pd=48.245u as=35.511p ps=48.245u w=46.725u l=1u
X3690 BAT GATE DVDD DVDD pfet_06v0 ad=58.1096p pd=77.98u as=58.1096p ps=77.98u w=76.46u l=1u
X3691 DVDD GATE BAT DVDD pfet_06v0 ad=58.1134p pd=77.985u as=58.1134p ps=77.985u w=76.465u l=1u
X3692 DVDD GATE BAT DVDD pfet_06v0 ad=58.1552p pd=78.04u as=58.1552p ps=78.04u w=76.52u l=1u
X3693 BAT GATE DVDD DVDD pfet_06v0 ad=58.1134p pd=77.985u as=71.8771p ps=0.15481m w=76.465u l=1u
X3694 BAT GATE DVDD DVDD pfet_06v0 ad=35.511p pd=48.245u as=35.511p ps=48.245u w=46.725u l=1u
X3695 DVDD GATE BAT DVDD pfet_06v0 ad=58.1172p pd=77.99u as=58.1172p ps=77.99u w=76.47u l=1u
X3696 DVDD GATE BAT DVDD pfet_06v0 ad=71.8771p pd=0.15481m as=58.1134p ps=77.985u w=76.465u l=1u
X3697 DVDD GATE BAT DVDD pfet_06v0 ad=58.1172p pd=77.99u as=58.1172p ps=77.99u w=76.47u l=1u
X3698 BAT GATE DVDD DVDD pfet_06v0 ad=35.511p pd=48.245u as=35.511p ps=48.245u w=46.725u l=1u
X3699 DVDD GATE BAT DVDD pfet_06v0 ad=71.8771p pd=0.15481m as=58.1134p ps=77.985u w=76.465u l=1u
X3700 BAT GATE DVDD DVDD pfet_06v0 ad=35.511p pd=48.245u as=43.9215p ps=95.32999u w=46.725u l=1u
X3701 DVDD GATE BAT DVDD pfet_06v0 ad=58.1134p pd=77.985u as=58.1134p ps=77.985u w=76.465u l=1u
X3702 BAT GATE DVDD DVDD pfet_06v0 ad=35.511p pd=48.245u as=43.9215p ps=95.32999u w=46.725u l=1u
X3703 DVDD GATE BAT DVDD pfet_06v0 ad=71.8771p pd=0.15481m as=58.1134p ps=77.985u w=76.465u l=1u
X3704 BAT GATE DVDD DVDD pfet_06v0 ad=58.1134p pd=77.985u as=58.1134p ps=77.985u w=76.465u l=1u
X3705 BAT GATE DVDD DVDD pfet_06v0 ad=35.511p pd=48.245u as=35.511p ps=48.245u w=46.725u l=1u
X3706 BAT GATE DVDD DVDD pfet_06v0 ad=49.3848p pd=66.5u as=49.3848p ps=66.5u w=64.98u l=1u
X3707 BAT GATE DVDD DVDD pfet_06v0 ad=58.0754p pd=77.935u as=58.0754p ps=77.935u w=76.41499u l=1u
X3708 BAT GATE DVDD DVDD pfet_06v0 ad=47.6862p pd=64.265u as=58.9803p ps=0.12737m w=62.745u l=1u
X3709 DVDD GATE BAT DVDD pfet_06v0 ad=58.1552p pd=78.04u as=58.1552p ps=78.04u w=76.52u l=1u
X3710 BAT GATE DVDD DVDD pfet_06v0 ad=35.511p pd=48.245u as=35.511p ps=48.245u w=46.725u l=1u
X3711 BAT GATE DVDD DVDD pfet_06v0 ad=58.1134p pd=77.985u as=71.8771p ps=0.15481m w=76.465u l=1u
X3712 BAT GATE DVDD DVDD pfet_06v0 ad=35.511p pd=48.245u as=35.511p ps=48.245u w=46.725u l=1u
X3713 DVDD GATE BAT DVDD pfet_06v0 ad=35.511p pd=48.245u as=35.511p ps=48.245u w=46.725u l=1u
X3714 BAT GATE DVDD DVDD pfet_06v0 ad=58.1134p pd=77.985u as=58.1134p ps=77.985u w=76.465u l=1u
X3715 DVDD GATE BAT DVDD pfet_06v0 ad=58.0754p pd=77.935u as=58.0754p ps=77.935u w=76.41499u l=1u
X3716 DVDD GATE BAT DVDD pfet_06v0 ad=58.1552p pd=78.04u as=58.1552p ps=78.04u w=76.52u l=1u
X3717 DVDD GATE BAT DVDD pfet_06v0 ad=58.1096p pd=77.98u as=58.1096p ps=77.98u w=76.46u l=1u
X3718 BAT GATE DVDD DVDD pfet_06v0 ad=58.1134p pd=77.985u as=58.1134p ps=77.985u w=76.465u l=1u
X3719 BAT GATE DVDD DVDD pfet_06v0 ad=47.6862p pd=64.265u as=47.6862p ps=64.265u w=62.745u l=1u
X3720 BAT GATE DVDD DVDD pfet_06v0 ad=35.511p pd=48.245u as=35.511p ps=48.245u w=46.725u l=1u
X3721 BAT GATE DVDD DVDD pfet_06v0 ad=35.511p pd=48.245u as=35.511p ps=48.245u w=46.725u l=1u
X3722 DVDD GATE BAT DVDD pfet_06v0 ad=35.511p pd=48.245u as=35.511p ps=48.245u w=46.725u l=1u
X3723 BAT GATE DVDD DVDD pfet_06v0 ad=58.1134p pd=77.985u as=58.1134p ps=77.985u w=76.465u l=1u
X3724 DVDD GATE BAT DVDD pfet_06v0 ad=35.511p pd=48.245u as=35.511p ps=48.245u w=46.725u l=1u
X3725 BAT GATE DVDD DVDD pfet_06v0 ad=58.1134p pd=77.985u as=58.1134p ps=77.985u w=76.465u l=1u
X3726 BAT GATE DVDD DVDD pfet_06v0 ad=58.1134p pd=77.985u as=71.8771p ps=0.15481m w=76.465u l=1u
X3727 DVDD GATE BAT DVDD pfet_06v0 ad=58.0754p pd=77.935u as=58.0754p ps=77.935u w=76.41499u l=1u
X3728 DVDD GATE BAT DVDD pfet_06v0 ad=49.3848p pd=66.5u as=49.3848p ps=66.5u w=64.98u l=1u
X3729 BAT GATE DVDD DVDD pfet_06v0 ad=58.1096p pd=77.98u as=58.1096p ps=77.98u w=76.46u l=1u
X3730 BAT GATE DVDD DVDD pfet_06v0 ad=35.511p pd=48.245u as=35.511p ps=48.245u w=46.725u l=1u
X3731 DVDD GATE BAT DVDD pfet_06v0 ad=35.5072p pd=48.24u as=35.5072p ps=48.24u w=46.72u l=1u
X3732 BAT GATE DVDD DVDD pfet_06v0 ad=58.0754p pd=77.935u as=71.8301p ps=0.15471m w=76.41499u l=1u
X3733 BAT GATE DVDD DVDD pfet_06v0 ad=35.511p pd=48.245u as=35.511p ps=48.245u w=46.725u l=1u
X3734 DVDD GATE BAT DVDD pfet_06v0 ad=71.8771p pd=0.15481m as=58.1134p ps=77.985u w=76.465u l=1u
X3735 DVDD GATE BAT DVDD pfet_06v0 ad=43.9215p pd=95.32999u as=35.511p ps=48.245u w=46.725u l=1u
X3736 BAT GATE DVDD DVDD pfet_06v0 ad=49.3848p pd=66.5u as=49.3848p ps=66.5u w=64.98u l=1u
X3737 DVDD GATE BAT DVDD pfet_06v0 ad=58.1134p pd=77.985u as=58.1134p ps=77.985u w=76.465u l=1u
X3738 BAT GATE DVDD DVDD pfet_06v0 ad=58.1096p pd=77.98u as=58.1096p ps=77.98u w=76.46u l=1u
X3739 DVDD GATE BAT DVDD pfet_06v0 ad=35.5072p pd=48.24u as=35.5072p ps=48.24u w=46.72u l=1u
X3740 BAT GATE DVDD DVDD pfet_06v0 ad=35.511p pd=48.245u as=35.511p ps=48.245u w=46.725u l=1u
X3741 DVDD GATE BAT DVDD pfet_06v0 ad=43.9168p pd=95.32u as=35.5072p ps=48.24u w=46.72u l=1u
X3742 DVDD GATE BAT DVDD pfet_06v0 ad=35.511p pd=48.245u as=35.511p ps=48.245u w=46.725u l=1u
X3743 BAT GATE DVDD DVDD pfet_06v0 ad=49.3848p pd=66.5u as=49.3848p ps=66.5u w=64.98u l=1u
X3744 BAT GATE DVDD DVDD pfet_06v0 ad=35.511p pd=48.245u as=35.511p ps=48.245u w=46.725u l=1u
X3745 DVDD GATE BAT DVDD pfet_06v0 ad=58.1096p pd=77.98u as=58.1096p ps=77.98u w=76.46u l=1u
X3746 BAT GATE DVDD DVDD pfet_06v0 ad=35.5072p pd=48.24u as=35.5072p ps=48.24u w=46.72u l=1u
X3747 DVDD GATE BAT DVDD pfet_06v0 ad=47.6862p pd=64.265u as=47.6862p ps=64.265u w=62.745u l=1u
X3748 BAT GATE DVDD DVDD pfet_06v0 ad=35.511p pd=48.245u as=35.511p ps=48.245u w=46.725u l=1u
X3749 BAT GATE DVDD DVDD pfet_06v0 ad=58.0754p pd=77.935u as=58.0754p ps=77.935u w=76.41499u l=1u
X3750 DVDD GATE BAT DVDD pfet_06v0 ad=43.9215p pd=95.32999u as=35.511p ps=48.245u w=46.725u l=1u
X3751 DVDD GATE BAT DVDD pfet_06v0 ad=35.511p pd=48.245u as=35.511p ps=48.245u w=46.725u l=1u
X3752 DVDD GATE BAT DVDD pfet_06v0 ad=47.6862p pd=64.265u as=47.6862p ps=64.265u w=62.745u l=1u
X3753 BAT GATE DVDD DVDD pfet_06v0 ad=58.1134p pd=77.985u as=58.1134p ps=77.985u w=76.465u l=1u
X3754 BAT GATE DVDD DVDD pfet_06v0 ad=58.1134p pd=77.985u as=58.1134p ps=77.985u w=76.465u l=1u
X3755 BAT GATE DVDD DVDD pfet_06v0 ad=58.1172p pd=77.99u as=58.1172p ps=77.99u w=76.47u l=1u
X3756 DVDD GATE BAT DVDD pfet_06v0 ad=35.511p pd=48.245u as=35.511p ps=48.245u w=46.725u l=1u
X3757 BAT GATE DVDD DVDD pfet_06v0 ad=35.511p pd=48.245u as=43.9215p ps=95.32999u w=46.725u l=1u
X3758 DVDD GATE BAT DVDD pfet_06v0 ad=58.1134p pd=77.985u as=58.1134p ps=77.985u w=76.465u l=1u
X3759 DVDD GATE BAT DVDD pfet_06v0 ad=58.1134p pd=77.985u as=58.1134p ps=77.985u w=76.465u l=1u
X3760 DVDD GATE BAT DVDD pfet_06v0 ad=47.6862p pd=64.265u as=47.6862p ps=64.265u w=62.745u l=1u
X3761 BAT GATE DVDD DVDD pfet_06v0 ad=35.511p pd=48.245u as=35.511p ps=48.245u w=46.725u l=1u
X3762 DVDD GATE BAT DVDD pfet_06v0 ad=35.511p pd=48.245u as=35.511p ps=48.245u w=46.725u l=1u
X3763 DVDD GATE BAT DVDD pfet_06v0 ad=58.1134p pd=77.985u as=58.1134p ps=77.985u w=76.465u l=1u
X3764 BAT GATE DVDD DVDD pfet_06v0 ad=58.1134p pd=77.985u as=58.1134p ps=77.985u w=76.465u l=1u
X3765 DVDD GATE BAT DVDD pfet_06v0 ad=47.6862p pd=64.265u as=47.6862p ps=64.265u w=62.745u l=1u
X3766 DVDD GATE BAT DVDD pfet_06v0 ad=35.511p pd=48.245u as=35.511p ps=48.245u w=46.725u l=1u
X3767 DVDD GATE BAT DVDD pfet_06v0 ad=35.511p pd=48.245u as=35.511p ps=48.245u w=46.725u l=1u
X3768 DVDD GATE BAT DVDD pfet_06v0 ad=35.5072p pd=48.24u as=35.5072p ps=48.24u w=46.72u l=1u
X3769 BAT GATE DVDD DVDD pfet_06v0 ad=58.1172p pd=77.99u as=58.1172p ps=77.99u w=76.47u l=1u
X3770 BAT GATE DVDD DVDD pfet_06v0 ad=47.6862p pd=64.265u as=47.6862p ps=64.265u w=62.745u l=1u
X3771 BAT GATE DVDD DVDD pfet_06v0 ad=58.1134p pd=77.985u as=71.8771p ps=0.15481m w=76.465u l=1u
X3772 DVDD GATE BAT DVDD pfet_06v0 ad=58.1134p pd=77.985u as=58.1134p ps=77.985u w=76.465u l=1u
X3773 BAT GATE DVDD DVDD pfet_06v0 ad=58.1134p pd=77.985u as=58.1134p ps=77.985u w=76.465u l=1u
X3774 DVDD GATE BAT DVDD pfet_06v0 ad=58.1134p pd=77.985u as=58.1134p ps=77.985u w=76.465u l=1u
X3775 BAT GATE DVDD DVDD pfet_06v0 ad=58.1134p pd=77.985u as=58.1134p ps=77.985u w=76.465u l=1u
X3776 BAT GATE DVDD DVDD pfet_06v0 ad=58.1096p pd=77.98u as=71.8724p ps=0.1548m w=76.46u l=1u
X3777 DVDD GATE BAT DVDD pfet_06v0 ad=35.511p pd=48.245u as=35.511p ps=48.245u w=46.725u l=1u
X3778 DVDD GATE BAT DVDD pfet_06v0 ad=58.1134p pd=77.985u as=58.1134p ps=77.985u w=76.465u l=1u
X3779 DVDD GATE BAT DVDD pfet_06v0 ad=58.1172p pd=77.99u as=58.1172p ps=77.99u w=76.47u l=1u
X3780 DVDD GATE BAT DVDD pfet_06v0 ad=35.511p pd=48.245u as=35.511p ps=48.245u w=46.725u l=1u
X3781 BAT GATE DVDD DVDD pfet_06v0 ad=58.1134p pd=77.985u as=58.1134p ps=77.985u w=76.465u l=1u
X3782 DVDD GATE BAT DVDD pfet_06v0 ad=58.1134p pd=77.985u as=58.1134p ps=77.985u w=76.465u l=1u
X3783 BAT GATE DVDD DVDD pfet_06v0 ad=35.511p pd=48.245u as=35.511p ps=48.245u w=46.725u l=1u
X3784 BAT GATE DVDD DVDD pfet_06v0 ad=58.1134p pd=77.985u as=58.1134p ps=77.985u w=76.465u l=1u
X3785 DVDD GATE BAT DVDD pfet_06v0 ad=35.511p pd=48.245u as=35.511p ps=48.245u w=46.725u l=1u
X3786 DVDD GATE BAT DVDD pfet_06v0 ad=58.1134p pd=77.985u as=58.1134p ps=77.985u w=76.465u l=1u
X3787 DVDD GATE BAT DVDD pfet_06v0 ad=71.8818p pd=0.15482m as=58.1172p ps=77.99u w=76.47u l=1u
X3788 BAT GATE DVDD DVDD pfet_06v0 ad=35.511p pd=48.245u as=43.9215p ps=95.32999u w=46.725u l=1u
X3789 BAT GATE DVDD DVDD pfet_06v0 ad=35.511p pd=48.245u as=43.9215p ps=95.32999u w=46.725u l=1u
X3790 DVDD GATE BAT DVDD pfet_06v0 ad=47.6862p pd=64.265u as=47.6862p ps=64.265u w=62.745u l=1u
X3791 BAT GATE DVDD DVDD pfet_06v0 ad=58.1134p pd=77.985u as=58.1134p ps=77.985u w=76.465u l=1u
X3792 BAT GATE DVDD DVDD pfet_06v0 ad=35.511p pd=48.245u as=35.511p ps=48.245u w=46.725u l=1u
X3793 BAT GATE DVDD DVDD pfet_06v0 ad=35.5072p pd=48.24u as=35.5072p ps=48.24u w=46.72u l=1u
X3794 BAT GATE DVDD DVDD pfet_06v0 ad=58.1134p pd=77.985u as=58.1134p ps=77.985u w=76.465u l=1u
X3795 DVDD GATE BAT DVDD pfet_06v0 ad=35.511p pd=48.245u as=35.511p ps=48.245u w=46.725u l=1u
X3796 DVDD GATE BAT DVDD pfet_06v0 ad=43.9215p pd=95.32999u as=35.511p ps=48.245u w=46.725u l=1u
X3797 BAT GATE DVDD DVDD pfet_06v0 ad=35.511p pd=48.245u as=35.511p ps=48.245u w=46.725u l=1u
X3798 DVDD GATE BAT DVDD pfet_06v0 ad=71.8771p pd=0.15481m as=58.1134p ps=77.985u w=76.465u l=1u
X3799 DVDD GATE BAT DVDD pfet_06v0 ad=35.511p pd=48.245u as=35.511p ps=48.245u w=46.725u l=1u
X3800 BAT GATE DVDD DVDD pfet_06v0 ad=58.1172p pd=77.99u as=71.8818p ps=0.15482m w=76.47u l=1u
X3801 BAT GATE DVDD DVDD pfet_06v0 ad=35.511p pd=48.245u as=43.9215p ps=95.32999u w=46.725u l=1u
X3802 DVDD GATE BAT DVDD pfet_06v0 ad=58.1134p pd=77.985u as=58.1134p ps=77.985u w=76.465u l=1u
X3803 BAT GATE DVDD DVDD pfet_06v0 ad=58.1552p pd=78.04u as=58.1552p ps=78.04u w=76.52u l=1u
X3804 DVDD GATE BAT DVDD pfet_06v0 ad=58.1134p pd=77.985u as=58.1134p ps=77.985u w=76.465u l=1u
X3805 BAT GATE DVDD DVDD pfet_06v0 ad=35.511p pd=48.245u as=35.511p ps=48.245u w=46.725u l=1u
X3806 BAT GATE DVDD DVDD pfet_06v0 ad=35.511p pd=48.245u as=35.511p ps=48.245u w=46.725u l=1u
X3807 DVDD GATE BAT DVDD pfet_06v0 ad=47.6862p pd=64.265u as=47.6862p ps=64.265u w=62.745u l=1u
X3808 BAT GATE DVDD DVDD pfet_06v0 ad=58.1134p pd=77.985u as=58.1134p ps=77.985u w=76.465u l=1u
X3809 BAT GATE DVDD DVDD pfet_06v0 ad=58.1134p pd=77.985u as=71.8771p ps=0.15481m w=76.465u l=1u
X3810 DVDD GATE BAT DVDD pfet_06v0 ad=58.1134p pd=77.985u as=58.1134p ps=77.985u w=76.465u l=1u
X3811 DVDD GATE BAT DVDD pfet_06v0 ad=43.9215p pd=95.32999u as=35.511p ps=48.245u w=46.725u l=1u
X3812 DVDD GATE BAT DVDD pfet_06v0 ad=58.1096p pd=77.98u as=58.1096p ps=77.98u w=76.46u l=1u
X3813 BAT GATE DVDD DVDD pfet_06v0 ad=58.1552p pd=78.04u as=58.1552p ps=78.04u w=76.52u l=1u
X3814 BAT GATE DVDD DVDD pfet_06v0 ad=58.1134p pd=77.985u as=58.1134p ps=77.985u w=76.465u l=1u
X3815 DVDD GATE BAT DVDD pfet_06v0 ad=35.511p pd=48.245u as=35.511p ps=48.245u w=46.725u l=1u
X3816 BAT GATE DVDD DVDD pfet_06v0 ad=58.1134p pd=77.985u as=71.8771p ps=0.15481m w=76.465u l=1u
X3817 BAT GATE DVDD DVDD pfet_06v0 ad=58.1134p pd=77.985u as=58.1134p ps=77.985u w=76.465u l=1u
X3818 DVDD GATE BAT DVDD pfet_06v0 ad=35.511p pd=48.245u as=35.511p ps=48.245u w=46.725u l=1u
X3819 BAT GATE DVDD DVDD pfet_06v0 ad=58.1096p pd=77.98u as=58.1096p ps=77.98u w=76.46u l=1u
X3820 DVDD GATE BAT DVDD pfet_06v0 ad=58.1134p pd=77.985u as=58.1134p ps=77.985u w=76.465u l=1u
X3821 DVDD GATE BAT DVDD pfet_06v0 ad=49.3848p pd=66.5u as=49.3848p ps=66.5u w=64.98u l=1u
X3822 DVDD GATE BAT DVDD pfet_06v0 ad=43.9215p pd=95.32999u as=35.511p ps=48.245u w=46.725u l=1u
X3823 DVDD GATE BAT DVDD pfet_06v0 ad=58.0754p pd=77.935u as=58.0754p ps=77.935u w=76.41499u l=1u
X3824 DVDD GATE BAT DVDD pfet_06v0 ad=49.3848p pd=66.5u as=49.3848p ps=66.5u w=64.98u l=1u
X3825 BAT GATE DVDD DVDD pfet_06v0 ad=58.1552p pd=78.04u as=58.1552p ps=78.04u w=76.52u l=1u
X3826 BAT GATE DVDD DVDD pfet_06v0 ad=58.1134p pd=77.985u as=58.1134p ps=77.985u w=76.465u l=1u
X3827 DVDD GATE BAT DVDD pfet_06v0 ad=58.1172p pd=77.99u as=58.1172p ps=77.99u w=76.47u l=1u
X3828 BAT GATE DVDD DVDD pfet_06v0 ad=35.511p pd=48.245u as=35.511p ps=48.245u w=46.725u l=1u
X3829 DVDD GATE BAT DVDD pfet_06v0 ad=58.1134p pd=77.985u as=58.1134p ps=77.985u w=76.465u l=1u
X3830 BAT GATE DVDD DVDD pfet_06v0 ad=35.511p pd=48.245u as=35.511p ps=48.245u w=46.725u l=1u
X3831 DVDD GATE BAT DVDD pfet_06v0 ad=71.8301p pd=0.15471m as=58.0754p ps=77.935u w=76.41499u l=1u
X3832 BAT GATE DVDD DVDD pfet_06v0 ad=35.5072p pd=48.24u as=35.5072p ps=48.24u w=46.72u l=1u
X3833 BAT GATE DVDD DVDD pfet_06v0 ad=35.511p pd=48.245u as=35.511p ps=48.245u w=46.725u l=1u
X3834 BAT GATE DVDD DVDD pfet_06v0 ad=47.6862p pd=64.265u as=47.6862p ps=64.265u w=62.745u l=1u
X3835 DVDD GATE BAT DVDD pfet_06v0 ad=58.1134p pd=77.985u as=58.1134p ps=77.985u w=76.465u l=1u
X3836 BAT GATE DVDD DVDD pfet_06v0 ad=35.511p pd=48.245u as=35.511p ps=48.245u w=46.725u l=1u
X3837 BAT GATE DVDD DVDD pfet_06v0 ad=58.0754p pd=77.935u as=58.0754p ps=77.935u w=76.41499u l=1u
X3838 BAT GATE DVDD DVDD pfet_06v0 ad=58.1134p pd=77.985u as=58.1134p ps=77.985u w=76.465u l=1u
X3839 BAT GATE DVDD DVDD pfet_06v0 ad=58.1096p pd=77.98u as=58.1096p ps=77.98u w=76.46u l=1u
X3840 DVDD GATE BAT DVDD pfet_06v0 ad=71.8771p pd=0.15481m as=58.1134p ps=77.985u w=76.465u l=1u
X3841 DVDD GATE BAT DVDD pfet_06v0 ad=35.511p pd=48.245u as=35.511p ps=48.245u w=46.725u l=1u
X3842 DVDD GATE BAT DVDD pfet_06v0 ad=47.6862p pd=64.265u as=47.6862p ps=64.265u w=62.745u l=1u
X3843 BAT GATE DVDD DVDD pfet_06v0 ad=58.1134p pd=77.985u as=58.1134p ps=77.985u w=76.465u l=1u
X3844 BAT GATE DVDD DVDD pfet_06v0 ad=35.5072p pd=48.24u as=35.5072p ps=48.24u w=46.72u l=1u
X3845 DVDD GATE BAT DVDD pfet_06v0 ad=58.9803p pd=0.12737m as=47.6862p ps=64.265u w=62.745u l=1u
X3846 DVDD GATE BAT DVDD pfet_06v0 ad=58.1134p pd=77.985u as=58.1134p ps=77.985u w=76.465u l=1u
X3847 DVDD GATE BAT DVDD pfet_06v0 ad=58.1134p pd=77.985u as=58.1134p ps=77.985u w=76.465u l=1u
X3848 DVDD GATE BAT DVDD pfet_06v0 ad=35.511p pd=48.245u as=35.511p ps=48.245u w=46.725u l=1u
X3849 DVDD GATE BAT DVDD pfet_06v0 ad=43.9215p pd=95.32999u as=35.511p ps=48.245u w=46.725u l=1u
X3850 BAT GATE DVDD DVDD pfet_06v0 ad=35.5072p pd=48.24u as=35.5072p ps=48.24u w=46.72u l=1u
X3851 BAT GATE DVDD DVDD pfet_06v0 ad=58.1134p pd=77.985u as=58.1134p ps=77.985u w=76.465u l=1u
X3852 DVDD GATE BAT DVDD pfet_06v0 ad=35.511p pd=48.245u as=35.511p ps=48.245u w=46.725u l=1u
X3853 DVDD GATE BAT DVDD pfet_06v0 ad=49.3848p pd=66.5u as=49.3848p ps=66.5u w=64.98u l=1u
X3854 BAT GATE DVDD DVDD pfet_06v0 ad=35.511p pd=48.245u as=35.511p ps=48.245u w=46.725u l=1u
X3855 DVDD GATE BAT DVDD pfet_06v0 ad=35.511p pd=48.245u as=35.511p ps=48.245u w=46.725u l=1u
X3856 BAT GATE DVDD DVDD pfet_06v0 ad=35.5072p pd=48.24u as=35.5072p ps=48.24u w=46.72u l=1u
X3857 BAT GATE DVDD DVDD pfet_06v0 ad=35.5072p pd=48.24u as=35.5072p ps=48.24u w=46.72u l=1u
X3858 DVDD GATE BAT DVDD pfet_06v0 ad=58.1096p pd=77.98u as=58.1096p ps=77.98u w=76.46u l=1u
X3859 DVDD GATE BAT DVDD pfet_06v0 ad=71.8724p pd=0.1548m as=58.1096p ps=77.98u w=76.46u l=1u
X3860 BAT GATE DVDD DVDD pfet_06v0 ad=58.1172p pd=77.99u as=58.1172p ps=77.99u w=76.47u l=1u
X3861 DVDD GATE BAT DVDD pfet_06v0 ad=49.3848p pd=66.5u as=49.3848p ps=66.5u w=64.98u l=1u
X3862 BAT GATE DVDD DVDD pfet_06v0 ad=47.6862p pd=64.265u as=58.9803p ps=0.12737m w=62.745u l=1u
X3863 BAT GATE DVDD DVDD pfet_06v0 ad=58.1096p pd=77.98u as=58.1096p ps=77.98u w=76.46u l=1u
X3864 BAT GATE DVDD DVDD pfet_06v0 ad=58.1552p pd=78.04u as=58.1552p ps=78.04u w=76.52u l=1u
X3865 DVDD GATE BAT DVDD pfet_06v0 ad=58.1134p pd=77.985u as=58.1134p ps=77.985u w=76.465u l=1u
X3866 BAT GATE DVDD DVDD pfet_06v0 ad=35.511p pd=48.245u as=35.511p ps=48.245u w=46.725u l=1u
X3867 DVDD GATE BAT DVDD pfet_06v0 ad=43.9168p pd=95.32u as=35.5072p ps=48.24u w=46.72u l=1u
X3868 DVDD GATE BAT DVDD pfet_06v0 ad=71.8771p pd=0.15481m as=58.1134p ps=77.985u w=76.465u l=1u
X3869 BAT GATE DVDD DVDD pfet_06v0 ad=35.511p pd=48.245u as=35.511p ps=48.245u w=46.725u l=1u
X3870 BAT GATE DVDD DVDD pfet_06v0 ad=35.511p pd=48.245u as=35.511p ps=48.245u w=46.725u l=1u
X3871 BAT GATE DVDD DVDD pfet_06v0 ad=35.511p pd=48.245u as=35.511p ps=48.245u w=46.725u l=1u
X3872 DVDD GATE BAT DVDD pfet_06v0 ad=58.1134p pd=77.985u as=58.1134p ps=77.985u w=76.465u l=1u
X3873 BAT GATE DVDD DVDD pfet_06v0 ad=58.1134p pd=77.985u as=58.1134p ps=77.985u w=76.465u l=1u
X3874 BAT GATE DVDD DVDD pfet_06v0 ad=47.6862p pd=64.265u as=58.9803p ps=0.12737m w=62.745u l=1u
X3875 BAT GATE DVDD DVDD pfet_06v0 ad=47.6862p pd=64.265u as=47.6862p ps=64.265u w=62.745u l=1u
X3876 BAT GATE DVDD DVDD pfet_06v0 ad=58.1134p pd=77.985u as=58.1134p ps=77.985u w=76.465u l=1u
X3877 DVDD GATE BAT DVDD pfet_06v0 ad=43.9215p pd=95.32999u as=35.511p ps=48.245u w=46.725u l=1u
X3878 DVDD GATE BAT DVDD pfet_06v0 ad=58.1134p pd=77.985u as=58.1134p ps=77.985u w=76.465u l=1u
X3879 DVDD GATE BAT DVDD pfet_06v0 ad=47.6862p pd=64.265u as=47.6862p ps=64.265u w=62.745u l=1u
X3880 BAT GATE DVDD DVDD pfet_06v0 ad=35.5072p pd=48.24u as=43.9168p ps=95.32u w=46.72u l=1u
X3881 BAT GATE DVDD DVDD pfet_06v0 ad=58.1134p pd=77.985u as=58.1134p ps=77.985u w=76.465u l=1u
X3882 DVDD GATE BAT DVDD pfet_06v0 ad=58.1134p pd=77.985u as=58.1134p ps=77.985u w=76.465u l=1u
X3883 DVDD GATE BAT DVDD pfet_06v0 ad=43.9215p pd=95.32999u as=35.511p ps=48.245u w=46.725u l=1u
X3884 BAT GATE DVDD DVDD pfet_06v0 ad=35.511p pd=48.245u as=35.511p ps=48.245u w=46.725u l=1u
X3885 DVDD GATE BAT DVDD pfet_06v0 ad=58.1134p pd=77.985u as=58.1134p ps=77.985u w=76.465u l=1u
X3886 BAT GATE DVDD DVDD pfet_06v0 ad=35.511p pd=48.245u as=43.9215p ps=95.32999u w=46.725u l=1u
X3887 BAT GATE DVDD DVDD pfet_06v0 ad=58.1134p pd=77.985u as=58.1134p ps=77.985u w=76.465u l=1u
X3888 BAT GATE DVDD DVDD pfet_06v0 ad=35.5072p pd=48.24u as=35.5072p ps=48.24u w=46.72u l=1u
X3889 DVDD GATE BAT DVDD pfet_06v0 ad=35.511p pd=48.245u as=35.511p ps=48.245u w=46.725u l=1u
X3890 DVDD GATE BAT DVDD pfet_06v0 ad=71.8818p pd=0.15482m as=58.1172p ps=77.99u w=76.47u l=1u
X3891 DVDD GATE BAT DVDD pfet_06v0 ad=35.511p pd=48.245u as=35.511p ps=48.245u w=46.725u l=1u
X3892 BAT GATE DVDD DVDD pfet_06v0 ad=35.511p pd=48.245u as=35.511p ps=48.245u w=46.725u l=1u
X3893 DVDD GATE BAT DVDD pfet_06v0 ad=35.5072p pd=48.24u as=35.5072p ps=48.24u w=46.72u l=1u
X3894 DVDD GATE BAT DVDD pfet_06v0 ad=58.1134p pd=77.985u as=58.1134p ps=77.985u w=76.465u l=1u
X3895 DVDD GATE BAT DVDD pfet_06v0 ad=58.1134p pd=77.985u as=58.1134p ps=77.985u w=76.465u l=1u
X3896 DVDD GATE BAT DVDD pfet_06v0 ad=43.9215p pd=95.32999u as=35.511p ps=48.245u w=46.725u l=1u
X3897 BAT GATE DVDD DVDD pfet_06v0 ad=58.1134p pd=77.985u as=58.1134p ps=77.985u w=76.465u l=1u
X3898 DVDD GATE BAT DVDD pfet_06v0 ad=58.1552p pd=78.04u as=58.1552p ps=78.04u w=76.52u l=1u
X3899 BAT GATE DVDD DVDD pfet_06v0 ad=58.1134p pd=77.985u as=71.8771p ps=0.15481m w=76.465u l=1u
X3900 DVDD GATE BAT DVDD pfet_06v0 ad=43.9215p pd=95.32999u as=35.511p ps=48.245u w=46.725u l=1u
X3901 DVDD GATE BAT DVDD pfet_06v0 ad=71.92879p pd=0.15492m as=58.1552p ps=78.04u w=76.52u l=1u
X3902 BAT GATE DVDD DVDD pfet_06v0 ad=35.511p pd=48.245u as=35.511p ps=48.245u w=46.725u l=1u
X3903 BAT GATE DVDD DVDD pfet_06v0 ad=58.1172p pd=77.99u as=58.1172p ps=77.99u w=76.47u l=1u
X3904 BAT GATE DVDD DVDD pfet_06v0 ad=35.511p pd=48.245u as=35.511p ps=48.245u w=46.725u l=1u
X3905 DVDD GATE BAT DVDD pfet_06v0 ad=58.1134p pd=77.985u as=58.1134p ps=77.985u w=76.465u l=1u
X3906 BAT GATE DVDD DVDD pfet_06v0 ad=35.511p pd=48.245u as=35.511p ps=48.245u w=46.725u l=1u
X3907 BAT GATE DVDD DVDD pfet_06v0 ad=47.6862p pd=64.265u as=47.6862p ps=64.265u w=62.745u l=1u
X3908 DVDD GATE BAT DVDD pfet_06v0 ad=43.9215p pd=95.32999u as=35.511p ps=48.245u w=46.725u l=1u
X3909 BAT GATE DVDD DVDD pfet_06v0 ad=58.1134p pd=77.985u as=58.1134p ps=77.985u w=76.465u l=1u
X3910 DVDD GATE BAT DVDD pfet_06v0 ad=43.9215p pd=95.32999u as=35.511p ps=48.245u w=46.725u l=1u
X3911 BAT GATE DVDD DVDD pfet_06v0 ad=35.511p pd=48.245u as=35.511p ps=48.245u w=46.725u l=1u
X3912 DVDD GATE BAT DVDD pfet_06v0 ad=58.1172p pd=77.99u as=58.1172p ps=77.99u w=76.47u l=1u
X3913 DVDD GATE BAT DVDD pfet_06v0 ad=58.1134p pd=77.985u as=58.1134p ps=77.985u w=76.465u l=1u
X3914 BAT GATE DVDD DVDD pfet_06v0 ad=35.511p pd=48.245u as=35.511p ps=48.245u w=46.725u l=1u
X3915 DVDD GATE BAT DVDD pfet_06v0 ad=58.1552p pd=78.04u as=58.1552p ps=78.04u w=76.52u l=1u
X3916 DVDD GATE BAT DVDD pfet_06v0 ad=71.8818p pd=0.15482m as=58.1172p ps=77.99u w=76.47u l=1u
X3917 DVDD GATE BAT DVDD pfet_06v0 ad=35.511p pd=48.245u as=35.511p ps=48.245u w=46.725u l=1u
X3918 BAT GATE DVDD DVDD pfet_06v0 ad=49.3848p pd=66.5u as=49.3848p ps=66.5u w=64.98u l=1u
X3919 DVDD GATE BAT DVDD pfet_06v0 ad=58.1134p pd=77.985u as=58.1134p ps=77.985u w=76.465u l=1u
X3920 BAT GATE DVDD DVDD pfet_06v0 ad=35.511p pd=48.245u as=35.511p ps=48.245u w=46.725u l=1u
X3921 BAT GATE DVDD DVDD pfet_06v0 ad=49.3848p pd=66.5u as=49.3848p ps=66.5u w=64.98u l=1u
X3922 DVDD GATE BAT DVDD pfet_06v0 ad=58.1134p pd=77.985u as=58.1134p ps=77.985u w=76.465u l=1u
X3923 BAT GATE DVDD DVDD pfet_06v0 ad=49.3848p pd=66.5u as=49.3848p ps=66.5u w=64.98u l=1u
X3924 DVDD GATE BAT DVDD pfet_06v0 ad=58.1134p pd=77.985u as=58.1134p ps=77.985u w=76.465u l=1u
X3925 DVDD GATE BAT DVDD pfet_06v0 ad=58.0754p pd=77.935u as=58.0754p ps=77.935u w=76.41499u l=1u
X3926 DVDD GATE BAT DVDD pfet_06v0 ad=58.1134p pd=77.985u as=58.1134p ps=77.985u w=76.465u l=1u
X3927 DVDD GATE BAT DVDD pfet_06v0 ad=47.6862p pd=64.265u as=47.6862p ps=64.265u w=62.745u l=1u
X3928 DVDD GATE BAT DVDD pfet_06v0 ad=35.511p pd=48.245u as=35.511p ps=48.245u w=46.725u l=1u
X3929 DVDD GATE BAT DVDD pfet_06v0 ad=58.1134p pd=77.985u as=58.1134p ps=77.985u w=76.465u l=1u
X3930 BAT GATE DVDD DVDD pfet_06v0 ad=58.1172p pd=77.99u as=58.1172p ps=77.99u w=76.47u l=1u
X3931 DVDD GATE BAT DVDD pfet_06v0 ad=35.511p pd=48.245u as=35.511p ps=48.245u w=46.725u l=1u
X3932 DVDD GATE BAT DVDD pfet_06v0 ad=35.511p pd=48.245u as=35.511p ps=48.245u w=46.725u l=1u
X3933 BAT GATE DVDD DVDD pfet_06v0 ad=35.511p pd=48.245u as=35.511p ps=48.245u w=46.725u l=1u
X3934 DVDD GATE BAT DVDD pfet_06v0 ad=35.511p pd=48.245u as=35.511p ps=48.245u w=46.725u l=1u
X3935 DVDD GATE BAT DVDD pfet_06v0 ad=58.1134p pd=77.985u as=58.1134p ps=77.985u w=76.465u l=1u
X3936 BAT GATE DVDD DVDD pfet_06v0 ad=58.1134p pd=77.985u as=58.1134p ps=77.985u w=76.465u l=1u
X3937 DVDD GATE BAT DVDD pfet_06v0 ad=58.1134p pd=77.985u as=58.1134p ps=77.985u w=76.465u l=1u
X3938 DVDD GATE BAT DVDD pfet_06v0 ad=58.1096p pd=77.98u as=58.1096p ps=77.98u w=76.46u l=1u
X3939 DVDD GATE BAT DVDD pfet_06v0 ad=71.8724p pd=0.1548m as=58.1096p ps=77.98u w=76.46u l=1u
X3940 DVDD GATE BAT DVDD pfet_06v0 ad=35.511p pd=48.245u as=35.511p ps=48.245u w=46.725u l=1u
X3941 DVDD GATE BAT DVDD pfet_06v0 ad=35.5072p pd=48.24u as=35.5072p ps=48.24u w=46.72u l=1u
X3942 BAT GATE DVDD DVDD pfet_06v0 ad=58.1096p pd=77.98u as=58.1096p ps=77.98u w=76.46u l=1u
X3943 BAT GATE DVDD DVDD pfet_06v0 ad=47.6862p pd=64.265u as=47.6862p ps=64.265u w=62.745u l=1u
X3944 BAT GATE DVDD DVDD pfet_06v0 ad=58.1134p pd=77.985u as=58.1134p ps=77.985u w=76.465u l=1u
X3945 BAT GATE DVDD DVDD pfet_06v0 ad=35.511p pd=48.245u as=35.511p ps=48.245u w=46.725u l=1u
X3946 DVDD GATE BAT DVDD pfet_06v0 ad=35.511p pd=48.245u as=35.511p ps=48.245u w=46.725u l=1u
X3947 DVDD GATE BAT DVDD pfet_06v0 ad=43.9215p pd=95.32999u as=35.511p ps=48.245u w=46.725u l=1u
X3948 BAT GATE DVDD DVDD pfet_06v0 ad=35.511p pd=48.245u as=35.511p ps=48.245u w=46.725u l=1u
X3949 BAT GATE DVDD DVDD pfet_06v0 ad=35.511p pd=48.245u as=35.511p ps=48.245u w=46.725u l=1u
X3950 BAT GATE DVDD DVDD pfet_06v0 ad=58.1552p pd=78.04u as=71.92879p ps=0.15492m w=76.52u l=1u
X3951 DVDD GATE BAT DVDD pfet_06v0 ad=58.1134p pd=77.985u as=58.1134p ps=77.985u w=76.465u l=1u
X3952 DVDD GATE BAT DVDD pfet_06v0 ad=58.1172p pd=77.99u as=58.1172p ps=77.99u w=76.47u l=1u
X3953 BAT GATE DVDD DVDD pfet_06v0 ad=35.511p pd=48.245u as=35.511p ps=48.245u w=46.725u l=1u
X3954 DVDD GATE BAT DVDD pfet_06v0 ad=35.511p pd=48.245u as=35.511p ps=48.245u w=46.725u l=1u
X3955 DVDD GATE BAT DVDD pfet_06v0 ad=58.1134p pd=77.985u as=58.1134p ps=77.985u w=76.465u l=1u
X3956 DVDD GATE BAT DVDD pfet_06v0 ad=35.511p pd=48.245u as=35.511p ps=48.245u w=46.725u l=1u
X3957 BAT GATE DVDD DVDD pfet_06v0 ad=58.0754p pd=77.935u as=58.0754p ps=77.935u w=76.41499u l=1u
X3958 DVDD GATE BAT DVDD pfet_06v0 ad=35.511p pd=48.245u as=35.511p ps=48.245u w=46.725u l=1u
X3959 DVDD GATE BAT DVDD pfet_06v0 ad=58.1096p pd=77.98u as=58.1096p ps=77.98u w=76.46u l=1u
X3960 DVDD GATE BAT DVDD pfet_06v0 ad=35.511p pd=48.245u as=35.511p ps=48.245u w=46.725u l=1u
X3961 DVDD GATE BAT DVDD pfet_06v0 ad=43.9215p pd=95.32999u as=35.511p ps=48.245u w=46.725u l=1u
X3962 BAT GATE DVDD DVDD pfet_06v0 ad=35.511p pd=48.245u as=35.511p ps=48.245u w=46.725u l=1u
X3963 DVDD GATE BAT DVDD pfet_06v0 ad=58.1134p pd=77.985u as=58.1134p ps=77.985u w=76.465u l=1u
X3964 DVDD GATE BAT DVDD pfet_06v0 ad=71.8771p pd=0.15481m as=58.1134p ps=77.985u w=76.465u l=1u
X3965 DVDD GATE BAT DVDD pfet_06v0 ad=35.511p pd=48.245u as=35.511p ps=48.245u w=46.725u l=1u
X3966 BAT GATE DVDD DVDD pfet_06v0 ad=58.1134p pd=77.985u as=58.1134p ps=77.985u w=76.465u l=1u
X3967 DVDD GATE BAT DVDD pfet_06v0 ad=35.511p pd=48.245u as=35.511p ps=48.245u w=46.725u l=1u
X3968 DVDD GATE BAT DVDD pfet_06v0 ad=58.1134p pd=77.985u as=58.1134p ps=77.985u w=76.465u l=1u
X3969 BAT GATE DVDD DVDD pfet_06v0 ad=35.511p pd=48.245u as=35.511p ps=48.245u w=46.725u l=1u
X3970 BAT GATE DVDD DVDD pfet_06v0 ad=58.1134p pd=77.985u as=58.1134p ps=77.985u w=76.465u l=1u
X3971 DVDD GATE BAT DVDD pfet_06v0 ad=35.511p pd=48.245u as=35.511p ps=48.245u w=46.725u l=1u
X3972 DVDD GATE BAT DVDD pfet_06v0 ad=43.9215p pd=95.32999u as=35.511p ps=48.245u w=46.725u l=1u
X3973 BAT GATE DVDD DVDD pfet_06v0 ad=49.3848p pd=66.5u as=61.0812p ps=0.13184m w=64.98u l=1u
X3974 BAT GATE DVDD DVDD pfet_06v0 ad=47.6862p pd=64.265u as=47.6862p ps=64.265u w=62.745u l=1u
X3975 BAT GATE DVDD DVDD pfet_06v0 ad=35.511p pd=48.245u as=35.511p ps=48.245u w=46.725u l=1u
X3976 BAT GATE DVDD DVDD pfet_06v0 ad=47.6862p pd=64.265u as=47.6862p ps=64.265u w=62.745u l=1u
X3977 DVDD GATE BAT DVDD pfet_06v0 ad=58.0754p pd=77.935u as=58.0754p ps=77.935u w=76.41499u l=1u
X3978 BAT GATE DVDD DVDD pfet_06v0 ad=58.1134p pd=77.985u as=58.1134p ps=77.985u w=76.465u l=1u
X3979 BAT GATE DVDD DVDD pfet_06v0 ad=35.511p pd=48.245u as=35.511p ps=48.245u w=46.725u l=1u
X3980 DVDD GATE BAT DVDD pfet_06v0 ad=35.5072p pd=48.24u as=35.5072p ps=48.24u w=46.72u l=1u
X3981 BAT GATE DVDD DVDD pfet_06v0 ad=35.511p pd=48.245u as=35.511p ps=48.245u w=46.725u l=1u
X3982 BAT GATE DVDD DVDD pfet_06v0 ad=58.1096p pd=77.98u as=58.1096p ps=77.98u w=76.46u l=1u
X3983 DVDD GATE BAT DVDD pfet_06v0 ad=58.1134p pd=77.985u as=58.1134p ps=77.985u w=76.465u l=1u
X3984 BAT GATE DVDD DVDD pfet_06v0 ad=35.511p pd=48.245u as=35.511p ps=48.245u w=46.725u l=1u
X3985 BAT GATE DVDD DVDD pfet_06v0 ad=35.511p pd=48.245u as=35.511p ps=48.245u w=46.725u l=1u
X3986 DVDD GATE BAT DVDD pfet_06v0 ad=71.8771p pd=0.15481m as=58.1134p ps=77.985u w=76.465u l=1u
X3987 BAT GATE DVDD DVDD pfet_06v0 ad=58.1134p pd=77.985u as=71.8771p ps=0.15481m w=76.465u l=1u
X3988 BAT GATE DVDD DVDD pfet_06v0 ad=35.511p pd=48.245u as=35.511p ps=48.245u w=46.725u l=1u
X3989 DVDD GATE BAT DVDD pfet_06v0 ad=58.1134p pd=77.985u as=58.1134p ps=77.985u w=76.465u l=1u
X3990 DVDD GATE BAT DVDD pfet_06v0 ad=58.1172p pd=77.99u as=58.1172p ps=77.99u w=76.47u l=1u
X3991 DVDD GATE BAT DVDD pfet_06v0 ad=35.511p pd=48.245u as=35.511p ps=48.245u w=46.725u l=1u
X3992 DVDD GATE BAT DVDD pfet_06v0 ad=58.1172p pd=77.99u as=58.1172p ps=77.99u w=76.47u l=1u
X3993 BAT GATE DVDD DVDD pfet_06v0 ad=58.1134p pd=77.985u as=58.1134p ps=77.985u w=76.465u l=1u
X3994 BAT GATE DVDD DVDD pfet_06v0 ad=58.1134p pd=77.985u as=71.8771p ps=0.15481m w=76.465u l=1u
X3995 DVDD GATE BAT DVDD pfet_06v0 ad=35.511p pd=48.245u as=35.511p ps=48.245u w=46.725u l=1u
X3996 BAT GATE DVDD DVDD pfet_06v0 ad=58.1134p pd=77.985u as=58.1134p ps=77.985u w=76.465u l=1u
X3997 BAT GATE DVDD DVDD pfet_06v0 ad=35.511p pd=48.245u as=35.511p ps=48.245u w=46.725u l=1u
X3998 BAT GATE DVDD DVDD pfet_06v0 ad=58.1134p pd=77.985u as=58.1134p ps=77.985u w=76.465u l=1u
X3999 DVDD GATE BAT DVDD pfet_06v0 ad=49.3848p pd=66.5u as=49.3848p ps=66.5u w=64.98u l=1u
X4000 DVDD GATE BAT DVDD pfet_06v0 ad=58.1134p pd=77.985u as=58.1134p ps=77.985u w=76.465u l=1u
X4001 DVDD GATE BAT DVDD pfet_06v0 ad=58.1134p pd=77.985u as=58.1134p ps=77.985u w=76.465u l=1u
X4002 BAT GATE DVDD DVDD pfet_06v0 ad=35.511p pd=48.245u as=35.511p ps=48.245u w=46.725u l=1u
X4003 DVDD GATE BAT DVDD pfet_06v0 ad=43.9215p pd=95.32999u as=35.511p ps=48.245u w=46.725u l=1u
X4004 DVDD GATE BAT DVDD pfet_06v0 ad=58.1134p pd=77.985u as=58.1134p ps=77.985u w=76.465u l=1u
X4005 BAT GATE DVDD DVDD pfet_06v0 ad=35.511p pd=48.245u as=35.511p ps=48.245u w=46.725u l=1u
X4006 DVDD GATE BAT DVDD pfet_06v0 ad=71.8771p pd=0.15481m as=58.1134p ps=77.985u w=76.465u l=1u
X4007 BAT GATE DVDD DVDD pfet_06v0 ad=35.511p pd=48.245u as=35.511p ps=48.245u w=46.725u l=1u
X4008 DVDD GATE BAT DVDD pfet_06v0 ad=71.8771p pd=0.15481m as=58.1134p ps=77.985u w=76.465u l=1u
X4009 DVDD GATE BAT DVDD pfet_06v0 ad=35.511p pd=48.245u as=35.511p ps=48.245u w=46.725u l=1u
X4010 BAT GATE DVDD DVDD pfet_06v0 ad=47.6862p pd=64.265u as=47.6862p ps=64.265u w=62.745u l=1u
X4011 DVDD GATE BAT DVDD pfet_06v0 ad=71.8771p pd=0.15481m as=58.1134p ps=77.985u w=76.465u l=1u
X4012 DVDD GATE BAT DVDD pfet_06v0 ad=58.1134p pd=77.985u as=58.1134p ps=77.985u w=76.465u l=1u
X4013 DVDD GATE BAT DVDD pfet_06v0 ad=35.511p pd=48.245u as=35.511p ps=48.245u w=46.725u l=1u
X4014 BAT GATE DVDD DVDD pfet_06v0 ad=35.511p pd=48.245u as=35.511p ps=48.245u w=46.725u l=1u
X4015 BAT GATE DVDD DVDD pfet_06v0 ad=58.1552p pd=78.04u as=58.1552p ps=78.04u w=76.52u l=1u
X4016 BAT GATE DVDD DVDD pfet_06v0 ad=58.1134p pd=77.985u as=58.1134p ps=77.985u w=76.465u l=1u
X4017 DVDD GATE BAT DVDD pfet_06v0 ad=35.511p pd=48.245u as=35.511p ps=48.245u w=46.725u l=1u
X4018 BAT GATE DVDD DVDD pfet_06v0 ad=58.1134p pd=77.985u as=58.1134p ps=77.985u w=76.465u l=1u
X4019 DVDD GATE BAT DVDD pfet_06v0 ad=58.1552p pd=78.04u as=58.1552p ps=78.04u w=76.52u l=1u
X4020 BAT GATE DVDD DVDD pfet_06v0 ad=58.1134p pd=77.985u as=58.1134p ps=77.985u w=76.465u l=1u
X4021 BAT GATE DVDD DVDD pfet_06v0 ad=47.6862p pd=64.265u as=58.9803p ps=0.12737m w=62.745u l=1u
X4022 BAT GATE DVDD DVDD pfet_06v0 ad=58.1134p pd=77.985u as=71.8771p ps=0.15481m w=76.465u l=1u
X4023 DVDD GATE BAT DVDD pfet_06v0 ad=35.511p pd=48.245u as=35.511p ps=48.245u w=46.725u l=1u
X4024 BAT GATE DVDD DVDD pfet_06v0 ad=58.1134p pd=77.985u as=58.1134p ps=77.985u w=76.465u l=1u
X4025 DVDD GATE BAT DVDD pfet_06v0 ad=43.9215p pd=95.32999u as=35.511p ps=48.245u w=46.725u l=1u
X4026 BAT GATE DVDD DVDD pfet_06v0 ad=58.1134p pd=77.985u as=71.8771p ps=0.15481m w=76.465u l=1u
X4027 BAT GATE DVDD DVDD pfet_06v0 ad=58.1134p pd=77.985u as=58.1134p ps=77.985u w=76.465u l=1u
X4028 DVDD GATE BAT DVDD pfet_06v0 ad=71.8301p pd=0.15471m as=58.0754p ps=77.935u w=76.41499u l=1u
X4029 BAT GATE DVDD DVDD pfet_06v0 ad=58.1096p pd=77.98u as=58.1096p ps=77.98u w=76.46u l=1u
X4030 DVDD GATE BAT DVDD pfet_06v0 ad=35.511p pd=48.245u as=35.511p ps=48.245u w=46.725u l=1u
X4031 BAT GATE DVDD DVDD pfet_06v0 ad=35.511p pd=48.245u as=35.511p ps=48.245u w=46.725u l=1u
X4032 DVDD GATE BAT DVDD pfet_06v0 ad=58.1134p pd=77.985u as=58.1134p ps=77.985u w=76.465u l=1u
X4033 DVDD GATE BAT DVDD pfet_06v0 ad=58.1552p pd=78.04u as=58.1552p ps=78.04u w=76.52u l=1u
X4034 DVDD GATE BAT DVDD pfet_06v0 ad=58.1134p pd=77.985u as=58.1134p ps=77.985u w=76.465u l=1u
X4035 BAT GATE DVDD DVDD pfet_06v0 ad=58.1134p pd=77.985u as=58.1134p ps=77.985u w=76.465u l=1u
X4036 DVDD GATE BAT DVDD pfet_06v0 ad=58.1134p pd=77.985u as=58.1134p ps=77.985u w=76.465u l=1u
X4037 BAT GATE DVDD DVDD pfet_06v0 ad=58.1096p pd=77.98u as=58.1096p ps=77.98u w=76.46u l=1u
X4038 BAT GATE DVDD DVDD pfet_06v0 ad=58.1096p pd=77.98u as=58.1096p ps=77.98u w=76.46u l=1u
X4039 BAT GATE DVDD DVDD pfet_06v0 ad=35.511p pd=48.245u as=35.511p ps=48.245u w=46.725u l=1u
X4040 BAT GATE DVDD DVDD pfet_06v0 ad=35.511p pd=48.245u as=35.511p ps=48.245u w=46.725u l=1u
X4041 BAT GATE DVDD DVDD pfet_06v0 ad=58.0754p pd=77.935u as=58.0754p ps=77.935u w=76.41499u l=1u
X4042 BAT GATE DVDD DVDD pfet_06v0 ad=49.3848p pd=66.5u as=49.3848p ps=66.5u w=64.98u l=1u
X4043 BAT GATE DVDD DVDD pfet_06v0 ad=35.511p pd=48.245u as=35.511p ps=48.245u w=46.725u l=1u
X4044 DVDD GATE BAT DVDD pfet_06v0 ad=58.1134p pd=77.985u as=58.1134p ps=77.985u w=76.465u l=1u
X4045 DVDD GATE BAT DVDD pfet_06v0 ad=35.511p pd=48.245u as=35.511p ps=48.245u w=46.725u l=1u
X4046 BAT GATE DVDD DVDD pfet_06v0 ad=58.0754p pd=77.935u as=58.0754p ps=77.935u w=76.41499u l=1u
X4047 BAT GATE DVDD DVDD pfet_06v0 ad=58.1134p pd=77.985u as=58.1134p ps=77.985u w=76.465u l=1u
X4048 BAT GATE DVDD DVDD pfet_06v0 ad=35.511p pd=48.245u as=35.511p ps=48.245u w=46.725u l=1u
X4049 BAT GATE DVDD DVDD pfet_06v0 ad=58.1134p pd=77.985u as=58.1134p ps=77.985u w=76.465u l=1u
X4050 DVDD GATE BAT DVDD pfet_06v0 ad=35.511p pd=48.245u as=35.511p ps=48.245u w=46.725u l=1u
X4051 DVDD GATE BAT DVDD pfet_06v0 ad=58.0754p pd=77.935u as=58.0754p ps=77.935u w=76.41499u l=1u
X4052 DVDD GATE BAT DVDD pfet_06v0 ad=47.6862p pd=64.265u as=47.6862p ps=64.265u w=62.745u l=1u
X4053 DVDD GATE BAT DVDD pfet_06v0 ad=71.8724p pd=0.1548m as=58.1096p ps=77.98u w=76.46u l=1u
X4054 DVDD GATE BAT DVDD pfet_06v0 ad=58.1096p pd=77.98u as=58.1096p ps=77.98u w=76.46u l=1u
X4055 BAT GATE DVDD DVDD pfet_06v0 ad=58.1134p pd=77.985u as=58.1134p ps=77.985u w=76.465u l=1u
X4056 BAT GATE DVDD DVDD pfet_06v0 ad=47.6862p pd=64.265u as=58.9803p ps=0.12737m w=62.745u l=1u
X4057 BAT GATE DVDD DVDD pfet_06v0 ad=58.1134p pd=77.985u as=58.1134p ps=77.985u w=76.465u l=1u
X4058 BAT GATE DVDD DVDD pfet_06v0 ad=35.511p pd=48.245u as=35.511p ps=48.245u w=46.725u l=1u
X4059 DVDD GATE BAT DVDD pfet_06v0 ad=71.8771p pd=0.15481m as=58.1134p ps=77.985u w=76.465u l=1u
X4060 DVDD GATE BAT DVDD pfet_06v0 ad=43.9215p pd=95.32999u as=35.511p ps=48.245u w=46.725u l=1u
X4061 DVDD GATE BAT DVDD pfet_06v0 ad=35.511p pd=48.245u as=35.511p ps=48.245u w=46.725u l=1u
X4062 BAT GATE DVDD DVDD pfet_06v0 ad=35.511p pd=48.245u as=35.511p ps=48.245u w=46.725u l=1u
X4063 BAT GATE DVDD DVDD pfet_06v0 ad=58.1134p pd=77.985u as=71.8771p ps=0.15481m w=76.465u l=1u
X4064 BAT GATE DVDD DVDD pfet_06v0 ad=58.1096p pd=77.98u as=71.8724p ps=0.1548m w=76.46u l=1u
X4065 BAT GATE DVDD DVDD pfet_06v0 ad=35.511p pd=48.245u as=35.511p ps=48.245u w=46.725u l=1u
X4066 DVDD GATE BAT DVDD pfet_06v0 ad=35.5072p pd=48.24u as=35.5072p ps=48.24u w=46.72u l=1u
X4067 DVDD GATE BAT DVDD pfet_06v0 ad=47.6862p pd=64.265u as=47.6862p ps=64.265u w=62.745u l=1u
X4068 DVDD GATE BAT DVDD pfet_06v0 ad=58.1134p pd=77.985u as=58.1134p ps=77.985u w=76.465u l=1u
X4069 BAT GATE DVDD DVDD pfet_06v0 ad=35.511p pd=48.245u as=35.511p ps=48.245u w=46.725u l=1u
X4070 BAT GATE DVDD DVDD pfet_06v0 ad=49.3848p pd=66.5u as=49.3848p ps=66.5u w=64.98u l=1u
X4071 DVDD GATE BAT DVDD pfet_06v0 ad=35.5072p pd=48.24u as=35.5072p ps=48.24u w=46.72u l=1u
X4072 DVDD GATE BAT DVDD pfet_06v0 ad=35.5072p pd=48.24u as=35.5072p ps=48.24u w=46.72u l=1u
X4073 BAT GATE DVDD DVDD pfet_06v0 ad=58.1096p pd=77.98u as=58.1096p ps=77.98u w=76.46u l=1u
X4074 DVDD GATE BAT DVDD pfet_06v0 ad=35.511p pd=48.245u as=35.511p ps=48.245u w=46.725u l=1u
X4075 BAT GATE DVDD DVDD pfet_06v0 ad=58.1134p pd=77.985u as=58.1134p ps=77.985u w=76.465u l=1u
X4076 BAT GATE DVDD DVDD pfet_06v0 ad=35.511p pd=48.245u as=35.511p ps=48.245u w=46.725u l=1u
X4077 BAT GATE DVDD DVDD pfet_06v0 ad=35.511p pd=48.245u as=35.511p ps=48.245u w=46.725u l=1u
X4078 DVDD GATE BAT DVDD pfet_06v0 ad=58.1096p pd=77.98u as=58.1096p ps=77.98u w=76.46u l=1u
X4079 BAT GATE DVDD DVDD pfet_06v0 ad=35.511p pd=48.245u as=35.511p ps=48.245u w=46.725u l=1u
X4080 DVDD GATE BAT DVDD pfet_06v0 ad=71.8771p pd=0.15481m as=58.1134p ps=77.985u w=76.465u l=1u
X4081 DVDD GATE BAT DVDD pfet_06v0 ad=35.511p pd=48.245u as=35.511p ps=48.245u w=46.725u l=1u
X4082 DVDD GATE BAT DVDD pfet_06v0 ad=47.6862p pd=64.265u as=47.6862p ps=64.265u w=62.745u l=1u
X4083 BAT GATE DVDD DVDD pfet_06v0 ad=58.1134p pd=77.985u as=58.1134p ps=77.985u w=76.465u l=1u
X4084 BAT GATE DVDD DVDD pfet_06v0 ad=35.5072p pd=48.24u as=35.5072p ps=48.24u w=46.72u l=1u
X4085 DVDD GATE BAT DVDD pfet_06v0 ad=71.8818p pd=0.15482m as=58.1172p ps=77.99u w=76.47u l=1u
X4086 BAT GATE DVDD DVDD pfet_06v0 ad=58.1134p pd=77.985u as=58.1134p ps=77.985u w=76.465u l=1u
X4087 BAT GATE DVDD DVDD pfet_06v0 ad=58.0754p pd=77.935u as=58.0754p ps=77.935u w=76.41499u l=1u
X4088 DVDD GATE BAT DVDD pfet_06v0 ad=35.511p pd=48.245u as=35.511p ps=48.245u w=46.725u l=1u
X4089 DVDD GATE BAT DVDD pfet_06v0 ad=35.511p pd=48.245u as=35.511p ps=48.245u w=46.725u l=1u
X4090 BAT GATE DVDD DVDD pfet_06v0 ad=58.1172p pd=77.99u as=58.1172p ps=77.99u w=76.47u l=1u
X4091 DVDD GATE BAT DVDD pfet_06v0 ad=58.1134p pd=77.985u as=58.1134p ps=77.985u w=76.465u l=1u
X4092 BAT GATE DVDD DVDD pfet_06v0 ad=58.1134p pd=77.985u as=58.1134p ps=77.985u w=76.465u l=1u
X4093 DVDD GATE BAT DVDD pfet_06v0 ad=58.1134p pd=77.985u as=58.1134p ps=77.985u w=76.465u l=1u
X4094 DVDD GATE BAT DVDD pfet_06v0 ad=58.1134p pd=77.985u as=58.1134p ps=77.985u w=76.465u l=1u
X4095 BAT GATE DVDD DVDD pfet_06v0 ad=58.1134p pd=77.985u as=58.1134p ps=77.985u w=76.465u l=1u
X4096 BAT GATE DVDD DVDD pfet_06v0 ad=35.511p pd=48.245u as=35.511p ps=48.245u w=46.725u l=1u
X4097 DVDD GATE BAT DVDD pfet_06v0 ad=47.6862p pd=64.265u as=47.6862p ps=64.265u w=62.745u l=1u
X4098 DVDD GATE BAT DVDD pfet_06v0 ad=35.511p pd=48.245u as=35.511p ps=48.245u w=46.725u l=1u
X4099 DVDD GATE BAT DVDD pfet_06v0 ad=71.8771p pd=0.15481m as=58.1134p ps=77.985u w=76.465u l=1u
X4100 DVDD GATE BAT DVDD pfet_06v0 ad=35.511p pd=48.245u as=35.511p ps=48.245u w=46.725u l=1u
X4101 BAT GATE DVDD DVDD pfet_06v0 ad=58.1172p pd=77.99u as=71.8818p ps=0.15482m w=76.47u l=1u
X4102 BAT GATE DVDD DVDD pfet_06v0 ad=58.1134p pd=77.985u as=58.1134p ps=77.985u w=76.465u l=1u
X4103 DVDD GATE BAT DVDD pfet_06v0 ad=58.1134p pd=77.985u as=58.1134p ps=77.985u w=76.465u l=1u
X4104 BAT GATE DVDD DVDD pfet_06v0 ad=58.1134p pd=77.985u as=58.1134p ps=77.985u w=76.465u l=1u
X4105 DVDD GATE BAT DVDD pfet_06v0 ad=35.511p pd=48.245u as=35.511p ps=48.245u w=46.725u l=1u
X4106 DVDD GATE BAT DVDD pfet_06v0 ad=58.1134p pd=77.985u as=58.1134p ps=77.985u w=76.465u l=1u
X4107 BAT GATE DVDD DVDD pfet_06v0 ad=58.1172p pd=77.99u as=58.1172p ps=77.99u w=76.47u l=1u
X4108 BAT GATE DVDD DVDD pfet_06v0 ad=58.1134p pd=77.985u as=58.1134p ps=77.985u w=76.465u l=1u
X4109 BAT GATE DVDD DVDD pfet_06v0 ad=58.1172p pd=77.99u as=58.1172p ps=77.99u w=76.47u l=1u
X4110 DVDD GATE BAT DVDD pfet_06v0 ad=35.511p pd=48.245u as=35.511p ps=48.245u w=46.725u l=1u
X4111 DVDD GATE BAT DVDD pfet_06v0 ad=58.1134p pd=77.985u as=58.1134p ps=77.985u w=76.465u l=1u
X4112 DVDD GATE BAT DVDD pfet_06v0 ad=43.9215p pd=95.32999u as=35.511p ps=48.245u w=46.725u l=1u
X4113 DVDD GATE BAT DVDD pfet_06v0 ad=35.511p pd=48.245u as=35.511p ps=48.245u w=46.725u l=1u
X4114 DVDD GATE BAT DVDD pfet_06v0 ad=35.511p pd=48.245u as=35.511p ps=48.245u w=46.725u l=1u
X4115 DVDD GATE BAT DVDD pfet_06v0 ad=58.1134p pd=77.985u as=58.1134p ps=77.985u w=76.465u l=1u
X4116 DVDD GATE BAT DVDD pfet_06v0 ad=58.1172p pd=77.99u as=58.1172p ps=77.99u w=76.47u l=1u
X4117 DVDD GATE BAT DVDD pfet_06v0 ad=58.1134p pd=77.985u as=58.1134p ps=77.985u w=76.465u l=1u
X4118 DVDD GATE BAT DVDD pfet_06v0 ad=61.0812p pd=0.13184m as=49.3848p ps=66.5u w=64.98u l=1u
X4119 DVDD GATE BAT DVDD pfet_06v0 ad=58.0754p pd=77.935u as=58.0754p ps=77.935u w=76.41499u l=1u
X4120 DVDD GATE BAT DVDD pfet_06v0 ad=47.6862p pd=64.265u as=47.6862p ps=64.265u w=62.745u l=1u
X4121 DVDD GATE BAT DVDD pfet_06v0 ad=58.1134p pd=77.985u as=58.1134p ps=77.985u w=76.465u l=1u
X4122 BAT GATE DVDD DVDD pfet_06v0 ad=58.1552p pd=78.04u as=58.1552p ps=78.04u w=76.52u l=1u
X4123 BAT GATE DVDD DVDD pfet_06v0 ad=58.1134p pd=77.985u as=71.8771p ps=0.15481m w=76.465u l=1u
X4124 DVDD GATE BAT DVDD pfet_06v0 ad=35.511p pd=48.245u as=35.511p ps=48.245u w=46.725u l=1u
X4125 BAT GATE DVDD DVDD pfet_06v0 ad=35.5072p pd=48.24u as=35.5072p ps=48.24u w=46.72u l=1u
X4126 DVDD GATE BAT DVDD pfet_06v0 ad=35.511p pd=48.245u as=35.511p ps=48.245u w=46.725u l=1u
X4127 BAT GATE DVDD DVDD pfet_06v0 ad=35.511p pd=48.245u as=35.511p ps=48.245u w=46.725u l=1u
X4128 DVDD GATE BAT DVDD pfet_06v0 ad=58.1134p pd=77.985u as=58.1134p ps=77.985u w=76.465u l=1u
X4129 DVDD GATE BAT DVDD pfet_06v0 ad=35.511p pd=48.245u as=35.511p ps=48.245u w=46.725u l=1u
X4130 BAT GATE DVDD DVDD pfet_06v0 ad=58.1134p pd=77.985u as=58.1134p ps=77.985u w=76.465u l=1u
X4131 BAT GATE DVDD DVDD pfet_06v0 ad=35.511p pd=48.245u as=43.9215p ps=95.32999u w=46.725u l=1u
X4132 DVDD GATE BAT DVDD pfet_06v0 ad=58.1134p pd=77.985u as=58.1134p ps=77.985u w=76.465u l=1u
X4133 BAT GATE DVDD DVDD pfet_06v0 ad=58.1552p pd=78.04u as=58.1552p ps=78.04u w=76.52u l=1u
X4134 DVDD GATE BAT DVDD pfet_06v0 ad=35.511p pd=48.245u as=35.511p ps=48.245u w=46.725u l=1u
X4135 BAT GATE DVDD DVDD pfet_06v0 ad=58.1096p pd=77.98u as=58.1096p ps=77.98u w=76.46u l=1u
X4136 DVDD GATE BAT DVDD pfet_06v0 ad=47.6862p pd=64.265u as=47.6862p ps=64.265u w=62.745u l=1u
X4137 BAT GATE DVDD DVDD pfet_06v0 ad=35.511p pd=48.245u as=35.511p ps=48.245u w=46.725u l=1u
X4138 BAT GATE DVDD DVDD pfet_06v0 ad=35.511p pd=48.245u as=35.511p ps=48.245u w=46.725u l=1u
X4139 DVDD GATE BAT DVDD pfet_06v0 ad=58.1134p pd=77.985u as=58.1134p ps=77.985u w=76.465u l=1u
X4140 BAT GATE DVDD DVDD pfet_06v0 ad=35.511p pd=48.245u as=35.511p ps=48.245u w=46.725u l=1u
X4141 DVDD GATE BAT DVDD pfet_06v0 ad=58.1134p pd=77.985u as=58.1134p ps=77.985u w=76.465u l=1u
X4142 DVDD GATE BAT DVDD pfet_06v0 ad=58.1134p pd=77.985u as=58.1134p ps=77.985u w=76.465u l=1u
X4143 DVDD GATE BAT DVDD pfet_06v0 ad=58.1134p pd=77.985u as=58.1134p ps=77.985u w=76.465u l=1u
X4144 BAT GATE DVDD DVDD pfet_06v0 ad=58.0754p pd=77.935u as=58.0754p ps=77.935u w=76.41499u l=1u
X4145 DVDD GATE BAT DVDD pfet_06v0 ad=58.1096p pd=77.98u as=58.1096p ps=77.98u w=76.46u l=1u
X4146 BAT GATE DVDD DVDD pfet_06v0 ad=35.5072p pd=48.24u as=35.5072p ps=48.24u w=46.72u l=1u
X4147 BAT GATE DVDD DVDD pfet_06v0 ad=58.1172p pd=77.99u as=58.1172p ps=77.99u w=76.47u l=1u
X4148 BAT GATE DVDD DVDD pfet_06v0 ad=58.1134p pd=77.985u as=58.1134p ps=77.985u w=76.465u l=1u
X4149 DVDD GATE BAT DVDD pfet_06v0 ad=49.3848p pd=66.5u as=49.3848p ps=66.5u w=64.98u l=1u
X4150 BAT GATE DVDD DVDD pfet_06v0 ad=35.5072p pd=48.24u as=35.5072p ps=48.24u w=46.72u l=1u
X4151 BAT GATE DVDD DVDD pfet_06v0 ad=58.1134p pd=77.985u as=58.1134p ps=77.985u w=76.465u l=1u
X4152 DVDD GATE BAT DVDD pfet_06v0 ad=35.511p pd=48.245u as=35.511p ps=48.245u w=46.725u l=1u
X4153 DVDD GATE BAT DVDD pfet_06v0 ad=49.3848p pd=66.5u as=49.3848p ps=66.5u w=64.98u l=1u
X4154 DVDD GATE BAT DVDD pfet_06v0 ad=35.511p pd=48.245u as=35.511p ps=48.245u w=46.725u l=1u
X4155 DVDD GATE BAT DVDD pfet_06v0 ad=43.9168p pd=95.32u as=35.5072p ps=48.24u w=46.72u l=1u
X4156 DVDD GATE BAT DVDD pfet_06v0 ad=49.3848p pd=66.5u as=49.3848p ps=66.5u w=64.98u l=1u
X4157 DVDD GATE BAT DVDD pfet_06v0 ad=58.0754p pd=77.935u as=58.0754p ps=77.935u w=76.41499u l=1u
X4158 DVDD GATE BAT DVDD pfet_06v0 ad=35.511p pd=48.245u as=35.511p ps=48.245u w=46.725u l=1u
X4159 BAT GATE DVDD DVDD pfet_06v0 ad=58.1134p pd=77.985u as=58.1134p ps=77.985u w=76.465u l=1u
X4160 DVDD GATE BAT DVDD pfet_06v0 ad=58.0754p pd=77.935u as=58.0754p ps=77.935u w=76.41499u l=1u
X4161 BAT GATE DVDD DVDD pfet_06v0 ad=35.511p pd=48.245u as=35.511p ps=48.245u w=46.725u l=1u
X4162 BAT GATE DVDD DVDD pfet_06v0 ad=35.511p pd=48.245u as=43.9215p ps=95.32999u w=46.725u l=1u
X4163 BAT GATE DVDD DVDD pfet_06v0 ad=47.6862p pd=64.265u as=47.6862p ps=64.265u w=62.745u l=1u
X4164 DVDD GATE BAT DVDD pfet_06v0 ad=35.5072p pd=48.24u as=35.5072p ps=48.24u w=46.72u l=1u
X4165 DVDD GATE BAT DVDD pfet_06v0 ad=58.1134p pd=77.985u as=58.1134p ps=77.985u w=76.465u l=1u
X4166 BAT GATE DVDD DVDD pfet_06v0 ad=35.511p pd=48.245u as=35.511p ps=48.245u w=46.725u l=1u
X4167 BAT GATE DVDD DVDD pfet_06v0 ad=58.0754p pd=77.935u as=71.8301p ps=0.15471m w=76.41499u l=1u
X4168 BAT GATE DVDD DVDD pfet_06v0 ad=58.1096p pd=77.98u as=58.1096p ps=77.98u w=76.46u l=1u
X4169 DVDD GATE BAT DVDD pfet_06v0 ad=35.511p pd=48.245u as=35.511p ps=48.245u w=46.725u l=1u
X4170 DVDD GATE BAT DVDD pfet_06v0 ad=58.1134p pd=77.985u as=58.1134p ps=77.985u w=76.465u l=1u
X4171 DVDD GATE BAT DVDD pfet_06v0 ad=35.511p pd=48.245u as=35.511p ps=48.245u w=46.725u l=1u
X4172 BAT GATE DVDD DVDD pfet_06v0 ad=58.1134p pd=77.985u as=58.1134p ps=77.985u w=76.465u l=1u
X4173 BAT GATE DVDD DVDD pfet_06v0 ad=35.511p pd=48.245u as=35.511p ps=48.245u w=46.725u l=1u
X4174 BAT GATE DVDD DVDD pfet_06v0 ad=58.1134p pd=77.985u as=58.1134p ps=77.985u w=76.465u l=1u
X4175 BAT GATE DVDD DVDD pfet_06v0 ad=47.6862p pd=64.265u as=47.6862p ps=64.265u w=62.745u l=1u
X4176 DVDD GATE BAT DVDD pfet_06v0 ad=43.9168p pd=95.32u as=35.5072p ps=48.24u w=46.72u l=1u
X4177 BAT GATE DVDD DVDD pfet_06v0 ad=35.511p pd=48.245u as=35.511p ps=48.245u w=46.725u l=1u
X4178 DVDD GATE BAT DVDD pfet_06v0 ad=47.6862p pd=64.265u as=47.6862p ps=64.265u w=62.745u l=1u
X4179 BAT GATE DVDD DVDD pfet_06v0 ad=35.5072p pd=48.24u as=35.5072p ps=48.24u w=46.72u l=1u
X4180 DVDD GATE BAT DVDD pfet_06v0 ad=35.511p pd=48.245u as=35.511p ps=48.245u w=46.725u l=1u
X4181 DVDD GATE BAT DVDD pfet_06v0 ad=58.1134p pd=77.985u as=58.1134p ps=77.985u w=76.465u l=1u
X4182 BAT GATE DVDD DVDD pfet_06v0 ad=58.1134p pd=77.985u as=58.1134p ps=77.985u w=76.465u l=1u
X4183 BAT GATE DVDD DVDD pfet_06v0 ad=35.5072p pd=48.24u as=35.5072p ps=48.24u w=46.72u l=1u
X4184 BAT GATE DVDD DVDD pfet_06v0 ad=35.511p pd=48.245u as=35.511p ps=48.245u w=46.725u l=1u
X4185 BAT GATE DVDD DVDD pfet_06v0 ad=35.511p pd=48.245u as=35.511p ps=48.245u w=46.725u l=1u
X4186 DVDD GATE BAT DVDD pfet_06v0 ad=49.3848p pd=66.5u as=49.3848p ps=66.5u w=64.98u l=1u
X4187 DVDD GATE BAT DVDD pfet_06v0 ad=58.1096p pd=77.98u as=58.1096p ps=77.98u w=76.46u l=1u
X4188 BAT GATE DVDD DVDD pfet_06v0 ad=35.511p pd=48.245u as=35.511p ps=48.245u w=46.725u l=1u
X4189 BAT GATE DVDD DVDD pfet_06v0 ad=35.511p pd=48.245u as=35.511p ps=48.245u w=46.725u l=1u
X4190 BAT GATE DVDD DVDD pfet_06v0 ad=58.1172p pd=77.99u as=58.1172p ps=77.99u w=76.47u l=1u
X4191 BAT GATE DVDD DVDD pfet_06v0 ad=35.511p pd=48.245u as=35.511p ps=48.245u w=46.725u l=1u
X4192 BAT GATE DVDD DVDD pfet_06v0 ad=58.1552p pd=78.04u as=58.1552p ps=78.04u w=76.52u l=1u
X4193 DVDD GATE BAT DVDD pfet_06v0 ad=35.511p pd=48.245u as=35.511p ps=48.245u w=46.725u l=1u
X4194 BAT GATE DVDD DVDD pfet_06v0 ad=47.6862p pd=64.265u as=47.6862p ps=64.265u w=62.745u l=1u
X4195 DVDD GATE BAT DVDD pfet_06v0 ad=58.1134p pd=77.985u as=58.1134p ps=77.985u w=76.465u l=1u
X4196 DVDD GATE BAT DVDD pfet_06v0 ad=43.9215p pd=95.32999u as=35.511p ps=48.245u w=46.725u l=1u
X4197 DVDD GATE BAT DVDD pfet_06v0 ad=35.5072p pd=48.24u as=35.5072p ps=48.24u w=46.72u l=1u
X4198 DVDD GATE BAT DVDD pfet_06v0 ad=58.1134p pd=77.985u as=58.1134p ps=77.985u w=76.465u l=1u
X4199 BAT GATE DVDD DVDD pfet_06v0 ad=35.511p pd=48.245u as=35.511p ps=48.245u w=46.725u l=1u
X4200 BAT GATE DVDD DVDD pfet_06v0 ad=35.511p pd=48.245u as=35.511p ps=48.245u w=46.725u l=1u
X4201 DVDD GATE BAT DVDD pfet_06v0 ad=71.92879p pd=0.15492m as=58.1552p ps=78.04u w=76.52u l=1u
X4202 BAT GATE DVDD DVDD pfet_06v0 ad=58.1134p pd=77.985u as=71.8771p ps=0.15481m w=76.465u l=1u
X4203 BAT GATE DVDD DVDD pfet_06v0 ad=47.6862p pd=64.265u as=47.6862p ps=64.265u w=62.745u l=1u
X4204 BAT GATE DVDD DVDD pfet_06v0 ad=58.1134p pd=77.985u as=58.1134p ps=77.985u w=76.465u l=1u
X4205 DVDD GATE BAT DVDD pfet_06v0 ad=35.511p pd=48.245u as=35.511p ps=48.245u w=46.725u l=1u
X4206 DVDD GATE BAT DVDD pfet_06v0 ad=58.1134p pd=77.985u as=58.1134p ps=77.985u w=76.465u l=1u
X4207 DVDD GATE BAT DVDD pfet_06v0 ad=58.1134p pd=77.985u as=58.1134p ps=77.985u w=76.465u l=1u
X4208 BAT GATE DVDD DVDD pfet_06v0 ad=35.511p pd=48.245u as=35.511p ps=48.245u w=46.725u l=1u
X4209 DVDD GATE BAT DVDD pfet_06v0 ad=71.8771p pd=0.15481m as=58.1134p ps=77.985u w=76.465u l=1u
X4210 DVDD GATE BAT DVDD pfet_06v0 ad=58.1134p pd=77.985u as=58.1134p ps=77.985u w=76.465u l=1u
X4211 BAT GATE DVDD DVDD pfet_06v0 ad=58.1134p pd=77.985u as=58.1134p ps=77.985u w=76.465u l=1u
X4212 BAT GATE DVDD DVDD pfet_06v0 ad=35.511p pd=48.245u as=35.511p ps=48.245u w=46.725u l=1u
X4213 BAT GATE DVDD DVDD pfet_06v0 ad=58.1134p pd=77.985u as=71.8771p ps=0.15481m w=76.465u l=1u
X4214 BAT GATE DVDD DVDD pfet_06v0 ad=35.5072p pd=48.24u as=35.5072p ps=48.24u w=46.72u l=1u
X4215 DVDD GATE BAT DVDD pfet_06v0 ad=35.511p pd=48.245u as=35.511p ps=48.245u w=46.725u l=1u
X4216 DVDD GATE BAT DVDD pfet_06v0 ad=49.3848p pd=66.5u as=49.3848p ps=66.5u w=64.98u l=1u
X4217 DVDD GATE BAT DVDD pfet_06v0 ad=35.511p pd=48.245u as=35.511p ps=48.245u w=46.725u l=1u
X4218 BAT GATE DVDD DVDD pfet_06v0 ad=35.511p pd=48.245u as=35.511p ps=48.245u w=46.725u l=1u
X4219 DVDD GATE BAT DVDD pfet_06v0 ad=58.1134p pd=77.985u as=58.1134p ps=77.985u w=76.465u l=1u
X4220 DVDD GATE BAT DVDD pfet_06v0 ad=58.1096p pd=77.98u as=58.1096p ps=77.98u w=76.46u l=1u
X4221 DVDD GATE BAT DVDD pfet_06v0 ad=61.0812p pd=0.13184m as=49.3848p ps=66.5u w=64.98u l=1u
X4222 DVDD GATE BAT DVDD pfet_06v0 ad=58.1552p pd=78.04u as=58.1552p ps=78.04u w=76.52u l=1u
X4223 BAT GATE DVDD DVDD pfet_06v0 ad=58.0754p pd=77.935u as=58.0754p ps=77.935u w=76.41499u l=1u
X4224 BAT GATE DVDD DVDD pfet_06v0 ad=49.3848p pd=66.5u as=49.3848p ps=66.5u w=64.98u l=1u
X4225 DVDD GATE BAT DVDD pfet_06v0 ad=71.8771p pd=0.15481m as=58.1134p ps=77.985u w=76.465u l=1u
X4226 BAT GATE DVDD DVDD pfet_06v0 ad=58.1134p pd=77.985u as=58.1134p ps=77.985u w=76.465u l=1u
X4227 DVDD GATE BAT DVDD pfet_06v0 ad=58.1552p pd=78.04u as=58.1552p ps=78.04u w=76.52u l=1u
X4228 BAT GATE DVDD DVDD pfet_06v0 ad=35.511p pd=48.245u as=43.9215p ps=95.32999u w=46.725u l=1u
X4229 BAT GATE DVDD DVDD pfet_06v0 ad=58.1172p pd=77.99u as=58.1172p ps=77.99u w=76.47u l=1u
X4230 DVDD GATE BAT DVDD pfet_06v0 ad=35.5072p pd=48.24u as=35.5072p ps=48.24u w=46.72u l=1u
X4231 BAT GATE DVDD DVDD pfet_06v0 ad=58.1134p pd=77.985u as=71.8771p ps=0.15481m w=76.465u l=1u
X4232 DVDD GATE BAT DVDD pfet_06v0 ad=58.1096p pd=77.98u as=58.1096p ps=77.98u w=76.46u l=1u
X4233 BAT GATE DVDD DVDD pfet_06v0 ad=47.6862p pd=64.265u as=47.6862p ps=64.265u w=62.745u l=1u
X4234 BAT GATE DVDD DVDD pfet_06v0 ad=35.511p pd=48.245u as=43.9215p ps=95.32999u w=46.725u l=1u
X4235 DVDD GATE BAT DVDD pfet_06v0 ad=58.0754p pd=77.935u as=58.0754p ps=77.935u w=76.41499u l=1u
X4236 BAT GATE DVDD DVDD pfet_06v0 ad=58.1134p pd=77.985u as=71.8771p ps=0.15481m w=76.465u l=1u
X4237 BAT GATE DVDD DVDD pfet_06v0 ad=58.1134p pd=77.985u as=71.8771p ps=0.15481m w=76.465u l=1u
X4238 BAT GATE DVDD DVDD pfet_06v0 ad=58.1134p pd=77.985u as=58.1134p ps=77.985u w=76.465u l=1u
X4239 DVDD GATE BAT DVDD pfet_06v0 ad=35.511p pd=48.245u as=35.511p ps=48.245u w=46.725u l=1u
X4240 BAT GATE DVDD DVDD pfet_06v0 ad=58.1134p pd=77.985u as=58.1134p ps=77.985u w=76.465u l=1u
X4241 DVDD GATE BAT DVDD pfet_06v0 ad=35.511p pd=48.245u as=35.511p ps=48.245u w=46.725u l=1u
X4242 BAT GATE DVDD DVDD pfet_06v0 ad=35.511p pd=48.245u as=35.511p ps=48.245u w=46.725u l=1u
X4243 BAT GATE DVDD DVDD pfet_06v0 ad=58.1172p pd=77.99u as=58.1172p ps=77.99u w=76.47u l=1u
X4244 BAT GATE DVDD DVDD pfet_06v0 ad=58.1134p pd=77.985u as=58.1134p ps=77.985u w=76.465u l=1u
X4245 BAT GATE DVDD DVDD pfet_06v0 ad=58.1134p pd=77.985u as=58.1134p ps=77.985u w=76.465u l=1u
X4246 DVDD GATE BAT DVDD pfet_06v0 ad=58.1172p pd=77.99u as=58.1172p ps=77.99u w=76.47u l=1u
X4247 BAT GATE DVDD DVDD pfet_06v0 ad=35.511p pd=48.245u as=35.511p ps=48.245u w=46.725u l=1u
X4248 DVDD GATE BAT DVDD pfet_06v0 ad=35.5072p pd=48.24u as=35.5072p ps=48.24u w=46.72u l=1u
X4249 DVDD GATE BAT DVDD pfet_06v0 ad=58.1172p pd=77.99u as=58.1172p ps=77.99u w=76.47u l=1u
X4250 DVDD GATE BAT DVDD pfet_06v0 ad=58.1134p pd=77.985u as=58.1134p ps=77.985u w=76.465u l=1u
X4251 BAT GATE DVDD DVDD pfet_06v0 ad=49.3848p pd=66.5u as=61.0812p ps=0.13184m w=64.98u l=1u
X4252 DVDD GATE BAT DVDD pfet_06v0 ad=35.511p pd=48.245u as=35.511p ps=48.245u w=46.725u l=1u
X4253 BAT GATE DVDD DVDD pfet_06v0 ad=35.511p pd=48.245u as=43.9215p ps=95.32999u w=46.725u l=1u
X4254 BAT GATE DVDD DVDD pfet_06v0 ad=49.3848p pd=66.5u as=49.3848p ps=66.5u w=64.98u l=1u
X4255 BAT GATE DVDD DVDD pfet_06v0 ad=49.3848p pd=66.5u as=49.3848p ps=66.5u w=64.98u l=1u
X4256 DVDD GATE BAT DVDD pfet_06v0 ad=47.6862p pd=64.265u as=47.6862p ps=64.265u w=62.745u l=1u
X4257 BAT GATE DVDD DVDD pfet_06v0 ad=35.511p pd=48.245u as=35.511p ps=48.245u w=46.725u l=1u
X4258 DVDD GATE BAT DVDD pfet_06v0 ad=58.1134p pd=77.985u as=58.1134p ps=77.985u w=76.465u l=1u
X4259 BAT GATE DVDD DVDD pfet_06v0 ad=35.511p pd=48.245u as=35.511p ps=48.245u w=46.725u l=1u
X4260 DVDD GATE BAT DVDD pfet_06v0 ad=35.511p pd=48.245u as=35.511p ps=48.245u w=46.725u l=1u
X4261 BAT GATE DVDD DVDD pfet_06v0 ad=35.511p pd=48.245u as=43.9215p ps=95.32999u w=46.725u l=1u
X4262 DVDD GATE BAT DVDD pfet_06v0 ad=58.1134p pd=77.985u as=58.1134p ps=77.985u w=76.465u l=1u
X4263 BAT GATE DVDD DVDD pfet_06v0 ad=35.511p pd=48.245u as=43.9215p ps=95.32999u w=46.725u l=1u
X4264 DVDD GATE BAT DVDD pfet_06v0 ad=58.1134p pd=77.985u as=58.1134p ps=77.985u w=76.465u l=1u
X4265 DVDD GATE BAT DVDD pfet_06v0 ad=35.511p pd=48.245u as=35.511p ps=48.245u w=46.725u l=1u
X4266 DVDD GATE BAT DVDD pfet_06v0 ad=58.1096p pd=77.98u as=58.1096p ps=77.98u w=76.46u l=1u
X4267 DVDD GATE BAT DVDD pfet_06v0 ad=47.6862p pd=64.265u as=47.6862p ps=64.265u w=62.745u l=1u
X4268 DVDD GATE BAT DVDD pfet_06v0 ad=58.1096p pd=77.98u as=58.1096p ps=77.98u w=76.46u l=1u
X4269 DVDD GATE BAT DVDD pfet_06v0 ad=35.5072p pd=48.24u as=35.5072p ps=48.24u w=46.72u l=1u
X4270 BAT GATE DVDD DVDD pfet_06v0 ad=58.1134p pd=77.985u as=58.1134p ps=77.985u w=76.465u l=1u
X4271 BAT GATE DVDD DVDD pfet_06v0 ad=47.6862p pd=64.265u as=47.6862p ps=64.265u w=62.745u l=1u
X4272 DVDD GATE BAT DVDD pfet_06v0 ad=71.8771p pd=0.15481m as=58.1134p ps=77.985u w=76.465u l=1u
X4273 BAT GATE DVDD DVDD pfet_06v0 ad=35.511p pd=48.245u as=35.511p ps=48.245u w=46.725u l=1u
X4274 DVDD GATE BAT DVDD pfet_06v0 ad=35.511p pd=48.245u as=35.511p ps=48.245u w=46.725u l=1u
X4275 DVDD GATE BAT DVDD pfet_06v0 ad=35.511p pd=48.245u as=35.511p ps=48.245u w=46.725u l=1u
X4276 BAT GATE DVDD DVDD pfet_06v0 ad=58.1096p pd=77.98u as=58.1096p ps=77.98u w=76.46u l=1u
X4277 BAT GATE DVDD DVDD pfet_06v0 ad=35.511p pd=48.245u as=35.511p ps=48.245u w=46.725u l=1u
X4278 BAT GATE DVDD DVDD pfet_06v0 ad=58.1134p pd=77.985u as=58.1134p ps=77.985u w=76.465u l=1u
X4279 DVDD GATE BAT DVDD pfet_06v0 ad=35.511p pd=48.245u as=35.511p ps=48.245u w=46.725u l=1u
X4280 BAT GATE DVDD DVDD pfet_06v0 ad=35.511p pd=48.245u as=43.9215p ps=95.32999u w=46.725u l=1u
X4281 DVDD GATE BAT DVDD pfet_06v0 ad=71.8301p pd=0.15471m as=58.0754p ps=77.935u w=76.41499u l=1u
X4282 DVDD GATE BAT DVDD pfet_06v0 ad=35.511p pd=48.245u as=35.511p ps=48.245u w=46.725u l=1u
X4283 BAT GATE DVDD DVDD pfet_06v0 ad=35.511p pd=48.245u as=35.511p ps=48.245u w=46.725u l=1u
X4284 DVDD GATE BAT DVDD pfet_06v0 ad=58.1134p pd=77.985u as=58.1134p ps=77.985u w=76.465u l=1u
X4285 BAT GATE DVDD DVDD pfet_06v0 ad=58.0754p pd=77.935u as=58.0754p ps=77.935u w=76.41499u l=1u
X4286 DVDD GATE BAT DVDD pfet_06v0 ad=35.511p pd=48.245u as=35.511p ps=48.245u w=46.725u l=1u
X4287 DVDD GATE BAT DVDD pfet_06v0 ad=35.511p pd=48.245u as=35.511p ps=48.245u w=46.725u l=1u
X4288 BAT GATE DVDD DVDD pfet_06v0 ad=35.511p pd=48.245u as=43.9215p ps=95.32999u w=46.725u l=1u
X4289 DVDD GATE BAT DVDD pfet_06v0 ad=35.511p pd=48.245u as=35.511p ps=48.245u w=46.725u l=1u
X4290 DVDD GATE BAT DVDD pfet_06v0 ad=58.1134p pd=77.985u as=58.1134p ps=77.985u w=76.465u l=1u
X4291 BAT GATE DVDD DVDD pfet_06v0 ad=58.1134p pd=77.985u as=58.1134p ps=77.985u w=76.465u l=1u
X4292 DVDD GATE BAT DVDD pfet_06v0 ad=35.511p pd=48.245u as=35.511p ps=48.245u w=46.725u l=1u
X4293 BAT GATE DVDD DVDD pfet_06v0 ad=35.511p pd=48.245u as=35.511p ps=48.245u w=46.725u l=1u
X4294 DVDD GATE BAT DVDD pfet_06v0 ad=58.9803p pd=0.12737m as=47.6862p ps=64.265u w=62.745u l=1u
X4295 BAT GATE DVDD DVDD pfet_06v0 ad=58.1134p pd=77.985u as=58.1134p ps=77.985u w=76.465u l=1u
X4296 DVDD GATE BAT DVDD pfet_06v0 ad=35.511p pd=48.245u as=35.511p ps=48.245u w=46.725u l=1u
X4297 DVDD GATE BAT DVDD pfet_06v0 ad=35.511p pd=48.245u as=35.511p ps=48.245u w=46.725u l=1u
X4298 DVDD GATE BAT DVDD pfet_06v0 ad=35.511p pd=48.245u as=35.511p ps=48.245u w=46.725u l=1u
X4299 BAT GATE DVDD DVDD pfet_06v0 ad=47.6862p pd=64.265u as=47.6862p ps=64.265u w=62.745u l=1u
X4300 BAT GATE DVDD DVDD pfet_06v0 ad=35.511p pd=48.245u as=35.511p ps=48.245u w=46.725u l=1u
X4301 BAT GATE DVDD DVDD pfet_06v0 ad=47.6862p pd=64.265u as=47.6862p ps=64.265u w=62.745u l=1u
X4302 DVDD GATE BAT DVDD pfet_06v0 ad=71.8771p pd=0.15481m as=58.1134p ps=77.985u w=76.465u l=1u
X4303 DVDD GATE BAT DVDD pfet_06v0 ad=35.511p pd=48.245u as=35.511p ps=48.245u w=46.725u l=1u
X4304 BAT GATE DVDD DVDD pfet_06v0 ad=58.1172p pd=77.99u as=58.1172p ps=77.99u w=76.47u l=1u
X4305 BAT GATE DVDD DVDD pfet_06v0 ad=35.511p pd=48.245u as=43.9215p ps=95.32999u w=46.725u l=1u
X4306 BAT GATE DVDD DVDD pfet_06v0 ad=58.1134p pd=77.985u as=58.1134p ps=77.985u w=76.465u l=1u
X4307 DVDD GATE BAT DVDD pfet_06v0 ad=49.3848p pd=66.5u as=49.3848p ps=66.5u w=64.98u l=1u
X4308 BAT GATE DVDD DVDD pfet_06v0 ad=58.1096p pd=77.98u as=58.1096p ps=77.98u w=76.46u l=1u
X4309 DVDD GATE BAT DVDD pfet_06v0 ad=58.1134p pd=77.985u as=58.1134p ps=77.985u w=76.465u l=1u
X4310 DVDD GATE BAT DVDD pfet_06v0 ad=35.511p pd=48.245u as=35.511p ps=48.245u w=46.725u l=1u
X4311 DVDD GATE BAT DVDD pfet_06v0 ad=71.8301p pd=0.15471m as=58.0754p ps=77.935u w=76.41499u l=1u
X4312 BAT GATE DVDD DVDD pfet_06v0 ad=35.511p pd=48.245u as=43.9215p ps=95.32999u w=46.725u l=1u
X4313 BAT GATE DVDD DVDD pfet_06v0 ad=58.1134p pd=77.985u as=58.1134p ps=77.985u w=76.465u l=1u
X4314 BAT GATE DVDD DVDD pfet_06v0 ad=35.511p pd=48.245u as=35.511p ps=48.245u w=46.725u l=1u
X4315 DVDD GATE BAT DVDD pfet_06v0 ad=61.0812p pd=0.13184m as=49.3848p ps=66.5u w=64.98u l=1u
X4316 DVDD GATE BAT DVDD pfet_06v0 ad=35.511p pd=48.245u as=35.511p ps=48.245u w=46.725u l=1u
X4317 BAT GATE DVDD DVDD pfet_06v0 ad=49.3848p pd=66.5u as=49.3848p ps=66.5u w=64.98u l=1u
X4318 BAT GATE DVDD DVDD pfet_06v0 ad=35.511p pd=48.245u as=35.511p ps=48.245u w=46.725u l=1u
X4319 BAT GATE DVDD DVDD pfet_06v0 ad=35.511p pd=48.245u as=35.511p ps=48.245u w=46.725u l=1u
X4320 BAT GATE DVDD DVDD pfet_06v0 ad=58.1134p pd=77.985u as=58.1134p ps=77.985u w=76.465u l=1u
X4321 BAT GATE DVDD DVDD pfet_06v0 ad=58.1134p pd=77.985u as=58.1134p ps=77.985u w=76.465u l=1u
X4322 DVDD GATE BAT DVDD pfet_06v0 ad=58.1172p pd=77.99u as=58.1172p ps=77.99u w=76.47u l=1u
X4323 BAT GATE DVDD DVDD pfet_06v0 ad=58.1134p pd=77.985u as=71.8771p ps=0.15481m w=76.465u l=1u
X4324 BAT GATE DVDD DVDD pfet_06v0 ad=58.1134p pd=77.985u as=71.8771p ps=0.15481m w=76.465u l=1u
X4325 DVDD GATE BAT DVDD pfet_06v0 ad=58.1134p pd=77.985u as=58.1134p ps=77.985u w=76.465u l=1u
X4326 BAT GATE DVDD DVDD pfet_06v0 ad=58.1134p pd=77.985u as=71.8771p ps=0.15481m w=76.465u l=1u
X4327 BAT GATE DVDD DVDD pfet_06v0 ad=35.511p pd=48.245u as=35.511p ps=48.245u w=46.725u l=1u
X4328 DVDD GATE BAT DVDD pfet_06v0 ad=35.511p pd=48.245u as=35.511p ps=48.245u w=46.725u l=1u
X4329 BAT GATE DVDD DVDD pfet_06v0 ad=35.511p pd=48.245u as=35.511p ps=48.245u w=46.725u l=1u
X4330 BAT GATE DVDD DVDD pfet_06v0 ad=58.1096p pd=77.98u as=58.1096p ps=77.98u w=76.46u l=1u
X4331 DVDD GATE BAT DVDD pfet_06v0 ad=71.8771p pd=0.15481m as=58.1134p ps=77.985u w=76.465u l=1u
X4332 DVDD GATE BAT DVDD pfet_06v0 ad=58.1134p pd=77.985u as=58.1134p ps=77.985u w=76.465u l=1u
X4333 BAT GATE DVDD DVDD pfet_06v0 ad=35.511p pd=48.245u as=43.9215p ps=95.32999u w=46.725u l=1u
X4334 BAT GATE DVDD DVDD pfet_06v0 ad=35.511p pd=48.245u as=35.511p ps=48.245u w=46.725u l=1u
X4335 BAT GATE DVDD DVDD pfet_06v0 ad=58.1134p pd=77.985u as=58.1134p ps=77.985u w=76.465u l=1u
X4336 DVDD GATE BAT DVDD pfet_06v0 ad=58.1134p pd=77.985u as=58.1134p ps=77.985u w=76.465u l=1u
X4337 DVDD GATE BAT DVDD pfet_06v0 ad=58.1134p pd=77.985u as=58.1134p ps=77.985u w=76.465u l=1u
X4338 BAT GATE DVDD DVDD pfet_06v0 ad=47.6862p pd=64.265u as=47.6862p ps=64.265u w=62.745u l=1u
X4339 DVDD GATE BAT DVDD pfet_06v0 ad=35.511p pd=48.245u as=35.511p ps=48.245u w=46.725u l=1u
X4340 DVDD GATE BAT DVDD pfet_06v0 ad=71.8724p pd=0.1548m as=58.1096p ps=77.98u w=76.46u l=1u
X4341 DVDD GATE BAT DVDD pfet_06v0 ad=58.1134p pd=77.985u as=58.1134p ps=77.985u w=76.465u l=1u
X4342 BAT GATE DVDD DVDD pfet_06v0 ad=58.1172p pd=77.99u as=58.1172p ps=77.99u w=76.47u l=1u
X4343 BAT GATE DVDD DVDD pfet_06v0 ad=35.511p pd=48.245u as=35.511p ps=48.245u w=46.725u l=1u
X4344 BAT GATE DVDD DVDD pfet_06v0 ad=58.1134p pd=77.985u as=71.8771p ps=0.15481m w=76.465u l=1u
X4345 BAT GATE DVDD DVDD pfet_06v0 ad=58.1134p pd=77.985u as=58.1134p ps=77.985u w=76.465u l=1u
X4346 BAT GATE DVDD DVDD pfet_06v0 ad=58.1134p pd=77.985u as=71.8771p ps=0.15481m w=76.465u l=1u
X4347 DVDD GATE BAT DVDD pfet_06v0 ad=58.1552p pd=78.04u as=58.1552p ps=78.04u w=76.52u l=1u
X4348 BAT GATE DVDD DVDD pfet_06v0 ad=58.1134p pd=77.985u as=71.8771p ps=0.15481m w=76.465u l=1u
X4349 BAT GATE DVDD DVDD pfet_06v0 ad=58.1134p pd=77.985u as=58.1134p ps=77.985u w=76.465u l=1u
X4350 BAT GATE DVDD DVDD pfet_06v0 ad=35.511p pd=48.245u as=35.511p ps=48.245u w=46.725u l=1u
X4351 DVDD GATE BAT DVDD pfet_06v0 ad=35.511p pd=48.245u as=35.511p ps=48.245u w=46.725u l=1u
X4352 DVDD GATE BAT DVDD pfet_06v0 ad=71.8724p pd=0.1548m as=58.1096p ps=77.98u w=76.46u l=1u
X4353 BAT GATE DVDD DVDD pfet_06v0 ad=58.1134p pd=77.985u as=58.1134p ps=77.985u w=76.465u l=1u
X4354 DVDD GATE BAT DVDD pfet_06v0 ad=58.0754p pd=77.935u as=58.0754p ps=77.935u w=76.41499u l=1u
X4355 BAT GATE DVDD DVDD pfet_06v0 ad=47.6862p pd=64.265u as=58.9803p ps=0.12737m w=62.745u l=1u
X4356 BAT GATE DVDD DVDD pfet_06v0 ad=35.511p pd=48.245u as=35.511p ps=48.245u w=46.725u l=1u
X4357 DVDD GATE BAT DVDD pfet_06v0 ad=35.511p pd=48.245u as=35.511p ps=48.245u w=46.725u l=1u
X4358 BAT GATE DVDD DVDD pfet_06v0 ad=35.511p pd=48.245u as=35.511p ps=48.245u w=46.725u l=1u
X4359 BAT GATE DVDD DVDD pfet_06v0 ad=58.1096p pd=77.98u as=58.1096p ps=77.98u w=76.46u l=1u
X4360 BAT GATE DVDD DVDD pfet_06v0 ad=35.511p pd=48.245u as=43.9215p ps=95.32999u w=46.725u l=1u
X4361 BAT GATE DVDD DVDD pfet_06v0 ad=58.1134p pd=77.985u as=58.1134p ps=77.985u w=76.465u l=1u
X4362 BAT GATE DVDD DVDD pfet_06v0 ad=58.1134p pd=77.985u as=58.1134p ps=77.985u w=76.465u l=1u
X4363 DVDD GATE BAT DVDD pfet_06v0 ad=35.511p pd=48.245u as=35.511p ps=48.245u w=46.725u l=1u
X4364 BAT GATE DVDD DVDD pfet_06v0 ad=35.511p pd=48.245u as=35.511p ps=48.245u w=46.725u l=1u
X4365 DVDD GATE BAT DVDD pfet_06v0 ad=58.1134p pd=77.985u as=58.1134p ps=77.985u w=76.465u l=1u
X4366 DVDD GATE BAT DVDD pfet_06v0 ad=71.8818p pd=0.15482m as=58.1172p ps=77.99u w=76.47u l=1u
X4367 BAT GATE DVDD DVDD pfet_06v0 ad=58.0754p pd=77.935u as=71.8301p ps=0.15471m w=76.41499u l=1u
X4368 BAT GATE DVDD DVDD pfet_06v0 ad=49.3848p pd=66.5u as=49.3848p ps=66.5u w=64.98u l=1u
X4369 DVDD GATE BAT DVDD pfet_06v0 ad=43.9215p pd=95.32999u as=35.511p ps=48.245u w=46.725u l=1u
X4370 DVDD GATE BAT DVDD pfet_06v0 ad=47.6862p pd=64.265u as=47.6862p ps=64.265u w=62.745u l=1u
X4371 DVDD GATE BAT DVDD pfet_06v0 ad=58.1134p pd=77.985u as=58.1134p ps=77.985u w=76.465u l=1u
X4372 BAT GATE DVDD DVDD pfet_06v0 ad=58.0754p pd=77.935u as=58.0754p ps=77.935u w=76.41499u l=1u
X4373 DVDD GATE BAT DVDD pfet_06v0 ad=35.511p pd=48.245u as=35.511p ps=48.245u w=46.725u l=1u
X4374 BAT GATE DVDD DVDD pfet_06v0 ad=58.0754p pd=77.935u as=58.0754p ps=77.935u w=76.41499u l=1u
X4375 DVDD GATE BAT DVDD pfet_06v0 ad=58.1096p pd=77.98u as=58.1096p ps=77.98u w=76.46u l=1u
X4376 DVDD GATE BAT DVDD pfet_06v0 ad=35.511p pd=48.245u as=35.511p ps=48.245u w=46.725u l=1u
X4377 DVDD GATE BAT DVDD pfet_06v0 ad=58.1096p pd=77.98u as=58.1096p ps=77.98u w=76.46u l=1u
X4378 BAT GATE DVDD DVDD pfet_06v0 ad=58.1134p pd=77.985u as=58.1134p ps=77.985u w=76.465u l=1u
X4379 DVDD GATE BAT DVDD pfet_06v0 ad=35.511p pd=48.245u as=35.511p ps=48.245u w=46.725u l=1u
X4380 BAT GATE DVDD DVDD pfet_06v0 ad=35.5072p pd=48.24u as=35.5072p ps=48.24u w=46.72u l=1u
X4381 DVDD GATE BAT DVDD pfet_06v0 ad=35.511p pd=48.245u as=35.511p ps=48.245u w=46.725u l=1u
X4382 DVDD GATE BAT DVDD pfet_06v0 ad=35.511p pd=48.245u as=35.511p ps=48.245u w=46.725u l=1u
X4383 BAT GATE DVDD DVDD pfet_06v0 ad=35.511p pd=48.245u as=35.511p ps=48.245u w=46.725u l=1u
X4384 BAT GATE DVDD DVDD pfet_06v0 ad=35.511p pd=48.245u as=35.511p ps=48.245u w=46.725u l=1u
X4385 DVDD GATE BAT DVDD pfet_06v0 ad=35.511p pd=48.245u as=35.511p ps=48.245u w=46.725u l=1u
X4386 DVDD GATE BAT DVDD pfet_06v0 ad=35.5072p pd=48.24u as=35.5072p ps=48.24u w=46.72u l=1u
X4387 DVDD GATE BAT DVDD pfet_06v0 ad=43.9215p pd=95.32999u as=35.511p ps=48.245u w=46.725u l=1u
X4388 DVDD GATE BAT DVDD pfet_06v0 ad=47.6862p pd=64.265u as=47.6862p ps=64.265u w=62.745u l=1u
X4389 DVDD GATE BAT DVDD pfet_06v0 ad=58.1134p pd=77.985u as=58.1134p ps=77.985u w=76.465u l=1u
X4390 DVDD GATE BAT DVDD pfet_06v0 ad=35.511p pd=48.245u as=35.511p ps=48.245u w=46.725u l=1u
X4391 BAT GATE DVDD DVDD pfet_06v0 ad=35.511p pd=48.245u as=43.9215p ps=95.32999u w=46.725u l=1u
X4392 BAT GATE DVDD DVDD pfet_06v0 ad=35.511p pd=48.245u as=35.511p ps=48.245u w=46.725u l=1u
X4393 DVDD GATE BAT DVDD pfet_06v0 ad=35.511p pd=48.245u as=35.511p ps=48.245u w=46.725u l=1u
X4394 DVDD GATE BAT DVDD pfet_06v0 ad=35.5072p pd=48.24u as=35.5072p ps=48.24u w=46.72u l=1u
X4395 BAT GATE DVDD DVDD pfet_06v0 ad=58.1096p pd=77.98u as=58.1096p ps=77.98u w=76.46u l=1u
X4396 DVDD GATE BAT DVDD pfet_06v0 ad=35.511p pd=48.245u as=35.511p ps=48.245u w=46.725u l=1u
X4397 BAT GATE DVDD DVDD pfet_06v0 ad=58.1134p pd=77.985u as=58.1134p ps=77.985u w=76.465u l=1u
X4398 BAT GATE DVDD DVDD pfet_06v0 ad=35.511p pd=48.245u as=35.511p ps=48.245u w=46.725u l=1u
X4399 BAT GATE DVDD DVDD pfet_06v0 ad=35.511p pd=48.245u as=35.511p ps=48.245u w=46.725u l=1u
X4400 DVDD GATE BAT DVDD pfet_06v0 ad=35.511p pd=48.245u as=35.511p ps=48.245u w=46.725u l=1u
X4401 BAT GATE DVDD DVDD pfet_06v0 ad=35.511p pd=48.245u as=35.511p ps=48.245u w=46.725u l=1u
X4402 DVDD GATE BAT DVDD pfet_06v0 ad=47.6862p pd=64.265u as=47.6862p ps=64.265u w=62.745u l=1u
X4403 BAT GATE DVDD DVDD pfet_06v0 ad=58.1134p pd=77.985u as=58.1134p ps=77.985u w=76.465u l=1u
X4404 BAT GATE DVDD DVDD pfet_06v0 ad=58.1552p pd=78.04u as=71.92879p ps=0.15492m w=76.52u l=1u
X4405 BAT GATE DVDD DVDD pfet_06v0 ad=35.511p pd=48.245u as=35.511p ps=48.245u w=46.725u l=1u
X4406 BAT GATE DVDD DVDD pfet_06v0 ad=58.1552p pd=78.04u as=58.1552p ps=78.04u w=76.52u l=1u
X4407 DVDD GATE BAT DVDD pfet_06v0 ad=35.511p pd=48.245u as=35.511p ps=48.245u w=46.725u l=1u
X4408 BAT GATE DVDD DVDD pfet_06v0 ad=35.5072p pd=48.24u as=35.5072p ps=48.24u w=46.72u l=1u
X4409 DVDD GATE BAT DVDD pfet_06v0 ad=58.1172p pd=77.99u as=58.1172p ps=77.99u w=76.47u l=1u
X4410 DVDD GATE BAT DVDD pfet_06v0 ad=71.92879p pd=0.15492m as=58.1552p ps=78.04u w=76.52u l=1u
X4411 BAT GATE DVDD DVDD pfet_06v0 ad=58.1134p pd=77.985u as=58.1134p ps=77.985u w=76.465u l=1u
X4412 BAT GATE DVDD DVDD pfet_06v0 ad=58.1552p pd=78.04u as=58.1552p ps=78.04u w=76.52u l=1u
X4413 DVDD GATE BAT DVDD pfet_06v0 ad=58.1134p pd=77.985u as=58.1134p ps=77.985u w=76.465u l=1u
X4414 DVDD GATE BAT DVDD pfet_06v0 ad=47.6862p pd=64.265u as=47.6862p ps=64.265u w=62.745u l=1u
X4415 DVDD GATE BAT DVDD pfet_06v0 ad=35.511p pd=48.245u as=35.511p ps=48.245u w=46.725u l=1u
X4416 DVDD GATE BAT DVDD pfet_06v0 ad=58.1552p pd=78.04u as=58.1552p ps=78.04u w=76.52u l=1u
X4417 BAT GATE DVDD DVDD pfet_06v0 ad=35.511p pd=48.245u as=35.511p ps=48.245u w=46.725u l=1u
X4418 DVDD GATE BAT DVDD pfet_06v0 ad=71.8771p pd=0.15481m as=58.1134p ps=77.985u w=76.465u l=1u
X4419 DVDD GATE BAT DVDD pfet_06v0 ad=58.1134p pd=77.985u as=58.1134p ps=77.985u w=76.465u l=1u
X4420 DVDD GATE BAT DVDD pfet_06v0 ad=35.511p pd=48.245u as=35.511p ps=48.245u w=46.725u l=1u
X4421 BAT GATE DVDD DVDD pfet_06v0 ad=58.1134p pd=77.985u as=58.1134p ps=77.985u w=76.465u l=1u
X4422 DVDD GATE BAT DVDD pfet_06v0 ad=58.1134p pd=77.985u as=58.1134p ps=77.985u w=76.465u l=1u
X4423 DVDD GATE BAT DVDD pfet_06v0 ad=58.1134p pd=77.985u as=58.1134p ps=77.985u w=76.465u l=1u
X4424 BAT GATE DVDD DVDD pfet_06v0 ad=58.1134p pd=77.985u as=58.1134p ps=77.985u w=76.465u l=1u
X4425 DVDD GATE BAT DVDD pfet_06v0 ad=43.9215p pd=95.32999u as=35.511p ps=48.245u w=46.725u l=1u
X4426 BAT GATE DVDD DVDD pfet_06v0 ad=49.3848p pd=66.5u as=61.0812p ps=0.13184m w=64.98u l=1u
X4427 BAT GATE DVDD DVDD pfet_06v0 ad=35.511p pd=48.245u as=43.9215p ps=95.32999u w=46.725u l=1u
X4428 DVDD GATE BAT DVDD pfet_06v0 ad=35.511p pd=48.245u as=35.511p ps=48.245u w=46.725u l=1u
X4429 DVDD GATE BAT DVDD pfet_06v0 ad=35.511p pd=48.245u as=35.511p ps=48.245u w=46.725u l=1u
X4430 DVDD GATE BAT DVDD pfet_06v0 ad=71.8771p pd=0.15481m as=58.1134p ps=77.985u w=76.465u l=1u
X4431 DVDD GATE BAT DVDD pfet_06v0 ad=35.511p pd=48.245u as=35.511p ps=48.245u w=46.725u l=1u
X4432 DVDD GATE BAT DVDD pfet_06v0 ad=58.1134p pd=77.985u as=58.1134p ps=77.985u w=76.465u l=1u
X4433 BAT GATE DVDD DVDD pfet_06v0 ad=58.1134p pd=77.985u as=58.1134p ps=77.985u w=76.465u l=1u
X4434 DVDD GATE BAT DVDD pfet_06v0 ad=58.1172p pd=77.99u as=58.1172p ps=77.99u w=76.47u l=1u
X4435 DVDD GATE BAT DVDD pfet_06v0 ad=49.3848p pd=66.5u as=49.3848p ps=66.5u w=64.98u l=1u
X4436 BAT GATE DVDD DVDD pfet_06v0 ad=58.1134p pd=77.985u as=58.1134p ps=77.985u w=76.465u l=1u
X4437 DVDD GATE BAT DVDD pfet_06v0 ad=58.0754p pd=77.935u as=58.0754p ps=77.935u w=76.41499u l=1u
X4438 DVDD GATE BAT DVDD pfet_06v0 ad=47.6862p pd=64.265u as=47.6862p ps=64.265u w=62.745u l=1u
X4439 BAT GATE DVDD DVDD pfet_06v0 ad=58.1134p pd=77.985u as=58.1134p ps=77.985u w=76.465u l=1u
X4440 DVDD GATE BAT DVDD pfet_06v0 ad=58.1134p pd=77.985u as=58.1134p ps=77.985u w=76.465u l=1u
X4441 DVDD GATE BAT DVDD pfet_06v0 ad=58.1172p pd=77.99u as=58.1172p ps=77.99u w=76.47u l=1u
X4442 DVDD GATE BAT DVDD pfet_06v0 ad=35.511p pd=48.245u as=35.511p ps=48.245u w=46.725u l=1u
X4443 DVDD GATE BAT DVDD pfet_06v0 ad=35.511p pd=48.245u as=35.511p ps=48.245u w=46.725u l=1u
X4444 BAT GATE DVDD DVDD pfet_06v0 ad=35.511p pd=48.245u as=35.511p ps=48.245u w=46.725u l=1u
X4445 DVDD GATE BAT DVDD pfet_06v0 ad=35.511p pd=48.245u as=35.511p ps=48.245u w=46.725u l=1u
X4446 DVDD GATE BAT DVDD pfet_06v0 ad=71.8771p pd=0.15481m as=58.1134p ps=77.985u w=76.465u l=1u
X4447 DVDD GATE BAT DVDD pfet_06v0 ad=58.1134p pd=77.985u as=58.1134p ps=77.985u w=76.465u l=1u
X4448 BAT GATE DVDD DVDD pfet_06v0 ad=58.1096p pd=77.98u as=58.1096p ps=77.98u w=76.46u l=1u
X4449 DVDD GATE BAT DVDD pfet_06v0 ad=43.9215p pd=95.32999u as=35.511p ps=48.245u w=46.725u l=1u
X4450 DVDD GATE BAT DVDD pfet_06v0 ad=47.6862p pd=64.265u as=47.6862p ps=64.265u w=62.745u l=1u
X4451 BAT GATE DVDD DVDD pfet_06v0 ad=35.511p pd=48.245u as=43.9215p ps=95.32999u w=46.725u l=1u
X4452 BAT GATE DVDD DVDD pfet_06v0 ad=35.511p pd=48.245u as=35.511p ps=48.245u w=46.725u l=1u
X4453 DVDD GATE BAT DVDD pfet_06v0 ad=58.1134p pd=77.985u as=58.1134p ps=77.985u w=76.465u l=1u
X4454 DVDD GATE BAT DVDD pfet_06v0 ad=58.1096p pd=77.98u as=58.1096p ps=77.98u w=76.46u l=1u
X4455 DVDD GATE BAT DVDD pfet_06v0 ad=35.511p pd=48.245u as=35.511p ps=48.245u w=46.725u l=1u
X4456 BAT GATE DVDD DVDD pfet_06v0 ad=35.5072p pd=48.24u as=35.5072p ps=48.24u w=46.72u l=1u
X4457 BAT GATE DVDD DVDD pfet_06v0 ad=58.1172p pd=77.99u as=58.1172p ps=77.99u w=76.47u l=1u
X4458 DVDD GATE BAT DVDD pfet_06v0 ad=43.9215p pd=95.32999u as=35.511p ps=48.245u w=46.725u l=1u
X4459 BAT GATE DVDD DVDD pfet_06v0 ad=35.511p pd=48.245u as=35.511p ps=48.245u w=46.725u l=1u
X4460 DVDD GATE BAT DVDD pfet_06v0 ad=35.511p pd=48.245u as=35.511p ps=48.245u w=46.725u l=1u
X4461 BAT GATE DVDD DVDD pfet_06v0 ad=58.1134p pd=77.985u as=71.8771p ps=0.15481m w=76.465u l=1u
X4462 DVDD GATE BAT DVDD pfet_06v0 ad=49.3848p pd=66.5u as=49.3848p ps=66.5u w=64.98u l=1u
X4463 BAT GATE DVDD DVDD pfet_06v0 ad=35.5072p pd=48.24u as=35.5072p ps=48.24u w=46.72u l=1u
X4464 DVDD GATE BAT DVDD pfet_06v0 ad=43.9215p pd=95.32999u as=35.511p ps=48.245u w=46.725u l=1u
X4465 DVDD GATE BAT DVDD pfet_06v0 ad=35.511p pd=48.245u as=35.511p ps=48.245u w=46.725u l=1u
X4466 DVDD GATE BAT DVDD pfet_06v0 ad=43.9215p pd=95.32999u as=35.511p ps=48.245u w=46.725u l=1u
X4467 DVDD GATE BAT DVDD pfet_06v0 ad=35.511p pd=48.245u as=35.511p ps=48.245u w=46.725u l=1u
X4468 DVDD GATE BAT DVDD pfet_06v0 ad=49.3848p pd=66.5u as=49.3848p ps=66.5u w=64.98u l=1u
X4469 BAT GATE DVDD DVDD pfet_06v0 ad=35.511p pd=48.245u as=35.511p ps=48.245u w=46.725u l=1u
X4470 DVDD GATE BAT DVDD pfet_06v0 ad=35.511p pd=48.245u as=35.511p ps=48.245u w=46.725u l=1u
X4471 BAT GATE DVDD DVDD pfet_06v0 ad=58.1134p pd=77.985u as=58.1134p ps=77.985u w=76.465u l=1u
X4472 BAT GATE DVDD DVDD pfet_06v0 ad=58.1134p pd=77.985u as=58.1134p ps=77.985u w=76.465u l=1u
X4473 DVDD GATE BAT DVDD pfet_06v0 ad=35.511p pd=48.245u as=35.511p ps=48.245u w=46.725u l=1u
X4474 DVDD GATE BAT DVDD pfet_06v0 ad=58.0754p pd=77.935u as=58.0754p ps=77.935u w=76.41499u l=1u
X4475 DVDD GATE BAT DVDD pfet_06v0 ad=71.8771p pd=0.15481m as=58.1134p ps=77.985u w=76.465u l=1u
X4476 BAT GATE DVDD DVDD pfet_06v0 ad=35.511p pd=48.245u as=43.9215p ps=95.32999u w=46.725u l=1u
X4477 DVDD GATE BAT DVDD pfet_06v0 ad=35.5072p pd=48.24u as=35.5072p ps=48.24u w=46.72u l=1u
X4478 BAT GATE DVDD DVDD pfet_06v0 ad=58.1096p pd=77.98u as=71.8724p ps=0.1548m w=76.46u l=1u
X4479 DVDD GATE BAT DVDD pfet_06v0 ad=58.1134p pd=77.985u as=58.1134p ps=77.985u w=76.465u l=1u
X4480 BAT GATE DVDD DVDD pfet_06v0 ad=58.1134p pd=77.985u as=58.1134p ps=77.985u w=76.465u l=1u
X4481 BAT GATE DVDD DVDD pfet_06v0 ad=58.1134p pd=77.985u as=58.1134p ps=77.985u w=76.465u l=1u
X4482 BAT GATE DVDD DVDD pfet_06v0 ad=47.6862p pd=64.265u as=47.6862p ps=64.265u w=62.745u l=1u
X4483 BAT GATE DVDD DVDD pfet_06v0 ad=35.511p pd=48.245u as=35.511p ps=48.245u w=46.725u l=1u
X4484 DVDD GATE BAT DVDD pfet_06v0 ad=35.5072p pd=48.24u as=35.5072p ps=48.24u w=46.72u l=1u
X4485 DVDD GATE BAT DVDD pfet_06v0 ad=71.8771p pd=0.15481m as=58.1134p ps=77.985u w=76.465u l=1u
X4486 BAT GATE DVDD DVDD pfet_06v0 ad=47.6862p pd=64.265u as=47.6862p ps=64.265u w=62.745u l=1u
X4487 BAT GATE DVDD DVDD pfet_06v0 ad=35.511p pd=48.245u as=35.511p ps=48.245u w=46.725u l=1u
X4488 BAT GATE DVDD DVDD pfet_06v0 ad=35.511p pd=48.245u as=35.511p ps=48.245u w=46.725u l=1u
X4489 DVDD GATE BAT DVDD pfet_06v0 ad=58.1134p pd=77.985u as=58.1134p ps=77.985u w=76.465u l=1u
X4490 BAT GATE DVDD DVDD pfet_06v0 ad=35.5072p pd=48.24u as=35.5072p ps=48.24u w=46.72u l=1u
X4491 DVDD GATE BAT DVDD pfet_06v0 ad=35.511p pd=48.245u as=35.511p ps=48.245u w=46.725u l=1u
X4492 DVDD GATE BAT DVDD pfet_06v0 ad=58.1134p pd=77.985u as=58.1134p ps=77.985u w=76.465u l=1u
X4493 BAT GATE DVDD DVDD pfet_06v0 ad=58.1134p pd=77.985u as=58.1134p ps=77.985u w=76.465u l=1u
X4494 BAT GATE DVDD DVDD pfet_06v0 ad=35.5072p pd=48.24u as=43.9168p ps=95.32u w=46.72u l=1u
X4495 BAT GATE DVDD DVDD pfet_06v0 ad=35.511p pd=48.245u as=35.511p ps=48.245u w=46.725u l=1u
X4496 BAT GATE DVDD DVDD pfet_06v0 ad=35.511p pd=48.245u as=35.511p ps=48.245u w=46.725u l=1u
X4497 DVDD GATE BAT DVDD pfet_06v0 ad=43.9215p pd=95.32999u as=35.511p ps=48.245u w=46.725u l=1u
X4498 BAT GATE DVDD DVDD pfet_06v0 ad=35.511p pd=48.245u as=43.9215p ps=95.32999u w=46.725u l=1u
X4499 DVDD GATE BAT DVDD pfet_06v0 ad=71.8771p pd=0.15481m as=58.1134p ps=77.985u w=76.465u l=1u
X4500 DVDD GATE BAT DVDD pfet_06v0 ad=71.8771p pd=0.15481m as=58.1134p ps=77.985u w=76.465u l=1u
X4501 BAT GATE DVDD DVDD pfet_06v0 ad=35.511p pd=48.245u as=35.511p ps=48.245u w=46.725u l=1u
X4502 DVDD GATE BAT DVDD pfet_06v0 ad=35.511p pd=48.245u as=35.511p ps=48.245u w=46.725u l=1u
X4503 BAT GATE DVDD DVDD pfet_06v0 ad=35.511p pd=48.245u as=35.511p ps=48.245u w=46.725u l=1u
X4504 BAT GATE DVDD DVDD pfet_06v0 ad=35.511p pd=48.245u as=35.511p ps=48.245u w=46.725u l=1u
X4505 DVDD GATE BAT DVDD pfet_06v0 ad=35.511p pd=48.245u as=35.511p ps=48.245u w=46.725u l=1u
X4506 BAT GATE DVDD DVDD pfet_06v0 ad=35.5072p pd=48.24u as=35.5072p ps=48.24u w=46.72u l=1u
X4507 BAT GATE DVDD DVDD pfet_06v0 ad=58.1552p pd=78.04u as=71.92879p ps=0.15492m w=76.52u l=1u
X4508 DVDD GATE BAT DVDD pfet_06v0 ad=35.511p pd=48.245u as=35.511p ps=48.245u w=46.725u l=1u
X4509 BAT GATE DVDD DVDD pfet_06v0 ad=47.6862p pd=64.265u as=47.6862p ps=64.265u w=62.745u l=1u
X4510 BAT GATE DVDD DVDD pfet_06v0 ad=58.1134p pd=77.985u as=58.1134p ps=77.985u w=76.465u l=1u
X4511 DVDD GATE BAT DVDD pfet_06v0 ad=58.0754p pd=77.935u as=58.0754p ps=77.935u w=76.41499u l=1u
X4512 BAT GATE DVDD DVDD pfet_06v0 ad=58.1134p pd=77.985u as=58.1134p ps=77.985u w=76.465u l=1u
X4513 DVDD GATE BAT DVDD pfet_06v0 ad=58.1134p pd=77.985u as=58.1134p ps=77.985u w=76.465u l=1u
X4514 DVDD GATE BAT DVDD pfet_06v0 ad=43.9215p pd=95.32999u as=35.511p ps=48.245u w=46.725u l=1u
X4515 DVDD GATE BAT DVDD pfet_06v0 ad=35.5072p pd=48.24u as=35.5072p ps=48.24u w=46.72u l=1u
X4516 BAT GATE DVDD DVDD pfet_06v0 ad=35.511p pd=48.245u as=35.511p ps=48.245u w=46.725u l=1u
X4517 DVDD GATE BAT DVDD pfet_06v0 ad=43.9215p pd=95.32999u as=35.511p ps=48.245u w=46.725u l=1u
X4518 BAT GATE DVDD DVDD pfet_06v0 ad=35.511p pd=48.245u as=35.511p ps=48.245u w=46.725u l=1u
X4519 BAT GATE DVDD DVDD pfet_06v0 ad=58.1172p pd=77.99u as=71.8818p ps=0.15482m w=76.47u l=1u
X4520 BAT GATE DVDD DVDD pfet_06v0 ad=35.511p pd=48.245u as=35.511p ps=48.245u w=46.725u l=1u
X4521 DVDD GATE BAT DVDD pfet_06v0 ad=58.1134p pd=77.985u as=58.1134p ps=77.985u w=76.465u l=1u
X4522 DVDD GATE BAT DVDD pfet_06v0 ad=58.1552p pd=78.04u as=58.1552p ps=78.04u w=76.52u l=1u
X4523 BAT GATE DVDD DVDD pfet_06v0 ad=35.511p pd=48.245u as=35.511p ps=48.245u w=46.725u l=1u
X4524 BAT GATE DVDD DVDD pfet_06v0 ad=58.1134p pd=77.985u as=58.1134p ps=77.985u w=76.465u l=1u
X4525 DVDD GATE BAT DVDD pfet_06v0 ad=43.9215p pd=95.32999u as=35.511p ps=48.245u w=46.725u l=1u
X4526 DVDD GATE BAT DVDD pfet_06v0 ad=35.511p pd=48.245u as=35.511p ps=48.245u w=46.725u l=1u
X4527 BAT GATE DVDD DVDD pfet_06v0 ad=47.6862p pd=64.265u as=47.6862p ps=64.265u w=62.745u l=1u
X4528 BAT GATE DVDD DVDD pfet_06v0 ad=47.6862p pd=64.265u as=47.6862p ps=64.265u w=62.745u l=1u
X4529 DVDD GATE BAT DVDD pfet_06v0 ad=58.1134p pd=77.985u as=58.1134p ps=77.985u w=76.465u l=1u
X4530 DVDD GATE BAT DVDD pfet_06v0 ad=58.1134p pd=77.985u as=58.1134p ps=77.985u w=76.465u l=1u
X4531 DVDD GATE BAT DVDD pfet_06v0 ad=58.1134p pd=77.985u as=58.1134p ps=77.985u w=76.465u l=1u
X4532 BAT GATE DVDD DVDD pfet_06v0 ad=58.1134p pd=77.985u as=58.1134p ps=77.985u w=76.465u l=1u
X4533 DVDD GATE BAT DVDD pfet_06v0 ad=58.1134p pd=77.985u as=58.1134p ps=77.985u w=76.465u l=1u
X4534 BAT GATE DVDD DVDD pfet_06v0 ad=35.511p pd=48.245u as=43.9215p ps=95.32999u w=46.725u l=1u
X4535 BAT GATE DVDD DVDD pfet_06v0 ad=35.511p pd=48.245u as=35.511p ps=48.245u w=46.725u l=1u
X4536 BAT GATE DVDD DVDD pfet_06v0 ad=58.1134p pd=77.985u as=58.1134p ps=77.985u w=76.465u l=1u
X4537 BAT GATE DVDD DVDD pfet_06v0 ad=35.511p pd=48.245u as=35.511p ps=48.245u w=46.725u l=1u
X4538 BAT GATE DVDD DVDD pfet_06v0 ad=58.1134p pd=77.985u as=58.1134p ps=77.985u w=76.465u l=1u
X4539 BAT GATE DVDD DVDD pfet_06v0 ad=35.511p pd=48.245u as=43.9215p ps=95.32999u w=46.725u l=1u
X4540 DVDD GATE BAT DVDD pfet_06v0 ad=58.1134p pd=77.985u as=58.1134p ps=77.985u w=76.465u l=1u
X4541 BAT GATE DVDD DVDD pfet_06v0 ad=58.0754p pd=77.935u as=58.0754p ps=77.935u w=76.41499u l=1u
X4542 BAT GATE DVDD DVDD pfet_06v0 ad=49.3848p pd=66.5u as=49.3848p ps=66.5u w=64.98u l=1u
X4543 BAT GATE DVDD DVDD pfet_06v0 ad=58.1134p pd=77.985u as=58.1134p ps=77.985u w=76.465u l=1u
X4544 BAT GATE DVDD DVDD pfet_06v0 ad=58.1552p pd=78.04u as=58.1552p ps=78.04u w=76.52u l=1u
X4545 DVDD GATE BAT DVDD pfet_06v0 ad=58.1134p pd=77.985u as=58.1134p ps=77.985u w=76.465u l=1u
X4546 DVDD GATE BAT DVDD pfet_06v0 ad=43.9215p pd=95.32999u as=35.511p ps=48.245u w=46.725u l=1u
X4547 DVDD GATE BAT DVDD pfet_06v0 ad=58.1134p pd=77.985u as=58.1134p ps=77.985u w=76.465u l=1u
X4548 BAT GATE DVDD DVDD pfet_06v0 ad=58.1134p pd=77.985u as=71.8771p ps=0.15481m w=76.465u l=1u
X4549 DVDD GATE BAT DVDD pfet_06v0 ad=71.8771p pd=0.15481m as=58.1134p ps=77.985u w=76.465u l=1u
X4550 DVDD GATE BAT DVDD pfet_06v0 ad=58.1096p pd=77.98u as=58.1096p ps=77.98u w=76.46u l=1u
X4551 BAT GATE DVDD DVDD pfet_06v0 ad=35.511p pd=48.245u as=35.511p ps=48.245u w=46.725u l=1u
X4552 BAT GATE DVDD DVDD pfet_06v0 ad=35.511p pd=48.245u as=35.511p ps=48.245u w=46.725u l=1u
X4553 BAT GATE DVDD DVDD pfet_06v0 ad=47.6862p pd=64.265u as=47.6862p ps=64.265u w=62.745u l=1u
X4554 DVDD GATE BAT DVDD pfet_06v0 ad=43.9215p pd=95.32999u as=35.511p ps=48.245u w=46.725u l=1u
X4555 DVDD GATE BAT DVDD pfet_06v0 ad=71.8771p pd=0.15481m as=58.1134p ps=77.985u w=76.465u l=1u
X4556 DVDD GATE BAT DVDD pfet_06v0 ad=35.511p pd=48.245u as=35.511p ps=48.245u w=46.725u l=1u
X4557 BAT GATE DVDD DVDD pfet_06v0 ad=58.1134p pd=77.985u as=58.1134p ps=77.985u w=76.465u l=1u
X4558 DVDD GATE BAT DVDD pfet_06v0 ad=35.511p pd=48.245u as=35.511p ps=48.245u w=46.725u l=1u
X4559 DVDD GATE BAT DVDD pfet_06v0 ad=35.511p pd=48.245u as=35.511p ps=48.245u w=46.725u l=1u
X4560 BAT GATE DVDD DVDD pfet_06v0 ad=58.1134p pd=77.985u as=58.1134p ps=77.985u w=76.465u l=1u
X4561 BAT GATE DVDD DVDD pfet_06v0 ad=35.511p pd=48.245u as=35.511p ps=48.245u w=46.725u l=1u
X4562 BAT GATE DVDD DVDD pfet_06v0 ad=58.1172p pd=77.99u as=58.1172p ps=77.99u w=76.47u l=1u
X4563 BAT GATE DVDD DVDD pfet_06v0 ad=58.1134p pd=77.985u as=58.1134p ps=77.985u w=76.465u l=1u
X4564 BAT GATE DVDD DVDD pfet_06v0 ad=35.511p pd=48.245u as=35.511p ps=48.245u w=46.725u l=1u
X4565 DVDD GATE BAT DVDD pfet_06v0 ad=35.5072p pd=48.24u as=35.5072p ps=48.24u w=46.72u l=1u
X4566 DVDD GATE BAT DVDD pfet_06v0 ad=71.8771p pd=0.15481m as=58.1134p ps=77.985u w=76.465u l=1u
X4567 DVDD GATE BAT DVDD pfet_06v0 ad=35.511p pd=48.245u as=35.511p ps=48.245u w=46.725u l=1u
X4568 BAT GATE DVDD DVDD pfet_06v0 ad=49.3848p pd=66.5u as=49.3848p ps=66.5u w=64.98u l=1u
X4569 DVDD GATE BAT DVDD pfet_06v0 ad=35.511p pd=48.245u as=35.511p ps=48.245u w=46.725u l=1u
X4570 DVDD GATE BAT DVDD pfet_06v0 ad=35.511p pd=48.245u as=35.511p ps=48.245u w=46.725u l=1u
X4571 BAT GATE DVDD DVDD pfet_06v0 ad=35.511p pd=48.245u as=35.511p ps=48.245u w=46.725u l=1u
X4572 BAT GATE DVDD DVDD pfet_06v0 ad=35.511p pd=48.245u as=43.9215p ps=95.32999u w=46.725u l=1u
X4573 BAT GATE DVDD DVDD pfet_06v0 ad=58.1096p pd=77.98u as=58.1096p ps=77.98u w=76.46u l=1u
X4574 DVDD GATE BAT DVDD pfet_06v0 ad=58.1134p pd=77.985u as=58.1134p ps=77.985u w=76.465u l=1u
X4575 BAT GATE DVDD DVDD pfet_06v0 ad=35.511p pd=48.245u as=35.511p ps=48.245u w=46.725u l=1u
X4576 BAT GATE DVDD DVDD pfet_06v0 ad=58.1134p pd=77.985u as=58.1134p ps=77.985u w=76.465u l=1u
X4577 BAT GATE DVDD DVDD pfet_06v0 ad=35.511p pd=48.245u as=43.9215p ps=95.32999u w=46.725u l=1u
X4578 DVDD GATE BAT DVDD pfet_06v0 ad=35.511p pd=48.245u as=35.511p ps=48.245u w=46.725u l=1u
X4579 DVDD GATE BAT DVDD pfet_06v0 ad=43.9215p pd=95.32999u as=35.511p ps=48.245u w=46.725u l=1u
X4580 DVDD GATE BAT DVDD pfet_06v0 ad=71.8771p pd=0.15481m as=58.1134p ps=77.985u w=76.465u l=1u
X4581 DVDD GATE BAT DVDD pfet_06v0 ad=43.9215p pd=95.32999u as=35.511p ps=48.245u w=46.725u l=1u
X4582 DVDD GATE BAT DVDD pfet_06v0 ad=58.1134p pd=77.985u as=58.1134p ps=77.985u w=76.465u l=1u
X4583 DVDD GATE BAT DVDD pfet_06v0 ad=58.1134p pd=77.985u as=58.1134p ps=77.985u w=76.465u l=1u
X4584 DVDD GATE BAT DVDD pfet_06v0 ad=47.6862p pd=64.265u as=47.6862p ps=64.265u w=62.745u l=1u
X4585 DVDD GATE BAT DVDD pfet_06v0 ad=35.511p pd=48.245u as=35.511p ps=48.245u w=46.725u l=1u
X4586 DVDD GATE BAT DVDD pfet_06v0 ad=35.511p pd=48.245u as=35.511p ps=48.245u w=46.725u l=1u
X4587 DVDD GATE BAT DVDD pfet_06v0 ad=35.511p pd=48.245u as=35.511p ps=48.245u w=46.725u l=1u
X4588 DVDD GATE BAT DVDD pfet_06v0 ad=58.1096p pd=77.98u as=58.1096p ps=77.98u w=76.46u l=1u
X4589 BAT GATE DVDD DVDD pfet_06v0 ad=58.1134p pd=77.985u as=58.1134p ps=77.985u w=76.465u l=1u
X4590 BAT GATE DVDD DVDD pfet_06v0 ad=58.1172p pd=77.99u as=58.1172p ps=77.99u w=76.47u l=1u
X4591 BAT GATE DVDD DVDD pfet_06v0 ad=58.1134p pd=77.985u as=58.1134p ps=77.985u w=76.465u l=1u
X4592 DVDD GATE BAT DVDD pfet_06v0 ad=35.5072p pd=48.24u as=35.5072p ps=48.24u w=46.72u l=1u
X4593 BAT GATE DVDD DVDD pfet_06v0 ad=35.511p pd=48.245u as=43.9215p ps=95.32999u w=46.725u l=1u
X4594 BAT GATE DVDD DVDD pfet_06v0 ad=35.511p pd=48.245u as=35.511p ps=48.245u w=46.725u l=1u
X4595 DVDD GATE BAT DVDD pfet_06v0 ad=58.1134p pd=77.985u as=58.1134p ps=77.985u w=76.465u l=1u
X4596 DVDD GATE BAT DVDD pfet_06v0 ad=35.511p pd=48.245u as=35.511p ps=48.245u w=46.725u l=1u
X4597 DVDD GATE BAT DVDD pfet_06v0 ad=35.511p pd=48.245u as=35.511p ps=48.245u w=46.725u l=1u
X4598 BAT GATE DVDD DVDD pfet_06v0 ad=49.3848p pd=66.5u as=49.3848p ps=66.5u w=64.98u l=1u
X4599 BAT GATE DVDD DVDD pfet_06v0 ad=35.511p pd=48.245u as=35.511p ps=48.245u w=46.725u l=1u
X4600 BAT GATE DVDD DVDD pfet_06v0 ad=58.1096p pd=77.98u as=58.1096p ps=77.98u w=76.46u l=1u
X4601 BAT GATE DVDD DVDD pfet_06v0 ad=35.511p pd=48.245u as=35.511p ps=48.245u w=46.725u l=1u
X4602 DVDD GATE BAT DVDD pfet_06v0 ad=35.511p pd=48.245u as=35.511p ps=48.245u w=46.725u l=1u
X4603 BAT GATE DVDD DVDD pfet_06v0 ad=58.1134p pd=77.985u as=58.1134p ps=77.985u w=76.465u l=1u
X4604 DVDD GATE BAT DVDD pfet_06v0 ad=43.9215p pd=95.32999u as=35.511p ps=48.245u w=46.725u l=1u
X4605 DVDD GATE BAT DVDD pfet_06v0 ad=58.1134p pd=77.985u as=58.1134p ps=77.985u w=76.465u l=1u
X4606 BAT GATE DVDD DVDD pfet_06v0 ad=35.511p pd=48.245u as=43.9215p ps=95.32999u w=46.725u l=1u
X4607 BAT GATE DVDD DVDD pfet_06v0 ad=58.0754p pd=77.935u as=71.8301p ps=0.15471m w=76.41499u l=1u
X4608 DVDD GATE BAT DVDD pfet_06v0 ad=35.511p pd=48.245u as=35.511p ps=48.245u w=46.725u l=1u
X4609 DVDD GATE BAT DVDD pfet_06v0 ad=58.1134p pd=77.985u as=58.1134p ps=77.985u w=76.465u l=1u
X4610 DVDD GATE BAT DVDD pfet_06v0 ad=71.8818p pd=0.15482m as=58.1172p ps=77.99u w=76.47u l=1u
X4611 BAT GATE DVDD DVDD pfet_06v0 ad=35.511p pd=48.245u as=35.511p ps=48.245u w=46.725u l=1u
X4612 DVDD GATE BAT DVDD pfet_06v0 ad=58.1134p pd=77.985u as=58.1134p ps=77.985u w=76.465u l=1u
X4613 DVDD GATE BAT DVDD pfet_06v0 ad=71.8771p pd=0.15481m as=58.1134p ps=77.985u w=76.465u l=1u
X4614 DVDD GATE BAT DVDD pfet_06v0 ad=35.511p pd=48.245u as=35.511p ps=48.245u w=46.725u l=1u
X4615 DVDD GATE BAT DVDD pfet_06v0 ad=58.1134p pd=77.985u as=58.1134p ps=77.985u w=76.465u l=1u
X4616 BAT GATE DVDD DVDD pfet_06v0 ad=58.1134p pd=77.985u as=58.1134p ps=77.985u w=76.465u l=1u
X4617 DVDD GATE BAT DVDD pfet_06v0 ad=35.511p pd=48.245u as=35.511p ps=48.245u w=46.725u l=1u
X4618 DVDD GATE BAT DVDD pfet_06v0 ad=58.1134p pd=77.985u as=58.1134p ps=77.985u w=76.465u l=1u
X4619 DVDD GATE BAT DVDD pfet_06v0 ad=47.6862p pd=64.265u as=47.6862p ps=64.265u w=62.745u l=1u
X4620 DVDD GATE BAT DVDD pfet_06v0 ad=35.511p pd=48.245u as=35.511p ps=48.245u w=46.725u l=1u
X4621 BAT GATE DVDD DVDD pfet_06v0 ad=58.1134p pd=77.985u as=71.8771p ps=0.15481m w=76.465u l=1u
X4622 BAT GATE DVDD DVDD pfet_06v0 ad=35.511p pd=48.245u as=35.511p ps=48.245u w=46.725u l=1u
X4623 DVDD GATE BAT DVDD pfet_06v0 ad=71.8818p pd=0.15482m as=58.1172p ps=77.99u w=76.47u l=1u
X4624 BAT GATE DVDD DVDD pfet_06v0 ad=58.1134p pd=77.985u as=58.1134p ps=77.985u w=76.465u l=1u
X4625 BAT GATE DVDD DVDD pfet_06v0 ad=58.1172p pd=77.99u as=58.1172p ps=77.99u w=76.47u l=1u
X4626 DVDD GATE BAT DVDD pfet_06v0 ad=35.511p pd=48.245u as=35.511p ps=48.245u w=46.725u l=1u
X4627 DVDD GATE BAT DVDD pfet_06v0 ad=43.9215p pd=95.32999u as=35.511p ps=48.245u w=46.725u l=1u
X4628 DVDD GATE BAT DVDD pfet_06v0 ad=49.3848p pd=66.5u as=49.3848p ps=66.5u w=64.98u l=1u
X4629 BAT GATE DVDD DVDD pfet_06v0 ad=58.1134p pd=77.985u as=58.1134p ps=77.985u w=76.465u l=1u
X4630 DVDD GATE BAT DVDD pfet_06v0 ad=35.511p pd=48.245u as=35.511p ps=48.245u w=46.725u l=1u
X4631 DVDD GATE BAT DVDD pfet_06v0 ad=61.0812p pd=0.13184m as=49.3848p ps=66.5u w=64.98u l=1u
X4632 DVDD GATE BAT DVDD pfet_06v0 ad=58.0754p pd=77.935u as=58.0754p ps=77.935u w=76.41499u l=1u
X4633 DVDD GATE BAT DVDD pfet_06v0 ad=71.8771p pd=0.15481m as=58.1134p ps=77.985u w=76.465u l=1u
X4634 BAT GATE DVDD DVDD pfet_06v0 ad=58.1134p pd=77.985u as=58.1134p ps=77.985u w=76.465u l=1u
X4635 DVDD GATE BAT DVDD pfet_06v0 ad=49.3848p pd=66.5u as=49.3848p ps=66.5u w=64.98u l=1u
X4636 BAT GATE DVDD DVDD pfet_06v0 ad=35.511p pd=48.245u as=43.9215p ps=95.32999u w=46.725u l=1u
X4637 BAT GATE DVDD DVDD pfet_06v0 ad=58.1552p pd=78.04u as=71.92879p ps=0.15492m w=76.52u l=1u
X4638 BAT GATE DVDD DVDD pfet_06v0 ad=58.1134p pd=77.985u as=58.1134p ps=77.985u w=76.465u l=1u
X4639 BAT GATE DVDD DVDD pfet_06v0 ad=35.511p pd=48.245u as=43.9215p ps=95.32999u w=46.725u l=1u
X4640 DVDD GATE BAT DVDD pfet_06v0 ad=71.8301p pd=0.15471m as=58.0754p ps=77.935u w=76.41499u l=1u
X4641 BAT GATE DVDD DVDD pfet_06v0 ad=58.1134p pd=77.985u as=71.8771p ps=0.15481m w=76.465u l=1u
X4642 BAT GATE DVDD DVDD pfet_06v0 ad=58.1552p pd=78.04u as=58.1552p ps=78.04u w=76.52u l=1u
X4643 DVDD GATE BAT DVDD pfet_06v0 ad=43.9168p pd=95.32u as=35.5072p ps=48.24u w=46.72u l=1u
X4644 BAT GATE DVDD DVDD pfet_06v0 ad=35.511p pd=48.245u as=35.511p ps=48.245u w=46.725u l=1u
X4645 DVDD GATE BAT DVDD pfet_06v0 ad=35.511p pd=48.245u as=35.511p ps=48.245u w=46.725u l=1u
X4646 DVDD GATE BAT DVDD pfet_06v0 ad=35.511p pd=48.245u as=35.511p ps=48.245u w=46.725u l=1u
X4647 BAT GATE DVDD DVDD pfet_06v0 ad=58.1134p pd=77.985u as=58.1134p ps=77.985u w=76.465u l=1u
X4648 BAT GATE DVDD DVDD pfet_06v0 ad=35.511p pd=48.245u as=43.9215p ps=95.32999u w=46.725u l=1u
X4649 BAT GATE DVDD DVDD pfet_06v0 ad=58.1134p pd=77.985u as=58.1134p ps=77.985u w=76.465u l=1u
X4650 DVDD GATE BAT DVDD pfet_06v0 ad=58.1134p pd=77.985u as=58.1134p ps=77.985u w=76.465u l=1u
X4651 BAT GATE DVDD DVDD pfet_06v0 ad=58.1096p pd=77.98u as=58.1096p ps=77.98u w=76.46u l=1u
X4652 BAT GATE DVDD DVDD pfet_06v0 ad=58.1134p pd=77.985u as=71.8771p ps=0.15481m w=76.465u l=1u
X4653 DVDD GATE BAT DVDD pfet_06v0 ad=58.1134p pd=77.985u as=58.1134p ps=77.985u w=76.465u l=1u
X4654 DVDD GATE BAT DVDD pfet_06v0 ad=58.1134p pd=77.985u as=58.1134p ps=77.985u w=76.465u l=1u
X4655 DVDD GATE BAT DVDD pfet_06v0 ad=35.511p pd=48.245u as=35.511p ps=48.245u w=46.725u l=1u
X4656 BAT GATE DVDD DVDD pfet_06v0 ad=47.6862p pd=64.265u as=58.9803p ps=0.12737m w=62.745u l=1u
X4657 DVDD GATE BAT DVDD pfet_06v0 ad=58.9803p pd=0.12737m as=47.6862p ps=64.265u w=62.745u l=1u
X4658 BAT GATE DVDD DVDD pfet_06v0 ad=58.1172p pd=77.99u as=58.1172p ps=77.99u w=76.47u l=1u
X4659 DVDD GATE BAT DVDD pfet_06v0 ad=43.9215p pd=95.32999u as=35.511p ps=48.245u w=46.725u l=1u
X4660 BAT GATE DVDD DVDD pfet_06v0 ad=35.511p pd=48.245u as=43.9215p ps=95.32999u w=46.725u l=1u
X4661 BAT GATE DVDD DVDD pfet_06v0 ad=35.511p pd=48.245u as=35.511p ps=48.245u w=46.725u l=1u
X4662 DVDD GATE BAT DVDD pfet_06v0 ad=58.1552p pd=78.04u as=58.1552p ps=78.04u w=76.52u l=1u
X4663 DVDD GATE BAT DVDD pfet_06v0 ad=35.511p pd=48.245u as=35.511p ps=48.245u w=46.725u l=1u
X4664 BAT GATE DVDD DVDD pfet_06v0 ad=35.511p pd=48.245u as=35.511p ps=48.245u w=46.725u l=1u
X4665 DVDD GATE BAT DVDD pfet_06v0 ad=43.9215p pd=95.32999u as=35.511p ps=48.245u w=46.725u l=1u
X4666 DVDD GATE BAT DVDD pfet_06v0 ad=58.1096p pd=77.98u as=58.1096p ps=77.98u w=76.46u l=1u
X4667 BAT GATE DVDD DVDD pfet_06v0 ad=58.1134p pd=77.985u as=71.8771p ps=0.15481m w=76.465u l=1u
X4668 DVDD GATE BAT DVDD pfet_06v0 ad=35.511p pd=48.245u as=35.511p ps=48.245u w=46.725u l=1u
X4669 BAT GATE DVDD DVDD pfet_06v0 ad=58.1134p pd=77.985u as=58.1134p ps=77.985u w=76.465u l=1u
X4670 DVDD GATE BAT DVDD pfet_06v0 ad=35.511p pd=48.245u as=35.511p ps=48.245u w=46.725u l=1u
X4671 BAT GATE DVDD DVDD pfet_06v0 ad=58.1134p pd=77.985u as=58.1134p ps=77.985u w=76.465u l=1u
X4672 DVDD GATE BAT DVDD pfet_06v0 ad=58.0754p pd=77.935u as=58.0754p ps=77.935u w=76.41499u l=1u
X4673 BAT GATE DVDD DVDD pfet_06v0 ad=35.511p pd=48.245u as=35.511p ps=48.245u w=46.725u l=1u
X4674 BAT GATE DVDD DVDD pfet_06v0 ad=35.511p pd=48.245u as=35.511p ps=48.245u w=46.725u l=1u
X4675 BAT GATE DVDD DVDD pfet_06v0 ad=35.511p pd=48.245u as=35.511p ps=48.245u w=46.725u l=1u
X4676 BAT GATE DVDD DVDD pfet_06v0 ad=58.1096p pd=77.98u as=58.1096p ps=77.98u w=76.46u l=1u
X4677 BAT GATE DVDD DVDD pfet_06v0 ad=35.511p pd=48.245u as=35.511p ps=48.245u w=46.725u l=1u
X4678 BAT GATE DVDD DVDD pfet_06v0 ad=35.511p pd=48.245u as=35.511p ps=48.245u w=46.725u l=1u
X4679 DVDD GATE BAT DVDD pfet_06v0 ad=35.511p pd=48.245u as=35.511p ps=48.245u w=46.725u l=1u
X4680 BAT GATE DVDD DVDD pfet_06v0 ad=35.511p pd=48.245u as=43.9215p ps=95.32999u w=46.725u l=1u
X4681 DVDD GATE BAT DVDD pfet_06v0 ad=71.8771p pd=0.15481m as=58.1134p ps=77.985u w=76.465u l=1u
X4682 BAT GATE DVDD DVDD pfet_06v0 ad=58.1134p pd=77.985u as=58.1134p ps=77.985u w=76.465u l=1u
X4683 BAT GATE DVDD DVDD pfet_06v0 ad=58.1134p pd=77.985u as=58.1134p ps=77.985u w=76.465u l=1u
X4684 DVDD GATE BAT DVDD pfet_06v0 ad=43.9215p pd=95.32999u as=35.511p ps=48.245u w=46.725u l=1u
X4685 DVDD GATE BAT DVDD pfet_06v0 ad=58.1134p pd=77.985u as=58.1134p ps=77.985u w=76.465u l=1u
X4686 DVDD GATE BAT DVDD pfet_06v0 ad=35.511p pd=48.245u as=35.511p ps=48.245u w=46.725u l=1u
X4687 BAT GATE DVDD DVDD pfet_06v0 ad=35.511p pd=48.245u as=35.511p ps=48.245u w=46.725u l=1u
X4688 DVDD GATE BAT DVDD pfet_06v0 ad=58.1134p pd=77.985u as=58.1134p ps=77.985u w=76.465u l=1u
X4689 BAT GATE DVDD DVDD pfet_06v0 ad=35.511p pd=48.245u as=35.511p ps=48.245u w=46.725u l=1u
X4690 BAT GATE DVDD DVDD pfet_06v0 ad=49.3848p pd=66.5u as=61.0812p ps=0.13184m w=64.98u l=1u
X4691 DVDD GATE BAT DVDD pfet_06v0 ad=58.1172p pd=77.99u as=58.1172p ps=77.99u w=76.47u l=1u
X4692 DVDD GATE BAT DVDD pfet_06v0 ad=35.511p pd=48.245u as=35.511p ps=48.245u w=46.725u l=1u
X4693 BAT GATE DVDD DVDD pfet_06v0 ad=58.1096p pd=77.98u as=58.1096p ps=77.98u w=76.46u l=1u
X4694 DVDD GATE BAT DVDD pfet_06v0 ad=47.6862p pd=64.265u as=47.6862p ps=64.265u w=62.745u l=1u
X4695 DVDD GATE BAT DVDD pfet_06v0 ad=35.511p pd=48.245u as=35.511p ps=48.245u w=46.725u l=1u
X4696 BAT GATE DVDD DVDD pfet_06v0 ad=58.0754p pd=77.935u as=71.8301p ps=0.15471m w=76.41499u l=1u
X4697 DVDD GATE BAT DVDD pfet_06v0 ad=58.1172p pd=77.99u as=58.1172p ps=77.99u w=76.47u l=1u
X4698 BAT GATE DVDD DVDD pfet_06v0 ad=35.511p pd=48.245u as=35.511p ps=48.245u w=46.725u l=1u
X4699 DVDD GATE BAT DVDD pfet_06v0 ad=71.8771p pd=0.15481m as=58.1134p ps=77.985u w=76.465u l=1u
X4700 DVDD GATE BAT DVDD pfet_06v0 ad=58.1096p pd=77.98u as=58.1096p ps=77.98u w=76.46u l=1u
X4701 DVDD GATE BAT DVDD pfet_06v0 ad=58.1552p pd=78.04u as=58.1552p ps=78.04u w=76.52u l=1u
X4702 DVDD GATE BAT DVDD pfet_06v0 ad=43.9168p pd=95.32u as=35.5072p ps=48.24u w=46.72u l=1u
X4703 BAT GATE DVDD DVDD pfet_06v0 ad=58.1134p pd=77.985u as=58.1134p ps=77.985u w=76.465u l=1u
X4704 DVDD GATE BAT DVDD pfet_06v0 ad=35.511p pd=48.245u as=35.511p ps=48.245u w=46.725u l=1u
X4705 BAT GATE DVDD DVDD pfet_06v0 ad=35.511p pd=48.245u as=35.511p ps=48.245u w=46.725u l=1u
X4706 DVDD GATE BAT DVDD pfet_06v0 ad=58.1134p pd=77.985u as=58.1134p ps=77.985u w=76.465u l=1u
X4707 BAT GATE DVDD DVDD pfet_06v0 ad=35.5072p pd=48.24u as=35.5072p ps=48.24u w=46.72u l=1u
X4708 DVDD GATE BAT DVDD pfet_06v0 ad=35.511p pd=48.245u as=35.511p ps=48.245u w=46.725u l=1u
X4709 DVDD GATE BAT DVDD pfet_06v0 ad=35.511p pd=48.245u as=35.511p ps=48.245u w=46.725u l=1u
X4710 BAT GATE DVDD DVDD pfet_06v0 ad=58.1134p pd=77.985u as=71.8771p ps=0.15481m w=76.465u l=1u
X4711 BAT GATE DVDD DVDD pfet_06v0 ad=58.1552p pd=78.04u as=58.1552p ps=78.04u w=76.52u l=1u
X4712 BAT GATE DVDD DVDD pfet_06v0 ad=58.1172p pd=77.99u as=58.1172p ps=77.99u w=76.47u l=1u
X4713 DVDD GATE BAT DVDD pfet_06v0 ad=35.511p pd=48.245u as=35.511p ps=48.245u w=46.725u l=1u
X4714 DVDD GATE BAT DVDD pfet_06v0 ad=35.511p pd=48.245u as=35.511p ps=48.245u w=46.725u l=1u
X4715 DVDD GATE BAT DVDD pfet_06v0 ad=58.1134p pd=77.985u as=58.1134p ps=77.985u w=76.465u l=1u
X4716 DVDD GATE BAT DVDD pfet_06v0 ad=47.6862p pd=64.265u as=47.6862p ps=64.265u w=62.745u l=1u
X4717 DVDD GATE BAT DVDD pfet_06v0 ad=58.1134p pd=77.985u as=58.1134p ps=77.985u w=76.465u l=1u
X4718 BAT GATE DVDD DVDD pfet_06v0 ad=58.1134p pd=77.985u as=58.1134p ps=77.985u w=76.465u l=1u
X4719 DVDD GATE BAT DVDD pfet_06v0 ad=35.511p pd=48.245u as=35.511p ps=48.245u w=46.725u l=1u
X4720 BAT GATE DVDD DVDD pfet_06v0 ad=58.1134p pd=77.985u as=58.1134p ps=77.985u w=76.465u l=1u
X4721 BAT GATE DVDD DVDD pfet_06v0 ad=35.511p pd=48.245u as=35.511p ps=48.245u w=46.725u l=1u
X4722 BAT GATE DVDD DVDD pfet_06v0 ad=58.1134p pd=77.985u as=58.1134p ps=77.985u w=76.465u l=1u
X4723 DVDD GATE BAT DVDD pfet_06v0 ad=35.511p pd=48.245u as=35.511p ps=48.245u w=46.725u l=1u
X4724 BAT GATE DVDD DVDD pfet_06v0 ad=35.511p pd=48.245u as=35.511p ps=48.245u w=46.725u l=1u
X4725 BAT GATE DVDD DVDD pfet_06v0 ad=58.1134p pd=77.985u as=58.1134p ps=77.985u w=76.465u l=1u
X4726 DVDD GATE BAT DVDD pfet_06v0 ad=58.1134p pd=77.985u as=58.1134p ps=77.985u w=76.465u l=1u
X4727 BAT GATE DVDD DVDD pfet_06v0 ad=35.511p pd=48.245u as=43.9215p ps=95.32999u w=46.725u l=1u
X4728 DVDD GATE BAT DVDD pfet_06v0 ad=35.5072p pd=48.24u as=35.5072p ps=48.24u w=46.72u l=1u
X4729 DVDD GATE BAT DVDD pfet_06v0 ad=71.8818p pd=0.15482m as=58.1172p ps=77.99u w=76.47u l=1u
X4730 DVDD GATE BAT DVDD pfet_06v0 ad=35.511p pd=48.245u as=35.511p ps=48.245u w=46.725u l=1u
X4731 BAT GATE DVDD DVDD pfet_06v0 ad=58.1172p pd=77.99u as=58.1172p ps=77.99u w=76.47u l=1u
X4732 BAT GATE DVDD DVDD pfet_06v0 ad=35.511p pd=48.245u as=43.9215p ps=95.32999u w=46.725u l=1u
X4733 DVDD GATE BAT DVDD pfet_06v0 ad=47.6862p pd=64.265u as=47.6862p ps=64.265u w=62.745u l=1u
X4734 BAT GATE DVDD DVDD pfet_06v0 ad=35.511p pd=48.245u as=35.511p ps=48.245u w=46.725u l=1u
X4735 BAT GATE DVDD DVDD pfet_06v0 ad=58.1134p pd=77.985u as=58.1134p ps=77.985u w=76.465u l=1u
X4736 BAT GATE DVDD DVDD pfet_06v0 ad=35.511p pd=48.245u as=35.511p ps=48.245u w=46.725u l=1u
X4737 DVDD GATE BAT DVDD pfet_06v0 ad=43.9215p pd=95.32999u as=35.511p ps=48.245u w=46.725u l=1u
X4738 DVDD GATE BAT DVDD pfet_06v0 ad=58.1134p pd=77.985u as=58.1134p ps=77.985u w=76.465u l=1u
X4739 DVDD GATE BAT DVDD pfet_06v0 ad=71.8771p pd=0.15481m as=58.1134p ps=77.985u w=76.465u l=1u
X4740 BAT GATE DVDD DVDD pfet_06v0 ad=58.1552p pd=78.04u as=58.1552p ps=78.04u w=76.52u l=1u
X4741 DVDD GATE BAT DVDD pfet_06v0 ad=58.1134p pd=77.985u as=58.1134p ps=77.985u w=76.465u l=1u
X4742 BAT GATE DVDD DVDD pfet_06v0 ad=35.511p pd=48.245u as=35.511p ps=48.245u w=46.725u l=1u
X4743 BAT GATE DVDD DVDD pfet_06v0 ad=35.511p pd=48.245u as=35.511p ps=48.245u w=46.725u l=1u
X4744 BAT GATE DVDD DVDD pfet_06v0 ad=58.0754p pd=77.935u as=58.0754p ps=77.935u w=76.41499u l=1u
X4745 DVDD GATE BAT DVDD pfet_06v0 ad=58.1134p pd=77.985u as=58.1134p ps=77.985u w=76.465u l=1u
X4746 BAT GATE DVDD DVDD pfet_06v0 ad=58.1134p pd=77.985u as=71.8771p ps=0.15481m w=76.465u l=1u
X4747 DVDD GATE BAT DVDD pfet_06v0 ad=47.6862p pd=64.265u as=47.6862p ps=64.265u w=62.745u l=1u
X4748 DVDD GATE BAT DVDD pfet_06v0 ad=43.9215p pd=95.32999u as=35.511p ps=48.245u w=46.725u l=1u
X4749 DVDD GATE BAT DVDD pfet_06v0 ad=35.511p pd=48.245u as=35.511p ps=48.245u w=46.725u l=1u
X4750 DVDD GATE BAT DVDD pfet_06v0 ad=43.9215p pd=95.32999u as=35.511p ps=48.245u w=46.725u l=1u
X4751 DVDD GATE BAT DVDD pfet_06v0 ad=35.511p pd=48.245u as=35.511p ps=48.245u w=46.725u l=1u
X4752 BAT GATE DVDD DVDD pfet_06v0 ad=35.511p pd=48.245u as=35.511p ps=48.245u w=46.725u l=1u
X4753 DVDD GATE BAT DVDD pfet_06v0 ad=58.1134p pd=77.985u as=58.1134p ps=77.985u w=76.465u l=1u
X4754 DVDD GATE BAT DVDD pfet_06v0 ad=35.511p pd=48.245u as=35.511p ps=48.245u w=46.725u l=1u
X4755 DVDD GATE BAT DVDD pfet_06v0 ad=58.1134p pd=77.985u as=58.1134p ps=77.985u w=76.465u l=1u
X4756 BAT GATE DVDD DVDD pfet_06v0 ad=58.1134p pd=77.985u as=71.8771p ps=0.15481m w=76.465u l=1u
X4757 DVDD GATE BAT DVDD pfet_06v0 ad=58.0754p pd=77.935u as=58.0754p ps=77.935u w=76.41499u l=1u
X4758 DVDD GATE BAT DVDD pfet_06v0 ad=49.3848p pd=66.5u as=49.3848p ps=66.5u w=64.98u l=1u
X4759 BAT GATE DVDD DVDD pfet_06v0 ad=58.1134p pd=77.985u as=71.8771p ps=0.15481m w=76.465u l=1u
X4760 BAT GATE DVDD DVDD pfet_06v0 ad=58.1134p pd=77.985u as=58.1134p ps=77.985u w=76.465u l=1u
X4761 DVDD GATE BAT DVDD pfet_06v0 ad=58.1134p pd=77.985u as=58.1134p ps=77.985u w=76.465u l=1u
X4762 DVDD GATE BAT DVDD pfet_06v0 ad=58.1172p pd=77.99u as=58.1172p ps=77.99u w=76.47u l=1u
X4763 BAT GATE DVDD DVDD pfet_06v0 ad=35.511p pd=48.245u as=35.511p ps=48.245u w=46.725u l=1u
X4764 BAT GATE DVDD DVDD pfet_06v0 ad=35.511p pd=48.245u as=35.511p ps=48.245u w=46.725u l=1u
X4765 DVDD GATE BAT DVDD pfet_06v0 ad=35.511p pd=48.245u as=35.511p ps=48.245u w=46.725u l=1u
X4766 BAT GATE DVDD DVDD pfet_06v0 ad=58.1134p pd=77.985u as=58.1134p ps=77.985u w=76.465u l=1u
X4767 BAT GATE DVDD DVDD pfet_06v0 ad=58.1096p pd=77.98u as=58.1096p ps=77.98u w=76.46u l=1u
X4768 DVDD GATE BAT DVDD pfet_06v0 ad=35.511p pd=48.245u as=35.511p ps=48.245u w=46.725u l=1u
X4769 DVDD GATE BAT DVDD pfet_06v0 ad=47.6862p pd=64.265u as=47.6862p ps=64.265u w=62.745u l=1u
X4770 BAT GATE DVDD DVDD pfet_06v0 ad=35.511p pd=48.245u as=35.511p ps=48.245u w=46.725u l=1u
X4771 DVDD GATE BAT DVDD pfet_06v0 ad=58.1134p pd=77.985u as=58.1134p ps=77.985u w=76.465u l=1u
X4772 BAT GATE DVDD DVDD pfet_06v0 ad=58.1134p pd=77.985u as=58.1134p ps=77.985u w=76.465u l=1u
X4773 BAT GATE DVDD DVDD pfet_06v0 ad=35.511p pd=48.245u as=35.511p ps=48.245u w=46.725u l=1u
X4774 DVDD GATE BAT DVDD pfet_06v0 ad=58.1134p pd=77.985u as=58.1134p ps=77.985u w=76.465u l=1u
X4775 DVDD GATE BAT DVDD pfet_06v0 ad=58.1096p pd=77.98u as=58.1096p ps=77.98u w=76.46u l=1u
X4776 DVDD GATE BAT DVDD pfet_06v0 ad=35.511p pd=48.245u as=35.511p ps=48.245u w=46.725u l=1u
X4777 BAT GATE DVDD DVDD pfet_06v0 ad=35.5072p pd=48.24u as=35.5072p ps=48.24u w=46.72u l=1u
X4778 BAT GATE DVDD DVDD pfet_06v0 ad=58.1172p pd=77.99u as=71.8818p ps=0.15482m w=76.47u l=1u
X4779 BAT GATE DVDD DVDD pfet_06v0 ad=58.1172p pd=77.99u as=58.1172p ps=77.99u w=76.47u l=1u
X4780 BAT GATE DVDD DVDD pfet_06v0 ad=58.1134p pd=77.985u as=58.1134p ps=77.985u w=76.465u l=1u
X4781 BAT GATE DVDD DVDD pfet_06v0 ad=35.511p pd=48.245u as=35.511p ps=48.245u w=46.725u l=1u
X4782 DVDD GATE BAT DVDD pfet_06v0 ad=35.511p pd=48.245u as=35.511p ps=48.245u w=46.725u l=1u
X4783 BAT GATE DVDD DVDD pfet_06v0 ad=35.511p pd=48.245u as=43.9215p ps=95.32999u w=46.725u l=1u
X4784 BAT GATE DVDD DVDD pfet_06v0 ad=35.5072p pd=48.24u as=35.5072p ps=48.24u w=46.72u l=1u
X4785 BAT GATE DVDD DVDD pfet_06v0 ad=58.1134p pd=77.985u as=58.1134p ps=77.985u w=76.465u l=1u
X4786 DVDD GATE BAT DVDD pfet_06v0 ad=35.511p pd=48.245u as=35.511p ps=48.245u w=46.725u l=1u
X4787 DVDD GATE BAT DVDD pfet_06v0 ad=43.9215p pd=95.32999u as=35.511p ps=48.245u w=46.725u l=1u
X4788 DVDD GATE BAT DVDD pfet_06v0 ad=35.511p pd=48.245u as=35.511p ps=48.245u w=46.725u l=1u
X4789 DVDD GATE BAT DVDD pfet_06v0 ad=35.511p pd=48.245u as=35.511p ps=48.245u w=46.725u l=1u
X4790 BAT GATE DVDD DVDD pfet_06v0 ad=35.511p pd=48.245u as=35.511p ps=48.245u w=46.725u l=1u
X4791 BAT GATE DVDD DVDD pfet_06v0 ad=58.1134p pd=77.985u as=71.8771p ps=0.15481m w=76.465u l=1u
X4792 DVDD GATE BAT DVDD pfet_06v0 ad=35.511p pd=48.245u as=35.511p ps=48.245u w=46.725u l=1u
X4793 BAT GATE DVDD DVDD pfet_06v0 ad=58.1172p pd=77.99u as=58.1172p ps=77.99u w=76.47u l=1u
X4794 DVDD GATE BAT DVDD pfet_06v0 ad=58.1134p pd=77.985u as=58.1134p ps=77.985u w=76.465u l=1u
X4795 DVDD GATE BAT DVDD pfet_06v0 ad=43.9168p pd=95.32u as=35.5072p ps=48.24u w=46.72u l=1u
X4796 DVDD GATE BAT DVDD pfet_06v0 ad=71.8771p pd=0.15481m as=58.1134p ps=77.985u w=76.465u l=1u
X4797 DVDD GATE BAT DVDD pfet_06v0 ad=35.511p pd=48.245u as=35.511p ps=48.245u w=46.725u l=1u
X4798 BAT GATE DVDD DVDD pfet_06v0 ad=35.511p pd=48.245u as=35.511p ps=48.245u w=46.725u l=1u
X4799 DVDD GATE BAT DVDD pfet_06v0 ad=35.5072p pd=48.24u as=35.5072p ps=48.24u w=46.72u l=1u
X4800 BAT GATE DVDD DVDD pfet_06v0 ad=58.1134p pd=77.985u as=58.1134p ps=77.985u w=76.465u l=1u
X4801 BAT GATE DVDD DVDD pfet_06v0 ad=58.1134p pd=77.985u as=58.1134p ps=77.985u w=76.465u l=1u
X4802 BAT GATE DVDD DVDD pfet_06v0 ad=47.6862p pd=64.265u as=58.9803p ps=0.12737m w=62.745u l=1u
X4803 DVDD GATE BAT DVDD pfet_06v0 ad=35.5072p pd=48.24u as=35.5072p ps=48.24u w=46.72u l=1u
X4804 BAT GATE DVDD DVDD pfet_06v0 ad=35.511p pd=48.245u as=35.511p ps=48.245u w=46.725u l=1u
X4805 DVDD GATE BAT DVDD pfet_06v0 ad=43.9215p pd=95.32999u as=35.511p ps=48.245u w=46.725u l=1u
X4806 BAT GATE DVDD DVDD pfet_06v0 ad=47.6862p pd=64.265u as=47.6862p ps=64.265u w=62.745u l=1u
X4807 BAT GATE DVDD DVDD pfet_06v0 ad=35.511p pd=48.245u as=35.511p ps=48.245u w=46.725u l=1u
X4808 BAT GATE DVDD DVDD pfet_06v0 ad=58.1552p pd=78.04u as=58.1552p ps=78.04u w=76.52u l=1u
X4809 BAT GATE DVDD DVDD pfet_06v0 ad=35.511p pd=48.245u as=35.511p ps=48.245u w=46.725u l=1u
X4810 DVDD GATE BAT DVDD pfet_06v0 ad=58.1134p pd=77.985u as=58.1134p ps=77.985u w=76.465u l=1u
X4811 BAT GATE DVDD DVDD pfet_06v0 ad=58.1134p pd=77.985u as=58.1134p ps=77.985u w=76.465u l=1u
X4812 BAT GATE DVDD DVDD pfet_06v0 ad=58.1134p pd=77.985u as=58.1134p ps=77.985u w=76.465u l=1u
X4813 BAT GATE DVDD DVDD pfet_06v0 ad=35.511p pd=48.245u as=35.511p ps=48.245u w=46.725u l=1u
X4814 BAT GATE DVDD DVDD pfet_06v0 ad=35.511p pd=48.245u as=43.9215p ps=95.32999u w=46.725u l=1u
X4815 DVDD GATE BAT DVDD pfet_06v0 ad=35.511p pd=48.245u as=35.511p ps=48.245u w=46.725u l=1u
X4816 BAT GATE DVDD DVDD pfet_06v0 ad=35.511p pd=48.245u as=35.511p ps=48.245u w=46.725u l=1u
X4817 DVDD GATE BAT DVDD pfet_06v0 ad=35.511p pd=48.245u as=35.511p ps=48.245u w=46.725u l=1u
X4818 DVDD GATE BAT DVDD pfet_06v0 ad=58.1134p pd=77.985u as=58.1134p ps=77.985u w=76.465u l=1u
X4819 BAT GATE DVDD DVDD pfet_06v0 ad=35.511p pd=48.245u as=35.511p ps=48.245u w=46.725u l=1u
X4820 DVDD GATE BAT DVDD pfet_06v0 ad=58.1134p pd=77.985u as=58.1134p ps=77.985u w=76.465u l=1u
X4821 BAT GATE DVDD DVDD pfet_06v0 ad=35.5072p pd=48.24u as=43.9168p ps=95.32u w=46.72u l=1u
X4822 BAT GATE DVDD DVDD pfet_06v0 ad=58.1172p pd=77.99u as=58.1172p ps=77.99u w=76.47u l=1u
X4823 BAT GATE DVDD DVDD pfet_06v0 ad=58.1134p pd=77.985u as=71.8771p ps=0.15481m w=76.465u l=1u
X4824 BAT GATE DVDD DVDD pfet_06v0 ad=47.6862p pd=64.265u as=47.6862p ps=64.265u w=62.745u l=1u
X4825 BAT GATE DVDD DVDD pfet_06v0 ad=58.1134p pd=77.985u as=58.1134p ps=77.985u w=76.465u l=1u
X4826 DVDD GATE BAT DVDD pfet_06v0 ad=58.1134p pd=77.985u as=58.1134p ps=77.985u w=76.465u l=1u
X4827 BAT GATE DVDD DVDD pfet_06v0 ad=35.511p pd=48.245u as=35.511p ps=48.245u w=46.725u l=1u
X4828 DVDD GATE BAT DVDD pfet_06v0 ad=71.8771p pd=0.15481m as=58.1134p ps=77.985u w=76.465u l=1u
X4829 DVDD GATE BAT DVDD pfet_06v0 ad=58.0754p pd=77.935u as=58.0754p ps=77.935u w=76.41499u l=1u
X4830 BAT GATE DVDD DVDD pfet_06v0 ad=35.511p pd=48.245u as=35.511p ps=48.245u w=46.725u l=1u
X4831 DVDD GATE BAT DVDD pfet_06v0 ad=35.511p pd=48.245u as=35.511p ps=48.245u w=46.725u l=1u
X4832 BAT GATE DVDD DVDD pfet_06v0 ad=58.1134p pd=77.985u as=58.1134p ps=77.985u w=76.465u l=1u
X4833 DVDD GATE BAT DVDD pfet_06v0 ad=35.511p pd=48.245u as=35.511p ps=48.245u w=46.725u l=1u
X4834 BAT GATE DVDD DVDD pfet_06v0 ad=58.1134p pd=77.985u as=58.1134p ps=77.985u w=76.465u l=1u
X4835 BAT GATE DVDD DVDD pfet_06v0 ad=35.511p pd=48.245u as=35.511p ps=48.245u w=46.725u l=1u
X4836 DVDD GATE BAT DVDD pfet_06v0 ad=71.8724p pd=0.1548m as=58.1096p ps=77.98u w=76.46u l=1u
X4837 BAT GATE DVDD DVDD pfet_06v0 ad=58.1134p pd=77.985u as=58.1134p ps=77.985u w=76.465u l=1u
X4838 DVDD GATE BAT DVDD pfet_06v0 ad=49.3848p pd=66.5u as=49.3848p ps=66.5u w=64.98u l=1u
X4839 BAT GATE DVDD DVDD pfet_06v0 ad=58.1134p pd=77.985u as=58.1134p ps=77.985u w=76.465u l=1u
X4840 BAT GATE DVDD DVDD pfet_06v0 ad=58.1134p pd=77.985u as=58.1134p ps=77.985u w=76.465u l=1u
X4841 BAT GATE DVDD DVDD pfet_06v0 ad=35.511p pd=48.245u as=43.9215p ps=95.32999u w=46.725u l=1u
X4842 BAT GATE DVDD DVDD pfet_06v0 ad=35.511p pd=48.245u as=35.511p ps=48.245u w=46.725u l=1u
X4843 DVDD GATE BAT DVDD pfet_06v0 ad=71.8724p pd=0.1548m as=58.1096p ps=77.98u w=76.46u l=1u
X4844 DVDD GATE BAT DVDD pfet_06v0 ad=35.5072p pd=48.24u as=35.5072p ps=48.24u w=46.72u l=1u
X4845 DVDD GATE BAT DVDD pfet_06v0 ad=35.511p pd=48.245u as=35.511p ps=48.245u w=46.725u l=1u
X4846 BAT GATE DVDD DVDD pfet_06v0 ad=58.1134p pd=77.985u as=58.1134p ps=77.985u w=76.465u l=1u
X4847 BAT GATE DVDD DVDD pfet_06v0 ad=47.6862p pd=64.265u as=47.6862p ps=64.265u w=62.745u l=1u
X4848 DVDD GATE BAT DVDD pfet_06v0 ad=43.9215p pd=95.32999u as=35.511p ps=48.245u w=46.725u l=1u
X4849 DVDD GATE BAT DVDD pfet_06v0 ad=43.9215p pd=95.32999u as=35.511p ps=48.245u w=46.725u l=1u
X4850 BAT GATE DVDD DVDD pfet_06v0 ad=35.511p pd=48.245u as=35.511p ps=48.245u w=46.725u l=1u
X4851 DVDD GATE BAT DVDD pfet_06v0 ad=43.9168p pd=95.32u as=35.5072p ps=48.24u w=46.72u l=1u
X4852 BAT GATE DVDD DVDD pfet_06v0 ad=35.511p pd=48.245u as=35.511p ps=48.245u w=46.725u l=1u
X4853 BAT GATE DVDD DVDD pfet_06v0 ad=35.511p pd=48.245u as=35.511p ps=48.245u w=46.725u l=1u
X4854 DVDD GATE BAT DVDD pfet_06v0 ad=71.8818p pd=0.15482m as=58.1172p ps=77.99u w=76.47u l=1u
X4855 DVDD GATE BAT DVDD pfet_06v0 ad=35.511p pd=48.245u as=35.511p ps=48.245u w=46.725u l=1u
X4856 BAT GATE DVDD DVDD pfet_06v0 ad=35.511p pd=48.245u as=35.511p ps=48.245u w=46.725u l=1u
X4857 BAT GATE DVDD DVDD pfet_06v0 ad=49.3848p pd=66.5u as=49.3848p ps=66.5u w=64.98u l=1u
X4858 BAT GATE DVDD DVDD pfet_06v0 ad=35.511p pd=48.245u as=43.9215p ps=95.32999u w=46.725u l=1u
X4859 BAT GATE DVDD DVDD pfet_06v0 ad=58.1134p pd=77.985u as=58.1134p ps=77.985u w=76.465u l=1u
X4860 BAT GATE DVDD DVDD pfet_06v0 ad=58.1134p pd=77.985u as=58.1134p ps=77.985u w=76.465u l=1u
X4861 BAT GATE DVDD DVDD pfet_06v0 ad=35.511p pd=48.245u as=35.511p ps=48.245u w=46.725u l=1u
X4862 BAT GATE DVDD DVDD pfet_06v0 ad=49.3848p pd=66.5u as=49.3848p ps=66.5u w=64.98u l=1u
X4863 BAT GATE DVDD DVDD pfet_06v0 ad=58.0754p pd=77.935u as=58.0754p ps=77.935u w=76.41499u l=1u
X4864 BAT GATE DVDD DVDD pfet_06v0 ad=58.1134p pd=77.985u as=71.8771p ps=0.15481m w=76.465u l=1u
X4865 BAT GATE DVDD DVDD pfet_06v0 ad=58.1552p pd=78.04u as=58.1552p ps=78.04u w=76.52u l=1u
X4866 DVDD GATE BAT DVDD pfet_06v0 ad=58.1134p pd=77.985u as=58.1134p ps=77.985u w=76.465u l=1u
X4867 DVDD GATE BAT DVDD pfet_06v0 ad=58.1134p pd=77.985u as=58.1134p ps=77.985u w=76.465u l=1u
X4868 DVDD GATE BAT DVDD pfet_06v0 ad=58.1134p pd=77.985u as=58.1134p ps=77.985u w=76.465u l=1u
X4869 BAT GATE DVDD DVDD pfet_06v0 ad=58.1134p pd=77.985u as=58.1134p ps=77.985u w=76.465u l=1u
X4870 DVDD GATE BAT DVDD pfet_06v0 ad=58.1096p pd=77.98u as=58.1096p ps=77.98u w=76.46u l=1u
X4871 BAT GATE DVDD DVDD pfet_06v0 ad=35.511p pd=48.245u as=35.511p ps=48.245u w=46.725u l=1u
X4872 DVDD GATE BAT DVDD pfet_06v0 ad=58.1134p pd=77.985u as=58.1134p ps=77.985u w=76.465u l=1u
X4873 BAT GATE DVDD DVDD pfet_06v0 ad=58.0754p pd=77.935u as=58.0754p ps=77.935u w=76.41499u l=1u
X4874 DVDD GATE BAT DVDD pfet_06v0 ad=58.1134p pd=77.985u as=58.1134p ps=77.985u w=76.465u l=1u
X4875 DVDD GATE BAT DVDD pfet_06v0 ad=58.1134p pd=77.985u as=58.1134p ps=77.985u w=76.465u l=1u
X4876 DVDD GATE BAT DVDD pfet_06v0 ad=43.9215p pd=95.32999u as=35.511p ps=48.245u w=46.725u l=1u
X4877 DVDD GATE BAT DVDD pfet_06v0 ad=43.9215p pd=95.32999u as=35.511p ps=48.245u w=46.725u l=1u
X4878 DVDD GATE BAT DVDD pfet_06v0 ad=43.9215p pd=95.32999u as=35.511p ps=48.245u w=46.725u l=1u
X4879 BAT GATE DVDD DVDD pfet_06v0 ad=58.1134p pd=77.985u as=58.1134p ps=77.985u w=76.465u l=1u
X4880 DVDD GATE BAT DVDD pfet_06v0 ad=43.9215p pd=95.32999u as=35.511p ps=48.245u w=46.725u l=1u
X4881 BAT GATE DVDD DVDD pfet_06v0 ad=35.511p pd=48.245u as=35.511p ps=48.245u w=46.725u l=1u
X4882 BAT GATE DVDD DVDD pfet_06v0 ad=35.511p pd=48.245u as=35.511p ps=48.245u w=46.725u l=1u
X4883 BAT GATE DVDD DVDD pfet_06v0 ad=35.511p pd=48.245u as=35.511p ps=48.245u w=46.725u l=1u
X4884 BAT GATE DVDD DVDD pfet_06v0 ad=58.1172p pd=77.99u as=58.1172p ps=77.99u w=76.47u l=1u
X4885 BAT GATE DVDD DVDD pfet_06v0 ad=58.1134p pd=77.985u as=58.1134p ps=77.985u w=76.465u l=1u
X4886 DVDD GATE BAT DVDD pfet_06v0 ad=35.5072p pd=48.24u as=35.5072p ps=48.24u w=46.72u l=1u
X4887 DVDD GATE BAT DVDD pfet_06v0 ad=43.9215p pd=95.32999u as=35.511p ps=48.245u w=46.725u l=1u
X4888 DVDD GATE BAT DVDD pfet_06v0 ad=35.511p pd=48.245u as=35.511p ps=48.245u w=46.725u l=1u
X4889 DVDD GATE BAT DVDD pfet_06v0 ad=35.511p pd=48.245u as=35.511p ps=48.245u w=46.725u l=1u
X4890 DVDD GATE BAT DVDD pfet_06v0 ad=43.9215p pd=95.32999u as=35.511p ps=48.245u w=46.725u l=1u
X4891 BAT GATE DVDD DVDD pfet_06v0 ad=35.511p pd=48.245u as=35.511p ps=48.245u w=46.725u l=1u
X4892 DVDD GATE BAT DVDD pfet_06v0 ad=35.511p pd=48.245u as=35.511p ps=48.245u w=46.725u l=1u
X4893 DVDD GATE BAT DVDD pfet_06v0 ad=43.9215p pd=95.32999u as=35.511p ps=48.245u w=46.725u l=1u
X4894 DVDD GATE BAT DVDD pfet_06v0 ad=71.8724p pd=0.1548m as=58.1096p ps=77.98u w=76.46u l=1u
X4895 BAT GATE DVDD DVDD pfet_06v0 ad=35.511p pd=48.245u as=35.511p ps=48.245u w=46.725u l=1u
X4896 BAT GATE DVDD DVDD pfet_06v0 ad=58.1096p pd=77.98u as=58.1096p ps=77.98u w=76.46u l=1u
X4897 DVDD GATE BAT DVDD pfet_06v0 ad=58.1134p pd=77.985u as=58.1134p ps=77.985u w=76.465u l=1u
X4898 BAT GATE DVDD DVDD pfet_06v0 ad=58.0754p pd=77.935u as=58.0754p ps=77.935u w=76.41499u l=1u
X4899 DVDD GATE BAT DVDD pfet_06v0 ad=58.9803p pd=0.12737m as=47.6862p ps=64.265u w=62.745u l=1u
X4900 BAT GATE DVDD DVDD pfet_06v0 ad=35.511p pd=48.245u as=35.511p ps=48.245u w=46.725u l=1u
X4901 DVDD GATE BAT DVDD pfet_06v0 ad=35.511p pd=48.245u as=35.511p ps=48.245u w=46.725u l=1u
X4902 BAT GATE DVDD DVDD pfet_06v0 ad=58.1134p pd=77.985u as=71.8771p ps=0.15481m w=76.465u l=1u
X4903 DVDD GATE BAT DVDD pfet_06v0 ad=35.511p pd=48.245u as=35.511p ps=48.245u w=46.725u l=1u
X4904 BAT GATE DVDD DVDD pfet_06v0 ad=58.1134p pd=77.985u as=58.1134p ps=77.985u w=76.465u l=1u
X4905 DVDD GATE BAT DVDD pfet_06v0 ad=35.511p pd=48.245u as=35.511p ps=48.245u w=46.725u l=1u
X4906 BAT GATE DVDD DVDD pfet_06v0 ad=35.5072p pd=48.24u as=35.5072p ps=48.24u w=46.72u l=1u
X4907 DVDD GATE BAT DVDD pfet_06v0 ad=58.1134p pd=77.985u as=58.1134p ps=77.985u w=76.465u l=1u
X4908 DVDD GATE BAT DVDD pfet_06v0 ad=58.1096p pd=77.98u as=58.1096p ps=77.98u w=76.46u l=1u
X4909 DVDD GATE BAT DVDD pfet_06v0 ad=35.511p pd=48.245u as=35.511p ps=48.245u w=46.725u l=1u
X4910 DVDD GATE BAT DVDD pfet_06v0 ad=35.511p pd=48.245u as=35.511p ps=48.245u w=46.725u l=1u
X4911 BAT GATE DVDD DVDD pfet_06v0 ad=35.511p pd=48.245u as=35.511p ps=48.245u w=46.725u l=1u
X4912 DVDD GATE BAT DVDD pfet_06v0 ad=58.1134p pd=77.985u as=58.1134p ps=77.985u w=76.465u l=1u
X4913 DVDD GATE BAT DVDD pfet_06v0 ad=58.1134p pd=77.985u as=58.1134p ps=77.985u w=76.465u l=1u
X4914 DVDD GATE BAT DVDD pfet_06v0 ad=35.511p pd=48.245u as=35.511p ps=48.245u w=46.725u l=1u
X4915 DVDD GATE BAT DVDD pfet_06v0 ad=35.511p pd=48.245u as=35.511p ps=48.245u w=46.725u l=1u
X4916 BAT GATE DVDD DVDD pfet_06v0 ad=35.511p pd=48.245u as=35.511p ps=48.245u w=46.725u l=1u
X4917 BAT GATE DVDD DVDD pfet_06v0 ad=58.1134p pd=77.985u as=58.1134p ps=77.985u w=76.465u l=1u
X4918 BAT GATE DVDD DVDD pfet_06v0 ad=49.3848p pd=66.5u as=61.0812p ps=0.13184m w=64.98u l=1u
X4919 BAT GATE DVDD DVDD pfet_06v0 ad=58.1134p pd=77.985u as=58.1134p ps=77.985u w=76.465u l=1u
X4920 BAT GATE DVDD DVDD pfet_06v0 ad=58.1172p pd=77.99u as=58.1172p ps=77.99u w=76.47u l=1u
X4921 BAT GATE DVDD DVDD pfet_06v0 ad=58.1134p pd=77.985u as=58.1134p ps=77.985u w=76.465u l=1u
X4922 DVDD GATE BAT DVDD pfet_06v0 ad=58.1096p pd=77.98u as=58.1096p ps=77.98u w=76.46u l=1u
X4923 BAT GATE DVDD DVDD pfet_06v0 ad=35.511p pd=48.245u as=35.511p ps=48.245u w=46.725u l=1u
X4924 DVDD GATE BAT DVDD pfet_06v0 ad=35.511p pd=48.245u as=35.511p ps=48.245u w=46.725u l=1u
X4925 DVDD GATE BAT DVDD pfet_06v0 ad=35.5072p pd=48.24u as=35.5072p ps=48.24u w=46.72u l=1u
X4926 BAT GATE DVDD DVDD pfet_06v0 ad=58.1134p pd=77.985u as=58.1134p ps=77.985u w=76.465u l=1u
X4927 BAT GATE DVDD DVDD pfet_06v0 ad=35.511p pd=48.245u as=35.511p ps=48.245u w=46.725u l=1u
X4928 BAT GATE DVDD DVDD pfet_06v0 ad=49.3848p pd=66.5u as=49.3848p ps=66.5u w=64.98u l=1u
X4929 BAT GATE DVDD DVDD pfet_06v0 ad=35.511p pd=48.245u as=35.511p ps=48.245u w=46.725u l=1u
X4930 BAT GATE DVDD DVDD pfet_06v0 ad=58.1552p pd=78.04u as=71.92879p ps=0.15492m w=76.52u l=1u
X4931 BAT GATE DVDD DVDD pfet_06v0 ad=58.1134p pd=77.985u as=58.1134p ps=77.985u w=76.465u l=1u
X4932 BAT GATE DVDD DVDD pfet_06v0 ad=58.1134p pd=77.985u as=58.1134p ps=77.985u w=76.465u l=1u
X4933 BAT GATE DVDD DVDD pfet_06v0 ad=35.511p pd=48.245u as=35.511p ps=48.245u w=46.725u l=1u
X4934 DVDD GATE BAT DVDD pfet_06v0 ad=35.511p pd=48.245u as=35.511p ps=48.245u w=46.725u l=1u
X4935 DVDD GATE BAT DVDD pfet_06v0 ad=35.511p pd=48.245u as=35.511p ps=48.245u w=46.725u l=1u
X4936 BAT GATE DVDD DVDD pfet_06v0 ad=58.1134p pd=77.985u as=58.1134p ps=77.985u w=76.465u l=1u
X4937 DVDD GATE BAT DVDD pfet_06v0 ad=43.9215p pd=95.32999u as=35.511p ps=48.245u w=46.725u l=1u
X4938 DVDD GATE BAT DVDD pfet_06v0 ad=61.0812p pd=0.13184m as=49.3848p ps=66.5u w=64.98u l=1u
X4939 DVDD GATE BAT DVDD pfet_06v0 ad=58.1134p pd=77.985u as=58.1134p ps=77.985u w=76.465u l=1u
X4940 DVDD GATE BAT DVDD pfet_06v0 ad=58.1552p pd=78.04u as=58.1552p ps=78.04u w=76.52u l=1u
X4941 BAT GATE DVDD DVDD pfet_06v0 ad=35.5072p pd=48.24u as=35.5072p ps=48.24u w=46.72u l=1u
X4942 DVDD GATE BAT DVDD pfet_06v0 ad=35.511p pd=48.245u as=35.511p ps=48.245u w=46.725u l=1u
X4943 BAT GATE DVDD DVDD pfet_06v0 ad=35.511p pd=48.245u as=35.511p ps=48.245u w=46.725u l=1u
X4944 BAT GATE DVDD DVDD pfet_06v0 ad=47.6862p pd=64.265u as=47.6862p ps=64.265u w=62.745u l=1u
X4945 BAT GATE DVDD DVDD pfet_06v0 ad=58.1134p pd=77.985u as=58.1134p ps=77.985u w=76.465u l=1u
X4946 DVDD GATE BAT DVDD pfet_06v0 ad=58.1134p pd=77.985u as=58.1134p ps=77.985u w=76.465u l=1u
X4947 DVDD GATE BAT DVDD pfet_06v0 ad=58.1134p pd=77.985u as=58.1134p ps=77.985u w=76.465u l=1u
X4948 BAT GATE DVDD DVDD pfet_06v0 ad=35.511p pd=48.245u as=43.9215p ps=95.32999u w=46.725u l=1u
X4949 DVDD GATE BAT DVDD pfet_06v0 ad=58.1134p pd=77.985u as=58.1134p ps=77.985u w=76.465u l=1u
X4950 BAT GATE DVDD DVDD pfet_06v0 ad=58.1096p pd=77.98u as=58.1096p ps=77.98u w=76.46u l=1u
X4951 DVDD GATE BAT DVDD pfet_06v0 ad=58.1134p pd=77.985u as=58.1134p ps=77.985u w=76.465u l=1u
X4952 DVDD GATE BAT DVDD pfet_06v0 ad=35.511p pd=48.245u as=35.511p ps=48.245u w=46.725u l=1u
X4953 DVDD GATE BAT DVDD pfet_06v0 ad=47.6862p pd=64.265u as=47.6862p ps=64.265u w=62.745u l=1u
X4954 DVDD GATE BAT DVDD pfet_06v0 ad=58.1134p pd=77.985u as=58.1134p ps=77.985u w=76.465u l=1u
X4955 BAT GATE DVDD DVDD pfet_06v0 ad=35.511p pd=48.245u as=35.511p ps=48.245u w=46.725u l=1u
X4956 DVDD GATE BAT DVDD pfet_06v0 ad=58.1172p pd=77.99u as=58.1172p ps=77.99u w=76.47u l=1u
X4957 DVDD GATE BAT DVDD pfet_06v0 ad=71.8771p pd=0.15481m as=58.1134p ps=77.985u w=76.465u l=1u
X4958 DVDD GATE BAT DVDD pfet_06v0 ad=71.8771p pd=0.15481m as=58.1134p ps=77.985u w=76.465u l=1u
X4959 BAT GATE DVDD DVDD pfet_06v0 ad=35.511p pd=48.245u as=35.511p ps=48.245u w=46.725u l=1u
X4960 BAT GATE DVDD DVDD pfet_06v0 ad=35.511p pd=48.245u as=43.9215p ps=95.32999u w=46.725u l=1u
X4961 DVDD GATE BAT DVDD pfet_06v0 ad=43.9215p pd=95.32999u as=35.511p ps=48.245u w=46.725u l=1u
X4962 DVDD GATE BAT DVDD pfet_06v0 ad=58.1172p pd=77.99u as=58.1172p ps=77.99u w=76.47u l=1u
X4963 BAT GATE DVDD DVDD pfet_06v0 ad=35.5072p pd=48.24u as=35.5072p ps=48.24u w=46.72u l=1u
X4964 BAT GATE DVDD DVDD pfet_06v0 ad=58.1134p pd=77.985u as=58.1134p ps=77.985u w=76.465u l=1u
X4965 DVDD GATE BAT DVDD pfet_06v0 ad=49.3848p pd=66.5u as=49.3848p ps=66.5u w=64.98u l=1u
X4966 DVDD GATE BAT DVDD pfet_06v0 ad=58.1134p pd=77.985u as=58.1134p ps=77.985u w=76.465u l=1u
X4967 DVDD GATE BAT DVDD pfet_06v0 ad=35.511p pd=48.245u as=35.511p ps=48.245u w=46.725u l=1u
X4968 DVDD GATE BAT DVDD pfet_06v0 ad=49.3848p pd=66.5u as=49.3848p ps=66.5u w=64.98u l=1u
X4969 DVDD GATE BAT DVDD pfet_06v0 ad=58.1134p pd=77.985u as=58.1134p ps=77.985u w=76.465u l=1u
X4970 BAT GATE DVDD DVDD pfet_06v0 ad=58.1134p pd=77.985u as=71.8771p ps=0.15481m w=76.465u l=1u
X4971 BAT GATE DVDD DVDD pfet_06v0 ad=58.1134p pd=77.985u as=58.1134p ps=77.985u w=76.465u l=1u
X4972 BAT GATE DVDD DVDD pfet_06v0 ad=35.511p pd=48.245u as=35.511p ps=48.245u w=46.725u l=1u
X4973 DVDD GATE BAT DVDD pfet_06v0 ad=58.0754p pd=77.935u as=58.0754p ps=77.935u w=76.41499u l=1u
X4974 DVDD GATE BAT DVDD pfet_06v0 ad=35.511p pd=48.245u as=35.511p ps=48.245u w=46.725u l=1u
X4975 DVDD GATE BAT DVDD pfet_06v0 ad=35.5072p pd=48.24u as=35.5072p ps=48.24u w=46.72u l=1u
X4976 BAT GATE DVDD DVDD pfet_06v0 ad=35.511p pd=48.245u as=35.511p ps=48.245u w=46.725u l=1u
X4977 BAT GATE DVDD DVDD pfet_06v0 ad=47.6862p pd=64.265u as=47.6862p ps=64.265u w=62.745u l=1u
X4978 DVDD GATE BAT DVDD pfet_06v0 ad=43.9215p pd=95.32999u as=35.511p ps=48.245u w=46.725u l=1u
X4979 DVDD GATE BAT DVDD pfet_06v0 ad=35.511p pd=48.245u as=35.511p ps=48.245u w=46.725u l=1u
X4980 BAT GATE DVDD DVDD pfet_06v0 ad=58.1134p pd=77.985u as=71.8771p ps=0.15481m w=76.465u l=1u
X4981 DVDD GATE BAT DVDD pfet_06v0 ad=43.9215p pd=95.32999u as=35.511p ps=48.245u w=46.725u l=1u
X4982 DVDD GATE BAT DVDD pfet_06v0 ad=58.1134p pd=77.985u as=58.1134p ps=77.985u w=76.465u l=1u
X4983 BAT GATE DVDD DVDD pfet_06v0 ad=58.1134p pd=77.985u as=58.1134p ps=77.985u w=76.465u l=1u
X4984 DVDD GATE BAT DVDD pfet_06v0 ad=35.511p pd=48.245u as=35.511p ps=48.245u w=46.725u l=1u
X4985 BAT GATE DVDD DVDD pfet_06v0 ad=58.1134p pd=77.985u as=58.1134p ps=77.985u w=76.465u l=1u
X4986 DVDD GATE BAT DVDD pfet_06v0 ad=58.0754p pd=77.935u as=58.0754p ps=77.935u w=76.41499u l=1u
X4987 BAT GATE DVDD DVDD pfet_06v0 ad=58.1096p pd=77.98u as=58.1096p ps=77.98u w=76.46u l=1u
X4988 BAT GATE DVDD DVDD pfet_06v0 ad=35.511p pd=48.245u as=35.511p ps=48.245u w=46.725u l=1u
X4989 BAT GATE DVDD DVDD pfet_06v0 ad=35.511p pd=48.245u as=35.511p ps=48.245u w=46.725u l=1u
X4990 DVDD GATE BAT DVDD pfet_06v0 ad=58.1134p pd=77.985u as=58.1134p ps=77.985u w=76.465u l=1u
X4991 DVDD GATE BAT DVDD pfet_06v0 ad=71.8771p pd=0.15481m as=58.1134p ps=77.985u w=76.465u l=1u
X4992 DVDD GATE BAT DVDD pfet_06v0 ad=58.1134p pd=77.985u as=58.1134p ps=77.985u w=76.465u l=1u
X4993 DVDD GATE BAT DVDD pfet_06v0 ad=71.8771p pd=0.15481m as=58.1134p ps=77.985u w=76.465u l=1u
X4994 DVDD GATE BAT DVDD pfet_06v0 ad=35.511p pd=48.245u as=35.511p ps=48.245u w=46.725u l=1u
X4995 BAT GATE DVDD DVDD pfet_06v0 ad=58.1172p pd=77.99u as=58.1172p ps=77.99u w=76.47u l=1u
X4996 DVDD GATE BAT DVDD pfet_06v0 ad=35.511p pd=48.245u as=35.511p ps=48.245u w=46.725u l=1u
X4997 BAT GATE DVDD DVDD pfet_06v0 ad=58.1134p pd=77.985u as=71.8771p ps=0.15481m w=76.465u l=1u
X4998 BAT GATE DVDD DVDD pfet_06v0 ad=35.511p pd=48.245u as=35.511p ps=48.245u w=46.725u l=1u
X4999 DVDD GATE BAT DVDD pfet_06v0 ad=35.511p pd=48.245u as=35.511p ps=48.245u w=46.725u l=1u
X5000 BAT GATE DVDD DVDD pfet_06v0 ad=35.5072p pd=48.24u as=35.5072p ps=48.24u w=46.72u l=1u
X5001 BAT GATE DVDD DVDD pfet_06v0 ad=35.511p pd=48.245u as=35.511p ps=48.245u w=46.725u l=1u
X5002 DVDD GATE BAT DVDD pfet_06v0 ad=71.8724p pd=0.1548m as=58.1096p ps=77.98u w=76.46u l=1u
X5003 BAT GATE DVDD DVDD pfet_06v0 ad=35.511p pd=48.245u as=35.511p ps=48.245u w=46.725u l=1u
X5004 DVDD GATE BAT DVDD pfet_06v0 ad=58.1096p pd=77.98u as=58.1096p ps=77.98u w=76.46u l=1u
X5005 DVDD GATE BAT DVDD pfet_06v0 ad=35.511p pd=48.245u as=35.511p ps=48.245u w=46.725u l=1u
X5006 DVDD GATE BAT DVDD pfet_06v0 ad=43.9215p pd=95.32999u as=35.511p ps=48.245u w=46.725u l=1u
X5007 BAT GATE DVDD DVDD pfet_06v0 ad=58.1134p pd=77.985u as=71.8771p ps=0.15481m w=76.465u l=1u
X5008 DVDD GATE BAT DVDD pfet_06v0 ad=35.511p pd=48.245u as=35.511p ps=48.245u w=46.725u l=1u
X5009 BAT GATE DVDD DVDD pfet_06v0 ad=58.1134p pd=77.985u as=58.1134p ps=77.985u w=76.465u l=1u
X5010 DVDD GATE BAT DVDD pfet_06v0 ad=58.0754p pd=77.935u as=58.0754p ps=77.935u w=76.41499u l=1u
X5011 BAT GATE DVDD DVDD pfet_06v0 ad=35.511p pd=48.245u as=35.511p ps=48.245u w=46.725u l=1u
X5012 BAT GATE DVDD DVDD pfet_06v0 ad=58.1552p pd=78.04u as=58.1552p ps=78.04u w=76.52u l=1u
X5013 BAT GATE DVDD DVDD pfet_06v0 ad=35.511p pd=48.245u as=43.9215p ps=95.32999u w=46.725u l=1u
X5014 BAT GATE DVDD DVDD pfet_06v0 ad=35.511p pd=48.245u as=35.511p ps=48.245u w=46.725u l=1u
X5015 BAT GATE DVDD DVDD pfet_06v0 ad=35.511p pd=48.245u as=35.511p ps=48.245u w=46.725u l=1u
X5016 BAT GATE DVDD DVDD pfet_06v0 ad=35.511p pd=48.245u as=35.511p ps=48.245u w=46.725u l=1u
X5017 DVDD GATE BAT DVDD pfet_06v0 ad=35.511p pd=48.245u as=35.511p ps=48.245u w=46.725u l=1u
X5018 BAT GATE DVDD DVDD pfet_06v0 ad=47.6862p pd=64.265u as=58.9803p ps=0.12737m w=62.745u l=1u
X5019 BAT GATE DVDD DVDD pfet_06v0 ad=58.1134p pd=77.985u as=58.1134p ps=77.985u w=76.465u l=1u
X5020 DVDD GATE BAT DVDD pfet_06v0 ad=35.5072p pd=48.24u as=35.5072p ps=48.24u w=46.72u l=1u
X5021 BAT GATE DVDD DVDD pfet_06v0 ad=35.511p pd=48.245u as=35.511p ps=48.245u w=46.725u l=1u
X5022 BAT GATE DVDD DVDD pfet_06v0 ad=58.1134p pd=77.985u as=58.1134p ps=77.985u w=76.465u l=1u
X5023 BAT GATE DVDD DVDD pfet_06v0 ad=58.1134p pd=77.985u as=71.8771p ps=0.15481m w=76.465u l=1u
X5024 DVDD GATE BAT DVDD pfet_06v0 ad=58.1134p pd=77.985u as=58.1134p ps=77.985u w=76.465u l=1u
X5025 BAT GATE DVDD DVDD pfet_06v0 ad=35.511p pd=48.245u as=35.511p ps=48.245u w=46.725u l=1u
X5026 DVDD GATE BAT DVDD pfet_06v0 ad=58.1134p pd=77.985u as=58.1134p ps=77.985u w=76.465u l=1u
X5027 BAT GATE DVDD DVDD pfet_06v0 ad=35.511p pd=48.245u as=35.511p ps=48.245u w=46.725u l=1u
X5028 BAT GATE DVDD DVDD pfet_06v0 ad=58.1134p pd=77.985u as=71.8771p ps=0.15481m w=76.465u l=1u
X5029 BAT GATE DVDD DVDD pfet_06v0 ad=35.511p pd=48.245u as=35.511p ps=48.245u w=46.725u l=1u
X5030 DVDD GATE BAT DVDD pfet_06v0 ad=35.511p pd=48.245u as=35.511p ps=48.245u w=46.725u l=1u
X5031 BAT GATE DVDD DVDD pfet_06v0 ad=58.1096p pd=77.98u as=71.8724p ps=0.1548m w=76.46u l=1u
X5032 DVDD GATE BAT DVDD pfet_06v0 ad=58.1134p pd=77.985u as=58.1134p ps=77.985u w=76.465u l=1u
X5033 DVDD GATE BAT DVDD pfet_06v0 ad=58.1172p pd=77.99u as=58.1172p ps=77.99u w=76.47u l=1u
X5034 BAT GATE DVDD DVDD pfet_06v0 ad=35.511p pd=48.245u as=35.511p ps=48.245u w=46.725u l=1u
X5035 DVDD GATE BAT DVDD pfet_06v0 ad=71.8818p pd=0.15482m as=58.1172p ps=77.99u w=76.47u l=1u
X5036 DVDD GATE BAT DVDD pfet_06v0 ad=58.1134p pd=77.985u as=58.1134p ps=77.985u w=76.465u l=1u
X5037 DVDD GATE BAT DVDD pfet_06v0 ad=35.5072p pd=48.24u as=35.5072p ps=48.24u w=46.72u l=1u
X5038 BAT GATE DVDD DVDD pfet_06v0 ad=58.1134p pd=77.985u as=58.1134p ps=77.985u w=76.465u l=1u
X5039 BAT GATE DVDD DVDD pfet_06v0 ad=35.511p pd=48.245u as=35.511p ps=48.245u w=46.725u l=1u
X5040 BAT GATE DVDD DVDD pfet_06v0 ad=35.511p pd=48.245u as=35.511p ps=48.245u w=46.725u l=1u
X5041 DVDD GATE BAT DVDD pfet_06v0 ad=35.511p pd=48.245u as=35.511p ps=48.245u w=46.725u l=1u
X5042 BAT GATE DVDD DVDD pfet_06v0 ad=35.511p pd=48.245u as=35.511p ps=48.245u w=46.725u l=1u
X5043 BAT GATE DVDD DVDD pfet_06v0 ad=35.511p pd=48.245u as=35.511p ps=48.245u w=46.725u l=1u
X5044 DVDD GATE BAT DVDD pfet_06v0 ad=58.1134p pd=77.985u as=58.1134p ps=77.985u w=76.465u l=1u
X5045 BAT GATE DVDD DVDD pfet_06v0 ad=35.5072p pd=48.24u as=35.5072p ps=48.24u w=46.72u l=1u
X5046 DVDD GATE BAT DVDD pfet_06v0 ad=58.1096p pd=77.98u as=58.1096p ps=77.98u w=76.46u l=1u
X5047 DVDD GATE BAT DVDD pfet_06v0 ad=35.511p pd=48.245u as=35.511p ps=48.245u w=46.725u l=1u
X5048 DVDD GATE BAT DVDD pfet_06v0 ad=35.511p pd=48.245u as=35.511p ps=48.245u w=46.725u l=1u
X5049 BAT GATE DVDD DVDD pfet_06v0 ad=47.6862p pd=64.265u as=47.6862p ps=64.265u w=62.745u l=1u
X5050 DVDD GATE BAT DVDD pfet_06v0 ad=71.8771p pd=0.15481m as=58.1134p ps=77.985u w=76.465u l=1u
X5051 BAT GATE DVDD DVDD pfet_06v0 ad=35.511p pd=48.245u as=35.511p ps=48.245u w=46.725u l=1u
X5052 BAT GATE DVDD DVDD pfet_06v0 ad=58.1552p pd=78.04u as=58.1552p ps=78.04u w=76.52u l=1u
X5053 DVDD GATE BAT DVDD pfet_06v0 ad=35.511p pd=48.245u as=35.511p ps=48.245u w=46.725u l=1u
X5054 DVDD GATE BAT DVDD pfet_06v0 ad=35.511p pd=48.245u as=35.511p ps=48.245u w=46.725u l=1u
X5055 DVDD GATE BAT DVDD pfet_06v0 ad=58.1134p pd=77.985u as=58.1134p ps=77.985u w=76.465u l=1u
X5056 DVDD GATE BAT DVDD pfet_06v0 ad=47.6862p pd=64.265u as=47.6862p ps=64.265u w=62.745u l=1u
X5057 DVDD GATE BAT DVDD pfet_06v0 ad=35.511p pd=48.245u as=35.511p ps=48.245u w=46.725u l=1u
X5058 BAT GATE DVDD DVDD pfet_06v0 ad=58.1134p pd=77.985u as=58.1134p ps=77.985u w=76.465u l=1u
X5059 BAT GATE DVDD DVDD pfet_06v0 ad=35.511p pd=48.245u as=35.511p ps=48.245u w=46.725u l=1u
X5060 BAT GATE DVDD DVDD pfet_06v0 ad=35.511p pd=48.245u as=35.511p ps=48.245u w=46.725u l=1u
X5061 BAT GATE DVDD DVDD pfet_06v0 ad=58.1134p pd=77.985u as=58.1134p ps=77.985u w=76.465u l=1u
X5062 BAT GATE DVDD DVDD pfet_06v0 ad=35.511p pd=48.245u as=35.511p ps=48.245u w=46.725u l=1u
X5063 DVDD GATE BAT DVDD pfet_06v0 ad=35.511p pd=48.245u as=35.511p ps=48.245u w=46.725u l=1u
X5064 BAT GATE DVDD DVDD pfet_06v0 ad=58.1134p pd=77.985u as=71.8771p ps=0.15481m w=76.465u l=1u
X5065 BAT GATE DVDD DVDD pfet_06v0 ad=47.6862p pd=64.265u as=47.6862p ps=64.265u w=62.745u l=1u
X5066 DVDD GATE BAT DVDD pfet_06v0 ad=58.1134p pd=77.985u as=58.1134p ps=77.985u w=76.465u l=1u
X5067 BAT GATE DVDD DVDD pfet_06v0 ad=58.1134p pd=77.985u as=58.1134p ps=77.985u w=76.465u l=1u
X5068 DVDD GATE BAT DVDD pfet_06v0 ad=47.6862p pd=64.265u as=47.6862p ps=64.265u w=62.745u l=1u
X5069 BAT GATE DVDD DVDD pfet_06v0 ad=58.1134p pd=77.985u as=58.1134p ps=77.985u w=76.465u l=1u
X5070 BAT GATE DVDD DVDD pfet_06v0 ad=35.511p pd=48.245u as=35.511p ps=48.245u w=46.725u l=1u
X5071 DVDD GATE BAT DVDD pfet_06v0 ad=35.511p pd=48.245u as=35.511p ps=48.245u w=46.725u l=1u
X5072 BAT GATE DVDD DVDD pfet_06v0 ad=58.1134p pd=77.985u as=71.8771p ps=0.15481m w=76.465u l=1u
X5073 BAT GATE DVDD DVDD pfet_06v0 ad=35.511p pd=48.245u as=35.511p ps=48.245u w=46.725u l=1u
X5074 DVDD GATE BAT DVDD pfet_06v0 ad=71.8818p pd=0.15482m as=58.1172p ps=77.99u w=76.47u l=1u
X5075 DVDD GATE BAT DVDD pfet_06v0 ad=58.1134p pd=77.985u as=58.1134p ps=77.985u w=76.465u l=1u
X5076 DVDD GATE BAT DVDD pfet_06v0 ad=43.9215p pd=95.32999u as=35.511p ps=48.245u w=46.725u l=1u
X5077 BAT GATE DVDD DVDD pfet_06v0 ad=35.511p pd=48.245u as=43.9215p ps=95.32999u w=46.725u l=1u
X5078 BAT GATE DVDD DVDD pfet_06v0 ad=58.1552p pd=78.04u as=58.1552p ps=78.04u w=76.52u l=1u
X5079 DVDD GATE BAT DVDD pfet_06v0 ad=58.1134p pd=77.985u as=58.1134p ps=77.985u w=76.465u l=1u
X5080 BAT GATE DVDD DVDD pfet_06v0 ad=35.511p pd=48.245u as=35.511p ps=48.245u w=46.725u l=1u
X5081 BAT GATE DVDD DVDD pfet_06v0 ad=35.511p pd=48.245u as=35.511p ps=48.245u w=46.725u l=1u
X5082 DVDD GATE BAT DVDD pfet_06v0 ad=71.8771p pd=0.15481m as=58.1134p ps=77.985u w=76.465u l=1u
X5083 BAT GATE DVDD DVDD pfet_06v0 ad=58.0754p pd=77.935u as=58.0754p ps=77.935u w=76.41499u l=1u
X5084 BAT GATE DVDD DVDD pfet_06v0 ad=58.0754p pd=77.935u as=58.0754p ps=77.935u w=76.41499u l=1u
X5085 DVDD GATE BAT DVDD pfet_06v0 ad=71.8771p pd=0.15481m as=58.1134p ps=77.985u w=76.465u l=1u
X5086 BAT GATE DVDD DVDD pfet_06v0 ad=58.0754p pd=77.935u as=58.0754p ps=77.935u w=76.41499u l=1u
X5087 DVDD GATE BAT DVDD pfet_06v0 ad=35.511p pd=48.245u as=35.511p ps=48.245u w=46.725u l=1u
X5088 DVDD GATE BAT DVDD pfet_06v0 ad=47.6862p pd=64.265u as=47.6862p ps=64.265u w=62.745u l=1u
X5089 DVDD GATE BAT DVDD pfet_06v0 ad=35.511p pd=48.245u as=35.511p ps=48.245u w=46.725u l=1u
X5090 DVDD GATE BAT DVDD pfet_06v0 ad=35.511p pd=48.245u as=35.511p ps=48.245u w=46.725u l=1u
X5091 DVDD GATE BAT DVDD pfet_06v0 ad=35.511p pd=48.245u as=35.511p ps=48.245u w=46.725u l=1u
X5092 BAT GATE DVDD DVDD pfet_06v0 ad=35.511p pd=48.245u as=43.9215p ps=95.32999u w=46.725u l=1u
X5093 DVDD GATE BAT DVDD pfet_06v0 ad=58.1134p pd=77.985u as=58.1134p ps=77.985u w=76.465u l=1u
X5094 DVDD GATE BAT DVDD pfet_06v0 ad=58.1134p pd=77.985u as=58.1134p ps=77.985u w=76.465u l=1u
X5095 BAT GATE DVDD DVDD pfet_06v0 ad=35.511p pd=48.245u as=35.511p ps=48.245u w=46.725u l=1u
X5096 BAT GATE DVDD DVDD pfet_06v0 ad=58.1134p pd=77.985u as=58.1134p ps=77.985u w=76.465u l=1u
X5097 DVDD GATE BAT DVDD pfet_06v0 ad=58.9803p pd=0.12737m as=47.6862p ps=64.265u w=62.745u l=1u
X5098 DVDD GATE BAT DVDD pfet_06v0 ad=58.1134p pd=77.985u as=58.1134p ps=77.985u w=76.465u l=1u
X5099 BAT GATE DVDD DVDD pfet_06v0 ad=58.1134p pd=77.985u as=58.1134p ps=77.985u w=76.465u l=1u
X5100 BAT GATE DVDD DVDD pfet_06v0 ad=58.1134p pd=77.985u as=58.1134p ps=77.985u w=76.465u l=1u
X5101 DVDD GATE BAT DVDD pfet_06v0 ad=58.0754p pd=77.935u as=58.0754p ps=77.935u w=76.41499u l=1u
X5102 DVDD GATE BAT DVDD pfet_06v0 ad=49.3848p pd=66.5u as=49.3848p ps=66.5u w=64.98u l=1u
X5103 BAT GATE DVDD DVDD pfet_06v0 ad=35.511p pd=48.245u as=35.511p ps=48.245u w=46.725u l=1u
X5104 DVDD GATE BAT DVDD pfet_06v0 ad=58.1172p pd=77.99u as=58.1172p ps=77.99u w=76.47u l=1u
X5105 BAT GATE DVDD DVDD pfet_06v0 ad=58.1172p pd=77.99u as=58.1172p ps=77.99u w=76.47u l=1u
X5106 BAT GATE DVDD DVDD pfet_06v0 ad=35.511p pd=48.245u as=35.511p ps=48.245u w=46.725u l=1u
X5107 DVDD GATE BAT DVDD pfet_06v0 ad=35.5072p pd=48.24u as=35.5072p ps=48.24u w=46.72u l=1u
X5108 BAT GATE DVDD DVDD pfet_06v0 ad=58.1096p pd=77.98u as=58.1096p ps=77.98u w=76.46u l=1u
X5109 DVDD GATE BAT DVDD pfet_06v0 ad=35.511p pd=48.245u as=35.511p ps=48.245u w=46.725u l=1u
X5110 BAT GATE DVDD DVDD pfet_06v0 ad=58.1552p pd=78.04u as=58.1552p ps=78.04u w=76.52u l=1u
X5111 BAT GATE DVDD DVDD pfet_06v0 ad=58.1096p pd=77.98u as=58.1096p ps=77.98u w=76.46u l=1u
X5112 DVDD GATE BAT DVDD pfet_06v0 ad=58.1134p pd=77.985u as=58.1134p ps=77.985u w=76.465u l=1u
X5113 BAT GATE DVDD DVDD pfet_06v0 ad=35.511p pd=48.245u as=35.511p ps=48.245u w=46.725u l=1u
X5114 DVDD GATE BAT DVDD pfet_06v0 ad=43.9168p pd=95.32u as=35.5072p ps=48.24u w=46.72u l=1u
X5115 BAT GATE DVDD DVDD pfet_06v0 ad=35.511p pd=48.245u as=35.511p ps=48.245u w=46.725u l=1u
X5116 BAT GATE DVDD DVDD pfet_06v0 ad=35.511p pd=48.245u as=35.511p ps=48.245u w=46.725u l=1u
X5117 BAT GATE DVDD DVDD pfet_06v0 ad=35.511p pd=48.245u as=35.511p ps=48.245u w=46.725u l=1u
X5118 BAT GATE DVDD DVDD pfet_06v0 ad=58.1134p pd=77.985u as=58.1134p ps=77.985u w=76.465u l=1u
X5119 DVDD GATE BAT DVDD pfet_06v0 ad=58.1172p pd=77.99u as=58.1172p ps=77.99u w=76.47u l=1u
X5120 BAT GATE DVDD DVDD pfet_06v0 ad=35.511p pd=48.245u as=35.511p ps=48.245u w=46.725u l=1u
X5121 DVDD GATE BAT DVDD pfet_06v0 ad=35.511p pd=48.245u as=35.511p ps=48.245u w=46.725u l=1u
X5122 BAT GATE DVDD DVDD pfet_06v0 ad=35.5072p pd=48.24u as=35.5072p ps=48.24u w=46.72u l=1u
X5123 BAT GATE DVDD DVDD pfet_06v0 ad=58.1134p pd=77.985u as=58.1134p ps=77.985u w=76.465u l=1u
X5124 BAT GATE DVDD DVDD pfet_06v0 ad=35.5072p pd=48.24u as=43.9168p ps=95.32u w=46.72u l=1u
X5125 BAT GATE DVDD DVDD pfet_06v0 ad=35.511p pd=48.245u as=35.511p ps=48.245u w=46.725u l=1u
X5126 DVDD GATE BAT DVDD pfet_06v0 ad=35.511p pd=48.245u as=35.511p ps=48.245u w=46.725u l=1u
X5127 BAT GATE DVDD DVDD pfet_06v0 ad=58.1134p pd=77.985u as=58.1134p ps=77.985u w=76.465u l=1u
X5128 DVDD GATE BAT DVDD pfet_06v0 ad=35.511p pd=48.245u as=35.511p ps=48.245u w=46.725u l=1u
X5129 BAT GATE DVDD DVDD pfet_06v0 ad=35.5072p pd=48.24u as=35.5072p ps=48.24u w=46.72u l=1u
X5130 BAT GATE DVDD DVDD pfet_06v0 ad=35.511p pd=48.245u as=43.9215p ps=95.32999u w=46.725u l=1u
X5131 DVDD GATE BAT DVDD pfet_06v0 ad=35.511p pd=48.245u as=35.511p ps=48.245u w=46.725u l=1u
X5132 BAT GATE DVDD DVDD pfet_06v0 ad=35.511p pd=48.245u as=35.511p ps=48.245u w=46.725u l=1u
X5133 DVDD GATE BAT DVDD pfet_06v0 ad=35.511p pd=48.245u as=35.511p ps=48.245u w=46.725u l=1u
X5134 DVDD GATE BAT DVDD pfet_06v0 ad=58.1134p pd=77.985u as=58.1134p ps=77.985u w=76.465u l=1u
X5135 BAT GATE DVDD DVDD pfet_06v0 ad=58.1096p pd=77.98u as=58.1096p ps=77.98u w=76.46u l=1u
X5136 DVDD GATE BAT DVDD pfet_06v0 ad=35.511p pd=48.245u as=35.511p ps=48.245u w=46.725u l=1u
X5137 DVDD GATE BAT DVDD pfet_06v0 ad=35.511p pd=48.245u as=35.511p ps=48.245u w=46.725u l=1u
X5138 BAT GATE DVDD DVDD pfet_06v0 ad=58.1134p pd=77.985u as=71.8771p ps=0.15481m w=76.465u l=1u
X5139 BAT GATE DVDD DVDD pfet_06v0 ad=58.1096p pd=77.98u as=58.1096p ps=77.98u w=76.46u l=1u
X5140 BAT GATE DVDD DVDD pfet_06v0 ad=58.1134p pd=77.985u as=71.8771p ps=0.15481m w=76.465u l=1u
X5141 DVDD GATE BAT DVDD pfet_06v0 ad=43.9215p pd=95.32999u as=35.511p ps=48.245u w=46.725u l=1u
X5142 BAT GATE DVDD DVDD pfet_06v0 ad=58.1134p pd=77.985u as=71.8771p ps=0.15481m w=76.465u l=1u
X5143 DVDD GATE BAT DVDD pfet_06v0 ad=43.9168p pd=95.32u as=35.5072p ps=48.24u w=46.72u l=1u
X5144 BAT GATE DVDD DVDD pfet_06v0 ad=35.511p pd=48.245u as=35.511p ps=48.245u w=46.725u l=1u
X5145 BAT GATE DVDD DVDD pfet_06v0 ad=58.1134p pd=77.985u as=58.1134p ps=77.985u w=76.465u l=1u
X5146 BAT GATE DVDD DVDD pfet_06v0 ad=35.511p pd=48.245u as=35.511p ps=48.245u w=46.725u l=1u
X5147 BAT GATE DVDD DVDD pfet_06v0 ad=58.1552p pd=78.04u as=58.1552p ps=78.04u w=76.52u l=1u
X5148 DVDD GATE BAT DVDD pfet_06v0 ad=35.511p pd=48.245u as=35.511p ps=48.245u w=46.725u l=1u
X5149 BAT GATE DVDD DVDD pfet_06v0 ad=58.1134p pd=77.985u as=58.1134p ps=77.985u w=76.465u l=1u
X5150 BAT GATE DVDD DVDD pfet_06v0 ad=35.511p pd=48.245u as=35.511p ps=48.245u w=46.725u l=1u
X5151 DVDD GATE BAT DVDD pfet_06v0 ad=58.1172p pd=77.99u as=58.1172p ps=77.99u w=76.47u l=1u
X5152 DVDD GATE BAT DVDD pfet_06v0 ad=58.1134p pd=77.985u as=58.1134p ps=77.985u w=76.465u l=1u
X5153 BAT GATE DVDD DVDD pfet_06v0 ad=58.1134p pd=77.985u as=58.1134p ps=77.985u w=76.465u l=1u
X5154 BAT GATE DVDD DVDD pfet_06v0 ad=35.5072p pd=48.24u as=35.5072p ps=48.24u w=46.72u l=1u
X5155 BAT GATE DVDD DVDD pfet_06v0 ad=47.6862p pd=64.265u as=47.6862p ps=64.265u w=62.745u l=1u
X5156 BAT GATE DVDD DVDD pfet_06v0 ad=35.511p pd=48.245u as=35.511p ps=48.245u w=46.725u l=1u
X5157 BAT GATE DVDD DVDD pfet_06v0 ad=35.511p pd=48.245u as=35.511p ps=48.245u w=46.725u l=1u
X5158 DVDD GATE BAT DVDD pfet_06v0 ad=35.511p pd=48.245u as=35.511p ps=48.245u w=46.725u l=1u
X5159 DVDD GATE BAT DVDD pfet_06v0 ad=35.511p pd=48.245u as=35.511p ps=48.245u w=46.725u l=1u
X5160 DVDD GATE BAT DVDD pfet_06v0 ad=58.9803p pd=0.12737m as=47.6862p ps=64.265u w=62.745u l=1u
X5161 DVDD GATE BAT DVDD pfet_06v0 ad=58.1134p pd=77.985u as=58.1134p ps=77.985u w=76.465u l=1u
X5162 BAT GATE DVDD DVDD pfet_06v0 ad=35.511p pd=48.245u as=35.511p ps=48.245u w=46.725u l=1u
X5163 DVDD GATE BAT DVDD pfet_06v0 ad=58.1134p pd=77.985u as=58.1134p ps=77.985u w=76.465u l=1u
X5164 BAT GATE DVDD DVDD pfet_06v0 ad=49.3848p pd=66.5u as=61.0812p ps=0.13184m w=64.98u l=1u
X5165 BAT GATE DVDD DVDD pfet_06v0 ad=49.3848p pd=66.5u as=49.3848p ps=66.5u w=64.98u l=1u
X5166 DVDD GATE BAT DVDD pfet_06v0 ad=47.6862p pd=64.265u as=47.6862p ps=64.265u w=62.745u l=1u
X5167 DVDD GATE BAT DVDD pfet_06v0 ad=58.1134p pd=77.985u as=58.1134p ps=77.985u w=76.465u l=1u
X5168 BAT GATE DVDD DVDD pfet_06v0 ad=35.511p pd=48.245u as=43.9215p ps=95.32999u w=46.725u l=1u
X5169 BAT GATE DVDD DVDD pfet_06v0 ad=49.3848p pd=66.5u as=49.3848p ps=66.5u w=64.98u l=1u
X5170 DVDD GATE BAT DVDD pfet_06v0 ad=58.1552p pd=78.04u as=58.1552p ps=78.04u w=76.52u l=1u
X5171 BAT GATE DVDD DVDD pfet_06v0 ad=47.6862p pd=64.265u as=47.6862p ps=64.265u w=62.745u l=1u
X5172 DVDD GATE BAT DVDD pfet_06v0 ad=71.8771p pd=0.15481m as=58.1134p ps=77.985u w=76.465u l=1u
X5173 BAT GATE DVDD DVDD pfet_06v0 ad=58.1134p pd=77.985u as=58.1134p ps=77.985u w=76.465u l=1u
X5174 DVDD GATE BAT DVDD pfet_06v0 ad=58.0754p pd=77.935u as=58.0754p ps=77.935u w=76.41499u l=1u
X5175 DVDD GATE BAT DVDD pfet_06v0 ad=49.3848p pd=66.5u as=49.3848p ps=66.5u w=64.98u l=1u
X5176 BAT GATE DVDD DVDD pfet_06v0 ad=58.1172p pd=77.99u as=58.1172p ps=77.99u w=76.47u l=1u
X5177 DVDD GATE BAT DVDD pfet_06v0 ad=58.1134p pd=77.985u as=58.1134p ps=77.985u w=76.465u l=1u
X5178 DVDD GATE BAT DVDD pfet_06v0 ad=35.511p pd=48.245u as=35.511p ps=48.245u w=46.725u l=1u
X5179 DVDD GATE BAT DVDD pfet_06v0 ad=35.511p pd=48.245u as=35.511p ps=48.245u w=46.725u l=1u
X5180 DVDD GATE BAT DVDD pfet_06v0 ad=58.1134p pd=77.985u as=58.1134p ps=77.985u w=76.465u l=1u
X5181 DVDD GATE BAT DVDD pfet_06v0 ad=58.1096p pd=77.98u as=58.1096p ps=77.98u w=76.46u l=1u
X5182 DVDD GATE BAT DVDD pfet_06v0 ad=58.9803p pd=0.12737m as=47.6862p ps=64.265u w=62.745u l=1u
X5183 BAT GATE DVDD DVDD pfet_06v0 ad=58.1134p pd=77.985u as=71.8771p ps=0.15481m w=76.465u l=1u
X5184 BAT GATE DVDD DVDD pfet_06v0 ad=58.1134p pd=77.985u as=71.8771p ps=0.15481m w=76.465u l=1u
X5185 BAT GATE DVDD DVDD pfet_06v0 ad=58.1134p pd=77.985u as=71.8771p ps=0.15481m w=76.465u l=1u
X5186 DVDD GATE BAT DVDD pfet_06v0 ad=58.1096p pd=77.98u as=58.1096p ps=77.98u w=76.46u l=1u
X5187 BAT GATE DVDD DVDD pfet_06v0 ad=58.1134p pd=77.985u as=71.8771p ps=0.15481m w=76.465u l=1u
X5188 BAT GATE DVDD DVDD pfet_06v0 ad=47.6862p pd=64.265u as=47.6862p ps=64.265u w=62.745u l=1u
X5189 DVDD GATE BAT DVDD pfet_06v0 ad=35.511p pd=48.245u as=35.511p ps=48.245u w=46.725u l=1u
X5190 BAT GATE DVDD DVDD pfet_06v0 ad=58.1134p pd=77.985u as=58.1134p ps=77.985u w=76.465u l=1u
X5191 DVDD GATE BAT DVDD pfet_06v0 ad=35.511p pd=48.245u as=35.511p ps=48.245u w=46.725u l=1u
X5192 DVDD GATE BAT DVDD pfet_06v0 ad=71.8771p pd=0.15481m as=58.1134p ps=77.985u w=76.465u l=1u
X5193 DVDD GATE BAT DVDD pfet_06v0 ad=58.1134p pd=77.985u as=58.1134p ps=77.985u w=76.465u l=1u
X5194 BAT GATE DVDD DVDD pfet_06v0 ad=35.511p pd=48.245u as=43.9215p ps=95.32999u w=46.725u l=1u
X5195 DVDD GATE BAT DVDD pfet_06v0 ad=35.5072p pd=48.24u as=35.5072p ps=48.24u w=46.72u l=1u
X5196 BAT GATE DVDD DVDD pfet_06v0 ad=35.511p pd=48.245u as=35.511p ps=48.245u w=46.725u l=1u
X5197 DVDD GATE BAT DVDD pfet_06v0 ad=58.1172p pd=77.99u as=58.1172p ps=77.99u w=76.47u l=1u
X5198 DVDD GATE BAT DVDD pfet_06v0 ad=43.9215p pd=95.32999u as=35.511p ps=48.245u w=46.725u l=1u
X5199 DVDD GATE BAT DVDD pfet_06v0 ad=35.511p pd=48.245u as=35.511p ps=48.245u w=46.725u l=1u
X5200 BAT GATE DVDD DVDD pfet_06v0 ad=35.511p pd=48.245u as=35.511p ps=48.245u w=46.725u l=1u
X5201 BAT GATE DVDD DVDD pfet_06v0 ad=58.1096p pd=77.98u as=58.1096p ps=77.98u w=76.46u l=1u
X5202 BAT GATE DVDD DVDD pfet_06v0 ad=47.6862p pd=64.265u as=47.6862p ps=64.265u w=62.745u l=1u
X5203 BAT GATE DVDD DVDD pfet_06v0 ad=58.1134p pd=77.985u as=58.1134p ps=77.985u w=76.465u l=1u
X5204 BAT GATE DVDD DVDD pfet_06v0 ad=35.511p pd=48.245u as=35.511p ps=48.245u w=46.725u l=1u
X5205 DVDD GATE BAT DVDD pfet_06v0 ad=43.9215p pd=95.32999u as=35.511p ps=48.245u w=46.725u l=1u
X5206 BAT GATE DVDD DVDD pfet_06v0 ad=35.511p pd=48.245u as=43.9215p ps=95.32999u w=46.725u l=1u
X5207 BAT GATE DVDD DVDD pfet_06v0 ad=58.1552p pd=78.04u as=71.92879p ps=0.15492m w=76.52u l=1u
X5208 DVDD GATE BAT DVDD pfet_06v0 ad=58.1134p pd=77.985u as=58.1134p ps=77.985u w=76.465u l=1u
X5209 DVDD GATE BAT DVDD pfet_06v0 ad=58.1172p pd=77.99u as=58.1172p ps=77.99u w=76.47u l=1u
X5210 BAT GATE DVDD DVDD pfet_06v0 ad=35.511p pd=48.245u as=35.511p ps=48.245u w=46.725u l=1u
X5211 BAT GATE DVDD DVDD pfet_06v0 ad=58.1134p pd=77.985u as=58.1134p ps=77.985u w=76.465u l=1u
X5212 BAT GATE DVDD DVDD pfet_06v0 ad=35.511p pd=48.245u as=43.9215p ps=95.32999u w=46.725u l=1u
X5213 BAT GATE DVDD DVDD pfet_06v0 ad=58.0754p pd=77.935u as=58.0754p ps=77.935u w=76.41499u l=1u
X5214 DVDD GATE BAT DVDD pfet_06v0 ad=58.1134p pd=77.985u as=58.1134p ps=77.985u w=76.465u l=1u
X5215 DVDD GATE BAT DVDD pfet_06v0 ad=58.1134p pd=77.985u as=58.1134p ps=77.985u w=76.465u l=1u
X5216 DVDD GATE BAT DVDD pfet_06v0 ad=35.511p pd=48.245u as=35.511p ps=48.245u w=46.725u l=1u
X5217 BAT GATE DVDD DVDD pfet_06v0 ad=58.1134p pd=77.985u as=58.1134p ps=77.985u w=76.465u l=1u
X5218 DVDD GATE BAT DVDD pfet_06v0 ad=58.1096p pd=77.98u as=58.1096p ps=77.98u w=76.46u l=1u
X5219 DVDD GATE BAT DVDD pfet_06v0 ad=35.511p pd=48.245u as=35.511p ps=48.245u w=46.725u l=1u
X5220 BAT GATE DVDD DVDD pfet_06v0 ad=35.5072p pd=48.24u as=35.5072p ps=48.24u w=46.72u l=1u
X5221 DVDD GATE BAT DVDD pfet_06v0 ad=43.9215p pd=95.32999u as=35.511p ps=48.245u w=46.725u l=1u
X5222 DVDD GATE BAT DVDD pfet_06v0 ad=35.511p pd=48.245u as=35.511p ps=48.245u w=46.725u l=1u
X5223 DVDD GATE BAT DVDD pfet_06v0 ad=35.511p pd=48.245u as=35.511p ps=48.245u w=46.725u l=1u
X5224 BAT GATE DVDD DVDD pfet_06v0 ad=58.1134p pd=77.985u as=58.1134p ps=77.985u w=76.465u l=1u
X5225 BAT GATE DVDD DVDD pfet_06v0 ad=35.511p pd=48.245u as=35.511p ps=48.245u w=46.725u l=1u
X5226 BAT GATE DVDD DVDD pfet_06v0 ad=58.1172p pd=77.99u as=71.8818p ps=0.15482m w=76.47u l=1u
X5227 BAT GATE DVDD DVDD pfet_06v0 ad=35.511p pd=48.245u as=35.511p ps=48.245u w=46.725u l=1u
X5228 DVDD GATE BAT DVDD pfet_06v0 ad=35.511p pd=48.245u as=35.511p ps=48.245u w=46.725u l=1u
X5229 DVDD GATE BAT DVDD pfet_06v0 ad=35.511p pd=48.245u as=35.511p ps=48.245u w=46.725u l=1u
X5230 DVDD GATE BAT DVDD pfet_06v0 ad=58.1134p pd=77.985u as=58.1134p ps=77.985u w=76.465u l=1u
X5231 BAT GATE DVDD DVDD pfet_06v0 ad=35.511p pd=48.245u as=35.511p ps=48.245u w=46.725u l=1u
X5232 DVDD GATE BAT DVDD pfet_06v0 ad=35.511p pd=48.245u as=35.511p ps=48.245u w=46.725u l=1u
X5233 DVDD GATE BAT DVDD pfet_06v0 ad=35.511p pd=48.245u as=35.511p ps=48.245u w=46.725u l=1u
X5234 DVDD GATE BAT DVDD pfet_06v0 ad=35.511p pd=48.245u as=35.511p ps=48.245u w=46.725u l=1u
X5235 DVDD GATE BAT DVDD pfet_06v0 ad=58.1096p pd=77.98u as=58.1096p ps=77.98u w=76.46u l=1u
X5236 BAT GATE DVDD DVDD pfet_06v0 ad=35.511p pd=48.245u as=35.511p ps=48.245u w=46.725u l=1u
X5237 BAT GATE DVDD DVDD pfet_06v0 ad=58.1134p pd=77.985u as=58.1134p ps=77.985u w=76.465u l=1u
X5238 BAT GATE DVDD DVDD pfet_06v0 ad=35.511p pd=48.245u as=35.511p ps=48.245u w=46.725u l=1u
X5239 DVDD GATE BAT DVDD pfet_06v0 ad=58.1134p pd=77.985u as=58.1134p ps=77.985u w=76.465u l=1u
X5240 BAT GATE DVDD DVDD pfet_06v0 ad=58.1096p pd=77.98u as=58.1096p ps=77.98u w=76.46u l=1u
X5241 DVDD GATE BAT DVDD pfet_06v0 ad=47.6862p pd=64.265u as=47.6862p ps=64.265u w=62.745u l=1u
X5242 BAT GATE DVDD DVDD pfet_06v0 ad=35.511p pd=48.245u as=35.511p ps=48.245u w=46.725u l=1u
X5243 DVDD GATE BAT DVDD pfet_06v0 ad=58.1134p pd=77.985u as=58.1134p ps=77.985u w=76.465u l=1u
X5244 BAT GATE DVDD DVDD pfet_06v0 ad=58.0754p pd=77.935u as=58.0754p ps=77.935u w=76.41499u l=1u
X5245 DVDD GATE BAT DVDD pfet_06v0 ad=71.8771p pd=0.15481m as=58.1134p ps=77.985u w=76.465u l=1u
X5246 DVDD GATE BAT DVDD pfet_06v0 ad=35.511p pd=48.245u as=35.511p ps=48.245u w=46.725u l=1u
X5247 BAT GATE DVDD DVDD pfet_06v0 ad=58.1134p pd=77.985u as=58.1134p ps=77.985u w=76.465u l=1u
X5248 DVDD GATE BAT DVDD pfet_06v0 ad=35.511p pd=48.245u as=35.511p ps=48.245u w=46.725u l=1u
X5249 DVDD GATE BAT DVDD pfet_06v0 ad=58.1134p pd=77.985u as=58.1134p ps=77.985u w=76.465u l=1u
X5250 DVDD GATE BAT DVDD pfet_06v0 ad=58.1134p pd=77.985u as=58.1134p ps=77.985u w=76.465u l=1u
X5251 DVDD GATE BAT DVDD pfet_06v0 ad=35.511p pd=48.245u as=35.511p ps=48.245u w=46.725u l=1u
X5252 BAT GATE DVDD DVDD pfet_06v0 ad=35.511p pd=48.245u as=35.511p ps=48.245u w=46.725u l=1u
X5253 BAT GATE DVDD DVDD pfet_06v0 ad=35.511p pd=48.245u as=35.511p ps=48.245u w=46.725u l=1u
X5254 DVDD GATE BAT DVDD pfet_06v0 ad=35.511p pd=48.245u as=35.511p ps=48.245u w=46.725u l=1u
X5255 DVDD GATE BAT DVDD pfet_06v0 ad=58.1134p pd=77.985u as=58.1134p ps=77.985u w=76.465u l=1u
X5256 DVDD GATE BAT DVDD pfet_06v0 ad=58.1134p pd=77.985u as=58.1134p ps=77.985u w=76.465u l=1u
X5257 DVDD GATE BAT DVDD pfet_06v0 ad=58.1134p pd=77.985u as=58.1134p ps=77.985u w=76.465u l=1u
X5258 BAT GATE DVDD DVDD pfet_06v0 ad=35.511p pd=48.245u as=35.511p ps=48.245u w=46.725u l=1u
X5259 DVDD GATE BAT DVDD pfet_06v0 ad=35.511p pd=48.245u as=35.511p ps=48.245u w=46.725u l=1u
X5260 BAT GATE DVDD DVDD pfet_06v0 ad=35.5072p pd=48.24u as=35.5072p ps=48.24u w=46.72u l=1u
X5261 DVDD GATE BAT DVDD pfet_06v0 ad=35.511p pd=48.245u as=35.511p ps=48.245u w=46.725u l=1u
X5262 BAT GATE DVDD DVDD pfet_06v0 ad=35.511p pd=48.245u as=35.511p ps=48.245u w=46.725u l=1u
X5263 BAT GATE DVDD DVDD pfet_06v0 ad=58.1134p pd=77.985u as=58.1134p ps=77.985u w=76.465u l=1u
X5264 BAT GATE DVDD DVDD pfet_06v0 ad=58.1172p pd=77.99u as=71.8818p ps=0.15482m w=76.47u l=1u
X5265 BAT GATE DVDD DVDD pfet_06v0 ad=58.1134p pd=77.985u as=58.1134p ps=77.985u w=76.465u l=1u
X5266 DVDD GATE BAT DVDD pfet_06v0 ad=35.511p pd=48.245u as=35.511p ps=48.245u w=46.725u l=1u
X5267 BAT GATE DVDD DVDD pfet_06v0 ad=35.511p pd=48.245u as=43.9215p ps=95.32999u w=46.725u l=1u
X5268 DVDD GATE BAT DVDD pfet_06v0 ad=35.511p pd=48.245u as=35.511p ps=48.245u w=46.725u l=1u
X5269 BAT GATE DVDD DVDD pfet_06v0 ad=58.1134p pd=77.985u as=58.1134p ps=77.985u w=76.465u l=1u
X5270 DVDD GATE BAT DVDD pfet_06v0 ad=35.511p pd=48.245u as=35.511p ps=48.245u w=46.725u l=1u
X5271 DVDD GATE BAT DVDD pfet_06v0 ad=43.9215p pd=95.32999u as=35.511p ps=48.245u w=46.725u l=1u
X5272 BAT GATE DVDD DVDD pfet_06v0 ad=49.3848p pd=66.5u as=61.0812p ps=0.13184m w=64.98u l=1u
X5273 BAT GATE DVDD DVDD pfet_06v0 ad=35.511p pd=48.245u as=43.9215p ps=95.32999u w=46.725u l=1u
X5274 BAT GATE DVDD DVDD pfet_06v0 ad=58.1134p pd=77.985u as=71.8771p ps=0.15481m w=76.465u l=1u
X5275 BAT GATE DVDD DVDD pfet_06v0 ad=58.1134p pd=77.985u as=58.1134p ps=77.985u w=76.465u l=1u
X5276 DVDD GATE BAT DVDD pfet_06v0 ad=71.8771p pd=0.15481m as=58.1134p ps=77.985u w=76.465u l=1u
X5277 BAT GATE DVDD DVDD pfet_06v0 ad=35.511p pd=48.245u as=35.511p ps=48.245u w=46.725u l=1u
X5278 BAT GATE DVDD DVDD pfet_06v0 ad=58.1134p pd=77.985u as=58.1134p ps=77.985u w=76.465u l=1u
X5279 BAT GATE DVDD DVDD pfet_06v0 ad=35.511p pd=48.245u as=43.9215p ps=95.32999u w=46.725u l=1u
X5280 DVDD GATE BAT DVDD pfet_06v0 ad=35.511p pd=48.245u as=35.511p ps=48.245u w=46.725u l=1u
X5281 DVDD GATE BAT DVDD pfet_06v0 ad=35.511p pd=48.245u as=35.511p ps=48.245u w=46.725u l=1u
X5282 BAT GATE DVDD DVDD pfet_06v0 ad=47.6862p pd=64.265u as=47.6862p ps=64.265u w=62.745u l=1u
X5283 DVDD GATE BAT DVDD pfet_06v0 ad=49.3848p pd=66.5u as=49.3848p ps=66.5u w=64.98u l=1u
X5284 DVDD GATE BAT DVDD pfet_06v0 ad=58.1134p pd=77.985u as=58.1134p ps=77.985u w=76.465u l=1u
X5285 DVDD GATE BAT DVDD pfet_06v0 ad=35.511p pd=48.245u as=35.511p ps=48.245u w=46.725u l=1u
X5286 DVDD GATE BAT DVDD pfet_06v0 ad=58.1552p pd=78.04u as=58.1552p ps=78.04u w=76.52u l=1u
X5287 BAT GATE DVDD DVDD pfet_06v0 ad=35.5072p pd=48.24u as=35.5072p ps=48.24u w=46.72u l=1u
X5288 BAT GATE DVDD DVDD pfet_06v0 ad=58.1134p pd=77.985u as=58.1134p ps=77.985u w=76.465u l=1u
X5289 BAT GATE DVDD DVDD pfet_06v0 ad=47.6862p pd=64.265u as=58.9803p ps=0.12737m w=62.745u l=1u
X5290 BAT GATE DVDD DVDD pfet_06v0 ad=58.1134p pd=77.985u as=58.1134p ps=77.985u w=76.465u l=1u
X5291 DVDD GATE BAT DVDD pfet_06v0 ad=58.1134p pd=77.985u as=58.1134p ps=77.985u w=76.465u l=1u
X5292 BAT GATE DVDD DVDD pfet_06v0 ad=35.511p pd=48.245u as=43.9215p ps=95.32999u w=46.725u l=1u
X5293 BAT GATE DVDD DVDD pfet_06v0 ad=58.1134p pd=77.985u as=58.1134p ps=77.985u w=76.465u l=1u
X5294 BAT GATE DVDD DVDD pfet_06v0 ad=58.1096p pd=77.98u as=58.1096p ps=77.98u w=76.46u l=1u
X5295 DVDD GATE BAT DVDD pfet_06v0 ad=35.511p pd=48.245u as=35.511p ps=48.245u w=46.725u l=1u
X5296 DVDD GATE BAT DVDD pfet_06v0 ad=71.8301p pd=0.15471m as=58.0754p ps=77.935u w=76.41499u l=1u
X5297 DVDD GATE BAT DVDD pfet_06v0 ad=71.8771p pd=0.15481m as=58.1134p ps=77.985u w=76.465u l=1u
X5298 DVDD GATE BAT DVDD pfet_06v0 ad=58.1134p pd=77.985u as=58.1134p ps=77.985u w=76.465u l=1u
X5299 DVDD GATE BAT DVDD pfet_06v0 ad=35.511p pd=48.245u as=35.511p ps=48.245u w=46.725u l=1u
X5300 DVDD GATE BAT DVDD pfet_06v0 ad=58.1172p pd=77.99u as=58.1172p ps=77.99u w=76.47u l=1u
X5301 BAT GATE DVDD DVDD pfet_06v0 ad=58.1134p pd=77.985u as=58.1134p ps=77.985u w=76.465u l=1u
X5302 BAT GATE DVDD DVDD pfet_06v0 ad=35.5072p pd=48.24u as=35.5072p ps=48.24u w=46.72u l=1u
X5303 BAT GATE DVDD DVDD pfet_06v0 ad=58.1134p pd=77.985u as=71.8771p ps=0.15481m w=76.465u l=1u
X5304 BAT GATE DVDD DVDD pfet_06v0 ad=35.511p pd=48.245u as=35.511p ps=48.245u w=46.725u l=1u
X5305 DVDD GATE BAT DVDD pfet_06v0 ad=58.1134p pd=77.985u as=58.1134p ps=77.985u w=76.465u l=1u
X5306 BAT GATE DVDD DVDD pfet_06v0 ad=49.3848p pd=66.5u as=49.3848p ps=66.5u w=64.98u l=1u
X5307 DVDD GATE BAT DVDD pfet_06v0 ad=58.1096p pd=77.98u as=58.1096p ps=77.98u w=76.46u l=1u
X5308 DVDD GATE BAT DVDD pfet_06v0 ad=58.1134p pd=77.985u as=58.1134p ps=77.985u w=76.465u l=1u
X5309 DVDD GATE BAT DVDD pfet_06v0 ad=71.8771p pd=0.15481m as=58.1134p ps=77.985u w=76.465u l=1u
X5310 BAT GATE DVDD DVDD pfet_06v0 ad=58.1172p pd=77.99u as=58.1172p ps=77.99u w=76.47u l=1u
X5311 DVDD GATE BAT DVDD pfet_06v0 ad=35.511p pd=48.245u as=35.511p ps=48.245u w=46.725u l=1u
X5312 BAT GATE DVDD DVDD pfet_06v0 ad=35.511p pd=48.245u as=43.9215p ps=95.32999u w=46.725u l=1u
X5313 BAT GATE DVDD DVDD pfet_06v0 ad=49.3848p pd=66.5u as=49.3848p ps=66.5u w=64.98u l=1u
X5314 BAT GATE DVDD DVDD pfet_06v0 ad=58.1134p pd=77.985u as=58.1134p ps=77.985u w=76.465u l=1u
X5315 DVDD GATE BAT DVDD pfet_06v0 ad=71.8724p pd=0.1548m as=58.1096p ps=77.98u w=76.46u l=1u
X5316 DVDD GATE BAT DVDD pfet_06v0 ad=58.1134p pd=77.985u as=58.1134p ps=77.985u w=76.465u l=1u
X5317 BAT GATE DVDD DVDD pfet_06v0 ad=58.1134p pd=77.985u as=58.1134p ps=77.985u w=76.465u l=1u
X5318 DVDD GATE BAT DVDD pfet_06v0 ad=58.0754p pd=77.935u as=58.0754p ps=77.935u w=76.41499u l=1u
X5319 BAT GATE DVDD DVDD pfet_06v0 ad=35.511p pd=48.245u as=35.511p ps=48.245u w=46.725u l=1u
X5320 DVDD GATE BAT DVDD pfet_06v0 ad=35.5072p pd=48.24u as=35.5072p ps=48.24u w=46.72u l=1u
X5321 BAT GATE DVDD DVDD pfet_06v0 ad=47.6862p pd=64.265u as=58.9803p ps=0.12737m w=62.745u l=1u
X5322 DVDD GATE BAT DVDD pfet_06v0 ad=71.8771p pd=0.15481m as=58.1134p ps=77.985u w=76.465u l=1u
X5323 BAT GATE DVDD DVDD pfet_06v0 ad=35.511p pd=48.245u as=35.511p ps=48.245u w=46.725u l=1u
X5324 BAT GATE DVDD DVDD pfet_06v0 ad=58.1134p pd=77.985u as=58.1134p ps=77.985u w=76.465u l=1u
X5325 BAT GATE DVDD DVDD pfet_06v0 ad=58.1096p pd=77.98u as=58.1096p ps=77.98u w=76.46u l=1u
X5326 BAT GATE DVDD DVDD pfet_06v0 ad=35.511p pd=48.245u as=35.511p ps=48.245u w=46.725u l=1u
X5327 DVDD GATE BAT DVDD pfet_06v0 ad=58.0754p pd=77.935u as=58.0754p ps=77.935u w=76.41499u l=1u
X5328 BAT GATE DVDD DVDD pfet_06v0 ad=58.1134p pd=77.985u as=58.1134p ps=77.985u w=76.465u l=1u
X5329 BAT GATE DVDD DVDD pfet_06v0 ad=58.1096p pd=77.98u as=71.8724p ps=0.1548m w=76.46u l=1u
X5330 BAT GATE DVDD DVDD pfet_06v0 ad=35.511p pd=48.245u as=35.511p ps=48.245u w=46.725u l=1u
X5331 DVDD GATE BAT DVDD pfet_06v0 ad=58.1134p pd=77.985u as=58.1134p ps=77.985u w=76.465u l=1u
X5332 DVDD GATE BAT DVDD pfet_06v0 ad=58.1172p pd=77.99u as=58.1172p ps=77.99u w=76.47u l=1u
X5333 BAT GATE DVDD DVDD pfet_06v0 ad=58.1096p pd=77.98u as=58.1096p ps=77.98u w=76.46u l=1u
X5334 DVDD GATE BAT DVDD pfet_06v0 ad=35.511p pd=48.245u as=35.511p ps=48.245u w=46.725u l=1u
X5335 BAT GATE DVDD DVDD pfet_06v0 ad=58.1172p pd=77.99u as=58.1172p ps=77.99u w=76.47u l=1u
X5336 DVDD GATE BAT DVDD pfet_06v0 ad=35.511p pd=48.245u as=35.511p ps=48.245u w=46.725u l=1u
X5337 BAT GATE DVDD DVDD pfet_06v0 ad=35.5072p pd=48.24u as=35.5072p ps=48.24u w=46.72u l=1u
X5338 BAT GATE DVDD DVDD pfet_06v0 ad=35.511p pd=48.245u as=35.511p ps=48.245u w=46.725u l=1u
X5339 BAT GATE DVDD DVDD pfet_06v0 ad=35.511p pd=48.245u as=35.511p ps=48.245u w=46.725u l=1u
X5340 BAT GATE DVDD DVDD pfet_06v0 ad=35.5072p pd=48.24u as=43.9168p ps=95.32u w=46.72u l=1u
X5341 BAT GATE DVDD DVDD pfet_06v0 ad=58.1134p pd=77.985u as=71.8771p ps=0.15481m w=76.465u l=1u
X5342 DVDD GATE BAT DVDD pfet_06v0 ad=58.1552p pd=78.04u as=58.1552p ps=78.04u w=76.52u l=1u
X5343 DVDD GATE BAT DVDD pfet_06v0 ad=71.8771p pd=0.15481m as=58.1134p ps=77.985u w=76.465u l=1u
X5344 DVDD GATE BAT DVDD pfet_06v0 ad=58.1134p pd=77.985u as=58.1134p ps=77.985u w=76.465u l=1u
X5345 DVDD GATE BAT DVDD pfet_06v0 ad=71.8771p pd=0.15481m as=58.1134p ps=77.985u w=76.465u l=1u
X5346 BAT GATE DVDD DVDD pfet_06v0 ad=35.511p pd=48.245u as=35.511p ps=48.245u w=46.725u l=1u
X5347 DVDD GATE BAT DVDD pfet_06v0 ad=71.8818p pd=0.15482m as=58.1172p ps=77.99u w=76.47u l=1u
X5348 DVDD GATE BAT DVDD pfet_06v0 ad=71.8724p pd=0.1548m as=58.1096p ps=77.98u w=76.46u l=1u
X5349 DVDD GATE BAT DVDD pfet_06v0 ad=58.1134p pd=77.985u as=58.1134p ps=77.985u w=76.465u l=1u
X5350 DVDD GATE BAT DVDD pfet_06v0 ad=35.511p pd=48.245u as=35.511p ps=48.245u w=46.725u l=1u
X5351 DVDD GATE BAT DVDD pfet_06v0 ad=35.511p pd=48.245u as=35.511p ps=48.245u w=46.725u l=1u
X5352 BAT GATE DVDD DVDD pfet_06v0 ad=58.1134p pd=77.985u as=58.1134p ps=77.985u w=76.465u l=1u
X5353 DVDD GATE BAT DVDD pfet_06v0 ad=58.0754p pd=77.935u as=58.0754p ps=77.935u w=76.41499u l=1u
X5354 DVDD GATE BAT DVDD pfet_06v0 ad=58.1552p pd=78.04u as=58.1552p ps=78.04u w=76.52u l=1u
X5355 BAT GATE DVDD DVDD pfet_06v0 ad=58.1134p pd=77.985u as=58.1134p ps=77.985u w=76.465u l=1u
X5356 BAT GATE DVDD DVDD pfet_06v0 ad=35.511p pd=48.245u as=43.9215p ps=95.32999u w=46.725u l=1u
X5357 BAT GATE DVDD DVDD pfet_06v0 ad=58.1552p pd=78.04u as=58.1552p ps=78.04u w=76.52u l=1u
X5358 BAT GATE DVDD DVDD pfet_06v0 ad=35.511p pd=48.245u as=35.511p ps=48.245u w=46.725u l=1u
X5359 DVDD GATE BAT DVDD pfet_06v0 ad=47.6862p pd=64.265u as=47.6862p ps=64.265u w=62.745u l=1u
X5360 BAT GATE DVDD DVDD pfet_06v0 ad=35.511p pd=48.245u as=35.511p ps=48.245u w=46.725u l=1u
X5361 DVDD GATE BAT DVDD pfet_06v0 ad=43.9215p pd=95.32999u as=35.511p ps=48.245u w=46.725u l=1u
X5362 DVDD GATE BAT DVDD pfet_06v0 ad=43.9215p pd=95.32999u as=35.511p ps=48.245u w=46.725u l=1u
X5363 BAT GATE DVDD DVDD pfet_06v0 ad=58.1134p pd=77.985u as=58.1134p ps=77.985u w=76.465u l=1u
X5364 DVDD GATE BAT DVDD pfet_06v0 ad=35.511p pd=48.245u as=35.511p ps=48.245u w=46.725u l=1u
X5365 DVDD GATE BAT DVDD pfet_06v0 ad=35.511p pd=48.245u as=35.511p ps=48.245u w=46.725u l=1u
X5366 DVDD GATE BAT DVDD pfet_06v0 ad=43.9215p pd=95.32999u as=35.511p ps=48.245u w=46.725u l=1u
X5367 BAT GATE DVDD DVDD pfet_06v0 ad=58.1134p pd=77.985u as=58.1134p ps=77.985u w=76.465u l=1u
X5368 DVDD GATE BAT DVDD pfet_06v0 ad=43.9215p pd=95.32999u as=35.511p ps=48.245u w=46.725u l=1u
X5369 DVDD GATE BAT DVDD pfet_06v0 ad=58.1134p pd=77.985u as=58.1134p ps=77.985u w=76.465u l=1u
X5370 BAT GATE DVDD DVDD pfet_06v0 ad=35.511p pd=48.245u as=35.511p ps=48.245u w=46.725u l=1u
X5371 DVDD GATE BAT DVDD pfet_06v0 ad=58.1134p pd=77.985u as=58.1134p ps=77.985u w=76.465u l=1u
X5372 DVDD GATE BAT DVDD pfet_06v0 ad=35.511p pd=48.245u as=35.511p ps=48.245u w=46.725u l=1u
X5373 DVDD GATE BAT DVDD pfet_06v0 ad=35.5072p pd=48.24u as=35.5072p ps=48.24u w=46.72u l=1u
X5374 BAT GATE DVDD DVDD pfet_06v0 ad=35.511p pd=48.245u as=35.511p ps=48.245u w=46.725u l=1u
X5375 BAT GATE DVDD DVDD pfet_06v0 ad=35.511p pd=48.245u as=43.9215p ps=95.32999u w=46.725u l=1u
X5376 DVDD GATE BAT DVDD pfet_06v0 ad=58.1134p pd=77.985u as=58.1134p ps=77.985u w=76.465u l=1u
X5377 BAT GATE DVDD DVDD pfet_06v0 ad=35.5072p pd=48.24u as=35.5072p ps=48.24u w=46.72u l=1u
X5378 DVDD GATE BAT DVDD pfet_06v0 ad=58.1134p pd=77.985u as=58.1134p ps=77.985u w=76.465u l=1u
X5379 DVDD GATE BAT DVDD pfet_06v0 ad=35.511p pd=48.245u as=35.511p ps=48.245u w=46.725u l=1u
X5380 DVDD GATE BAT DVDD pfet_06v0 ad=58.0754p pd=77.935u as=58.0754p ps=77.935u w=76.41499u l=1u
X5381 BAT GATE DVDD DVDD pfet_06v0 ad=35.511p pd=48.245u as=35.511p ps=48.245u w=46.725u l=1u
X5382 BAT GATE DVDD DVDD pfet_06v0 ad=35.511p pd=48.245u as=43.9215p ps=95.32999u w=46.725u l=1u
X5383 BAT GATE DVDD DVDD pfet_06v0 ad=58.1552p pd=78.04u as=58.1552p ps=78.04u w=76.52u l=1u
X5384 DVDD GATE BAT DVDD pfet_06v0 ad=58.1134p pd=77.985u as=58.1134p ps=77.985u w=76.465u l=1u
X5385 DVDD GATE BAT DVDD pfet_06v0 ad=35.511p pd=48.245u as=35.511p ps=48.245u w=46.725u l=1u
X5386 DVDD GATE BAT DVDD pfet_06v0 ad=43.9215p pd=95.32999u as=35.511p ps=48.245u w=46.725u l=1u
X5387 DVDD GATE BAT DVDD pfet_06v0 ad=47.6862p pd=64.265u as=47.6862p ps=64.265u w=62.745u l=1u
X5388 BAT GATE DVDD DVDD pfet_06v0 ad=58.1134p pd=77.985u as=71.8771p ps=0.15481m w=76.465u l=1u
X5389 BAT GATE DVDD DVDD pfet_06v0 ad=35.511p pd=48.245u as=35.511p ps=48.245u w=46.725u l=1u
X5390 BAT GATE DVDD DVDD pfet_06v0 ad=35.511p pd=48.245u as=43.9215p ps=95.32999u w=46.725u l=1u
X5391 BAT GATE DVDD DVDD pfet_06v0 ad=35.511p pd=48.245u as=35.511p ps=48.245u w=46.725u l=1u
X5392 DVDD GATE BAT DVDD pfet_06v0 ad=71.8301p pd=0.15471m as=58.0754p ps=77.935u w=76.41499u l=1u
X5393 BAT GATE DVDD DVDD pfet_06v0 ad=35.511p pd=48.245u as=35.511p ps=48.245u w=46.725u l=1u
X5394 DVDD GATE BAT DVDD pfet_06v0 ad=58.1134p pd=77.985u as=58.1134p ps=77.985u w=76.465u l=1u
X5395 BAT GATE DVDD DVDD pfet_06v0 ad=58.0754p pd=77.935u as=58.0754p ps=77.935u w=76.41499u l=1u
X5396 BAT GATE DVDD DVDD pfet_06v0 ad=58.1134p pd=77.985u as=58.1134p ps=77.985u w=76.465u l=1u
X5397 DVDD GATE BAT DVDD pfet_06v0 ad=71.8771p pd=0.15481m as=58.1134p ps=77.985u w=76.465u l=1u
X5398 DVDD GATE BAT DVDD pfet_06v0 ad=35.511p pd=48.245u as=35.511p ps=48.245u w=46.725u l=1u
X5399 BAT GATE DVDD DVDD pfet_06v0 ad=58.1134p pd=77.985u as=58.1134p ps=77.985u w=76.465u l=1u
X5400 BAT GATE DVDD DVDD pfet_06v0 ad=47.6862p pd=64.265u as=47.6862p ps=64.265u w=62.745u l=1u
X5401 DVDD GATE BAT DVDD pfet_06v0 ad=58.1134p pd=77.985u as=58.1134p ps=77.985u w=76.465u l=1u
X5402 BAT GATE DVDD DVDD pfet_06v0 ad=58.1134p pd=77.985u as=58.1134p ps=77.985u w=76.465u l=1u
X5403 BAT GATE DVDD DVDD pfet_06v0 ad=58.1134p pd=77.985u as=58.1134p ps=77.985u w=76.465u l=1u
X5404 DVDD GATE BAT DVDD pfet_06v0 ad=47.6862p pd=64.265u as=47.6862p ps=64.265u w=62.745u l=1u
X5405 BAT GATE DVDD DVDD pfet_06v0 ad=35.511p pd=48.245u as=35.511p ps=48.245u w=46.725u l=1u
X5406 DVDD GATE BAT DVDD pfet_06v0 ad=58.1172p pd=77.99u as=58.1172p ps=77.99u w=76.47u l=1u
X5407 BAT GATE DVDD DVDD pfet_06v0 ad=49.3848p pd=66.5u as=61.0812p ps=0.13184m w=64.98u l=1u
X5408 DVDD GATE BAT DVDD pfet_06v0 ad=35.511p pd=48.245u as=35.511p ps=48.245u w=46.725u l=1u
X5409 DVDD GATE BAT DVDD pfet_06v0 ad=35.5072p pd=48.24u as=35.5072p ps=48.24u w=46.72u l=1u
X5410 DVDD GATE BAT DVDD pfet_06v0 ad=43.9168p pd=95.32u as=35.5072p ps=48.24u w=46.72u l=1u
X5411 BAT GATE DVDD DVDD pfet_06v0 ad=47.6862p pd=64.265u as=47.6862p ps=64.265u w=62.745u l=1u
X5412 DVDD GATE BAT DVDD pfet_06v0 ad=35.511p pd=48.245u as=35.511p ps=48.245u w=46.725u l=1u
X5413 DVDD GATE BAT DVDD pfet_06v0 ad=47.6862p pd=64.265u as=47.6862p ps=64.265u w=62.745u l=1u
X5414 DVDD GATE BAT DVDD pfet_06v0 ad=58.1134p pd=77.985u as=58.1134p ps=77.985u w=76.465u l=1u
X5415 BAT GATE DVDD DVDD pfet_06v0 ad=58.0754p pd=77.935u as=71.8301p ps=0.15471m w=76.41499u l=1u
X5416 BAT GATE DVDD DVDD pfet_06v0 ad=58.1096p pd=77.98u as=58.1096p ps=77.98u w=76.46u l=1u
X5417 DVDD GATE BAT DVDD pfet_06v0 ad=58.1134p pd=77.985u as=58.1134p ps=77.985u w=76.465u l=1u
X5418 DVDD GATE BAT DVDD pfet_06v0 ad=35.511p pd=48.245u as=35.511p ps=48.245u w=46.725u l=1u
X5419 DVDD GATE BAT DVDD pfet_06v0 ad=71.92879p pd=0.15492m as=58.1552p ps=78.04u w=76.52u l=1u
X5420 BAT GATE DVDD DVDD pfet_06v0 ad=58.0754p pd=77.935u as=58.0754p ps=77.935u w=76.41499u l=1u
X5421 DVDD GATE BAT DVDD pfet_06v0 ad=35.511p pd=48.245u as=35.511p ps=48.245u w=46.725u l=1u
X5422 DVDD GATE BAT DVDD pfet_06v0 ad=35.511p pd=48.245u as=35.511p ps=48.245u w=46.725u l=1u
X5423 DVDD GATE BAT DVDD pfet_06v0 ad=43.9215p pd=95.32999u as=35.511p ps=48.245u w=46.725u l=1u
X5424 DVDD GATE BAT DVDD pfet_06v0 ad=35.511p pd=48.245u as=35.511p ps=48.245u w=46.725u l=1u
X5425 BAT GATE DVDD DVDD pfet_06v0 ad=35.511p pd=48.245u as=35.511p ps=48.245u w=46.725u l=1u
X5426 DVDD GATE BAT DVDD pfet_06v0 ad=58.1552p pd=78.04u as=58.1552p ps=78.04u w=76.52u l=1u
X5427 BAT GATE DVDD DVDD pfet_06v0 ad=58.1134p pd=77.985u as=58.1134p ps=77.985u w=76.465u l=1u
X5428 DVDD GATE BAT DVDD pfet_06v0 ad=35.511p pd=48.245u as=35.511p ps=48.245u w=46.725u l=1u
X5429 DVDD GATE BAT DVDD pfet_06v0 ad=71.8771p pd=0.15481m as=58.1134p ps=77.985u w=76.465u l=1u
X5430 BAT GATE DVDD DVDD pfet_06v0 ad=58.1134p pd=77.985u as=58.1134p ps=77.985u w=76.465u l=1u
X5431 DVDD GATE BAT DVDD pfet_06v0 ad=71.8771p pd=0.15481m as=58.1134p ps=77.985u w=76.465u l=1u
X5432 DVDD GATE BAT DVDD pfet_06v0 ad=47.6862p pd=64.265u as=47.6862p ps=64.265u w=62.745u l=1u
X5433 DVDD GATE BAT DVDD pfet_06v0 ad=47.6862p pd=64.265u as=47.6862p ps=64.265u w=62.745u l=1u
X5434 DVDD GATE BAT DVDD pfet_06v0 ad=58.1134p pd=77.985u as=58.1134p ps=77.985u w=76.465u l=1u
X5435 BAT GATE DVDD DVDD pfet_06v0 ad=35.511p pd=48.245u as=43.9215p ps=95.32999u w=46.725u l=1u
X5436 BAT GATE DVDD DVDD pfet_06v0 ad=35.511p pd=48.245u as=35.511p ps=48.245u w=46.725u l=1u
X5437 DVDD GATE BAT DVDD pfet_06v0 ad=43.9215p pd=95.32999u as=35.511p ps=48.245u w=46.725u l=1u
X5438 BAT GATE DVDD DVDD pfet_06v0 ad=58.1134p pd=77.985u as=58.1134p ps=77.985u w=76.465u l=1u
X5439 BAT GATE DVDD DVDD pfet_06v0 ad=58.1134p pd=77.985u as=58.1134p ps=77.985u w=76.465u l=1u
X5440 DVDD GATE BAT DVDD pfet_06v0 ad=58.1134p pd=77.985u as=58.1134p ps=77.985u w=76.465u l=1u
X5441 DVDD GATE BAT DVDD pfet_06v0 ad=49.3848p pd=66.5u as=49.3848p ps=66.5u w=64.98u l=1u
X5442 BAT GATE DVDD DVDD pfet_06v0 ad=35.511p pd=48.245u as=35.511p ps=48.245u w=46.725u l=1u
X5443 BAT GATE DVDD DVDD pfet_06v0 ad=58.1172p pd=77.99u as=58.1172p ps=77.99u w=76.47u l=1u
X5444 DVDD GATE BAT DVDD pfet_06v0 ad=43.9215p pd=95.32999u as=35.511p ps=48.245u w=46.725u l=1u
X5445 DVDD GATE BAT DVDD pfet_06v0 ad=35.511p pd=48.245u as=35.511p ps=48.245u w=46.725u l=1u
X5446 DVDD GATE BAT DVDD pfet_06v0 ad=35.511p pd=48.245u as=35.511p ps=48.245u w=46.725u l=1u
X5447 BAT GATE DVDD DVDD pfet_06v0 ad=58.1552p pd=78.04u as=58.1552p ps=78.04u w=76.52u l=1u
X5448 BAT GATE DVDD DVDD pfet_06v0 ad=58.1096p pd=77.98u as=71.8724p ps=0.1548m w=76.46u l=1u
X5449 BAT GATE DVDD DVDD pfet_06v0 ad=58.1134p pd=77.985u as=58.1134p ps=77.985u w=76.465u l=1u
X5450 BAT GATE DVDD DVDD pfet_06v0 ad=58.1134p pd=77.985u as=58.1134p ps=77.985u w=76.465u l=1u
X5451 DVDD GATE BAT DVDD pfet_06v0 ad=43.9215p pd=95.32999u as=35.511p ps=48.245u w=46.725u l=1u
X5452 DVDD GATE BAT DVDD pfet_06v0 ad=58.1134p pd=77.985u as=58.1134p ps=77.985u w=76.465u l=1u
X5453 DVDD GATE BAT DVDD pfet_06v0 ad=35.511p pd=48.245u as=35.511p ps=48.245u w=46.725u l=1u
X5454 DVDD GATE BAT DVDD pfet_06v0 ad=43.9215p pd=95.32999u as=35.511p ps=48.245u w=46.725u l=1u
X5455 DVDD GATE BAT DVDD pfet_06v0 ad=35.5072p pd=48.24u as=35.5072p ps=48.24u w=46.72u l=1u
X5456 BAT GATE DVDD DVDD pfet_06v0 ad=35.511p pd=48.245u as=35.511p ps=48.245u w=46.725u l=1u
X5457 BAT GATE DVDD DVDD pfet_06v0 ad=58.1096p pd=77.98u as=58.1096p ps=77.98u w=76.46u l=1u
X5458 BAT GATE DVDD DVDD pfet_06v0 ad=35.511p pd=48.245u as=35.511p ps=48.245u w=46.725u l=1u
X5459 BAT GATE DVDD DVDD pfet_06v0 ad=58.1134p pd=77.985u as=58.1134p ps=77.985u w=76.465u l=1u
X5460 BAT GATE DVDD DVDD pfet_06v0 ad=35.511p pd=48.245u as=35.511p ps=48.245u w=46.725u l=1u
X5461 BAT GATE DVDD DVDD pfet_06v0 ad=35.511p pd=48.245u as=35.511p ps=48.245u w=46.725u l=1u
X5462 DVDD GATE BAT DVDD pfet_06v0 ad=35.511p pd=48.245u as=35.511p ps=48.245u w=46.725u l=1u
X5463 DVDD GATE BAT DVDD pfet_06v0 ad=35.511p pd=48.245u as=35.511p ps=48.245u w=46.725u l=1u
X5464 DVDD GATE BAT DVDD pfet_06v0 ad=58.1134p pd=77.985u as=58.1134p ps=77.985u w=76.465u l=1u
X5465 BAT GATE DVDD DVDD pfet_06v0 ad=35.5072p pd=48.24u as=43.9168p ps=95.32u w=46.72u l=1u
X5466 DVDD GATE BAT DVDD pfet_06v0 ad=71.8771p pd=0.15481m as=58.1134p ps=77.985u w=76.465u l=1u
X5467 DVDD GATE BAT DVDD pfet_06v0 ad=58.1134p pd=77.985u as=58.1134p ps=77.985u w=76.465u l=1u
X5468 DVDD GATE BAT DVDD pfet_06v0 ad=71.8771p pd=0.15481m as=58.1134p ps=77.985u w=76.465u l=1u
X5469 BAT GATE DVDD DVDD pfet_06v0 ad=35.511p pd=48.245u as=35.511p ps=48.245u w=46.725u l=1u
X5470 BAT GATE DVDD DVDD pfet_06v0 ad=35.511p pd=48.245u as=35.511p ps=48.245u w=46.725u l=1u
X5471 DVDD GATE BAT DVDD pfet_06v0 ad=43.9215p pd=95.32999u as=35.511p ps=48.245u w=46.725u l=1u
X5472 DVDD GATE BAT DVDD pfet_06v0 ad=35.511p pd=48.245u as=35.511p ps=48.245u w=46.725u l=1u
X5473 BAT GATE DVDD DVDD pfet_06v0 ad=58.1134p pd=77.985u as=58.1134p ps=77.985u w=76.465u l=1u
X5474 DVDD GATE BAT DVDD pfet_06v0 ad=49.3848p pd=66.5u as=49.3848p ps=66.5u w=64.98u l=1u
X5475 DVDD GATE BAT DVDD pfet_06v0 ad=35.511p pd=48.245u as=35.511p ps=48.245u w=46.725u l=1u
X5476 BAT GATE DVDD DVDD pfet_06v0 ad=35.5072p pd=48.24u as=35.5072p ps=48.24u w=46.72u l=1u
X5477 BAT GATE DVDD DVDD pfet_06v0 ad=49.3848p pd=66.5u as=49.3848p ps=66.5u w=64.98u l=1u
X5478 DVDD GATE BAT DVDD pfet_06v0 ad=35.511p pd=48.245u as=35.511p ps=48.245u w=46.725u l=1u
X5479 DVDD GATE BAT DVDD pfet_06v0 ad=58.9803p pd=0.12737m as=47.6862p ps=64.265u w=62.745u l=1u
X5480 DVDD GATE BAT DVDD pfet_06v0 ad=43.9215p pd=95.32999u as=35.511p ps=48.245u w=46.725u l=1u
X5481 DVDD GATE BAT DVDD pfet_06v0 ad=58.1134p pd=77.985u as=58.1134p ps=77.985u w=76.465u l=1u
X5482 BAT GATE DVDD DVDD pfet_06v0 ad=58.1096p pd=77.98u as=58.1096p ps=77.98u w=76.46u l=1u
X5483 DVDD GATE BAT DVDD pfet_06v0 ad=35.511p pd=48.245u as=35.511p ps=48.245u w=46.725u l=1u
X5484 DVDD GATE BAT DVDD pfet_06v0 ad=71.8771p pd=0.15481m as=58.1134p ps=77.985u w=76.465u l=1u
X5485 BAT GATE DVDD DVDD pfet_06v0 ad=58.1096p pd=77.98u as=71.8724p ps=0.1548m w=76.46u l=1u
X5486 BAT GATE DVDD DVDD pfet_06v0 ad=49.3848p pd=66.5u as=49.3848p ps=66.5u w=64.98u l=1u
X5487 BAT GATE DVDD DVDD pfet_06v0 ad=35.511p pd=48.245u as=43.9215p ps=95.32999u w=46.725u l=1u
X5488 BAT GATE DVDD DVDD pfet_06v0 ad=58.1134p pd=77.985u as=58.1134p ps=77.985u w=76.465u l=1u
X5489 DVDD GATE BAT DVDD pfet_06v0 ad=35.5072p pd=48.24u as=35.5072p ps=48.24u w=46.72u l=1u
X5490 BAT GATE DVDD DVDD pfet_06v0 ad=58.1552p pd=78.04u as=71.92879p ps=0.15492m w=76.52u l=1u
X5491 DVDD GATE BAT DVDD pfet_06v0 ad=35.511p pd=48.245u as=35.511p ps=48.245u w=46.725u l=1u
X5492 BAT GATE DVDD DVDD pfet_06v0 ad=35.511p pd=48.245u as=43.9215p ps=95.32999u w=46.725u l=1u
X5493 DVDD GATE BAT DVDD pfet_06v0 ad=71.8301p pd=0.15471m as=58.0754p ps=77.935u w=76.41499u l=1u
X5494 BAT GATE DVDD DVDD pfet_06v0 ad=58.1134p pd=77.985u as=58.1134p ps=77.985u w=76.465u l=1u
X5495 DVDD GATE BAT DVDD pfet_06v0 ad=58.0754p pd=77.935u as=58.0754p ps=77.935u w=76.41499u l=1u
X5496 BAT GATE DVDD DVDD pfet_06v0 ad=58.1134p pd=77.985u as=71.8771p ps=0.15481m w=76.465u l=1u
X5497 DVDD GATE BAT DVDD pfet_06v0 ad=58.1134p pd=77.985u as=58.1134p ps=77.985u w=76.465u l=1u
X5498 BAT GATE DVDD DVDD pfet_06v0 ad=47.6862p pd=64.265u as=47.6862p ps=64.265u w=62.745u l=1u
X5499 BAT GATE DVDD DVDD pfet_06v0 ad=58.1134p pd=77.985u as=71.8771p ps=0.15481m w=76.465u l=1u
X5500 BAT GATE DVDD DVDD pfet_06v0 ad=35.5072p pd=48.24u as=43.9168p ps=95.32u w=46.72u l=1u
X5501 BAT GATE DVDD DVDD pfet_06v0 ad=35.511p pd=48.245u as=35.511p ps=48.245u w=46.725u l=1u
X5502 BAT GATE DVDD DVDD pfet_06v0 ad=58.0754p pd=77.935u as=58.0754p ps=77.935u w=76.41499u l=1u
X5503 DVDD GATE BAT DVDD pfet_06v0 ad=35.511p pd=48.245u as=35.511p ps=48.245u w=46.725u l=1u
X5504 BAT GATE DVDD DVDD pfet_06v0 ad=58.1134p pd=77.985u as=58.1134p ps=77.985u w=76.465u l=1u
X5505 BAT GATE DVDD DVDD pfet_06v0 ad=58.1134p pd=77.985u as=58.1134p ps=77.985u w=76.465u l=1u
X5506 DVDD GATE BAT DVDD pfet_06v0 ad=58.1134p pd=77.985u as=58.1134p ps=77.985u w=76.465u l=1u
X5507 BAT GATE DVDD DVDD pfet_06v0 ad=35.511p pd=48.245u as=43.9215p ps=95.32999u w=46.725u l=1u
X5508 DVDD GATE BAT DVDD pfet_06v0 ad=58.1134p pd=77.985u as=58.1134p ps=77.985u w=76.465u l=1u
X5509 DVDD GATE BAT DVDD pfet_06v0 ad=71.8771p pd=0.15481m as=58.1134p ps=77.985u w=76.465u l=1u
X5510 DVDD GATE BAT DVDD pfet_06v0 ad=47.6862p pd=64.265u as=47.6862p ps=64.265u w=62.745u l=1u
X5511 BAT GATE DVDD DVDD pfet_06v0 ad=35.511p pd=48.245u as=35.511p ps=48.245u w=46.725u l=1u
X5512 DVDD GATE BAT DVDD pfet_06v0 ad=58.1134p pd=77.985u as=58.1134p ps=77.985u w=76.465u l=1u
X5513 BAT GATE DVDD DVDD pfet_06v0 ad=47.6862p pd=64.265u as=58.9803p ps=0.12737m w=62.745u l=1u
X5514 BAT GATE DVDD DVDD pfet_06v0 ad=49.3848p pd=66.5u as=49.3848p ps=66.5u w=64.98u l=1u
X5515 DVDD GATE BAT DVDD pfet_06v0 ad=35.511p pd=48.245u as=35.511p ps=48.245u w=46.725u l=1u
X5516 BAT GATE DVDD DVDD pfet_06v0 ad=58.1134p pd=77.985u as=58.1134p ps=77.985u w=76.465u l=1u
X5517 BAT GATE DVDD DVDD pfet_06v0 ad=58.1172p pd=77.99u as=58.1172p ps=77.99u w=76.47u l=1u
X5518 DVDD GATE BAT DVDD pfet_06v0 ad=43.9215p pd=95.32999u as=35.511p ps=48.245u w=46.725u l=1u
X5519 DVDD GATE BAT DVDD pfet_06v0 ad=58.1134p pd=77.985u as=58.1134p ps=77.985u w=76.465u l=1u
X5520 DVDD GATE BAT DVDD pfet_06v0 ad=58.1096p pd=77.98u as=58.1096p ps=77.98u w=76.46u l=1u
X5521 BAT GATE DVDD DVDD pfet_06v0 ad=35.5072p pd=48.24u as=35.5072p ps=48.24u w=46.72u l=1u
X5522 BAT GATE DVDD DVDD pfet_06v0 ad=35.5072p pd=48.24u as=35.5072p ps=48.24u w=46.72u l=1u
X5523 DVDD GATE BAT DVDD pfet_06v0 ad=58.1096p pd=77.98u as=58.1096p ps=77.98u w=76.46u l=1u
X5524 BAT GATE DVDD DVDD pfet_06v0 ad=47.6862p pd=64.265u as=47.6862p ps=64.265u w=62.745u l=1u
X5525 DVDD GATE BAT DVDD pfet_06v0 ad=35.511p pd=48.245u as=35.511p ps=48.245u w=46.725u l=1u
X5526 DVDD GATE BAT DVDD pfet_06v0 ad=58.1134p pd=77.985u as=58.1134p ps=77.985u w=76.465u l=1u
X5527 DVDD GATE BAT DVDD pfet_06v0 ad=35.5072p pd=48.24u as=35.5072p ps=48.24u w=46.72u l=1u
X5528 BAT GATE DVDD DVDD pfet_06v0 ad=58.1172p pd=77.99u as=58.1172p ps=77.99u w=76.47u l=1u
X5529 DVDD GATE BAT DVDD pfet_06v0 ad=58.1134p pd=77.985u as=58.1134p ps=77.985u w=76.465u l=1u
X5530 DVDD GATE BAT DVDD pfet_06v0 ad=35.5072p pd=48.24u as=35.5072p ps=48.24u w=46.72u l=1u
X5531 BAT GATE DVDD DVDD pfet_06v0 ad=35.511p pd=48.245u as=35.511p ps=48.245u w=46.725u l=1u
X5532 BAT GATE DVDD DVDD pfet_06v0 ad=35.511p pd=48.245u as=43.9215p ps=95.32999u w=46.725u l=1u
X5533 BAT GATE DVDD DVDD pfet_06v0 ad=47.6862p pd=64.265u as=47.6862p ps=64.265u w=62.745u l=1u
X5534 BAT GATE DVDD DVDD pfet_06v0 ad=58.1134p pd=77.985u as=58.1134p ps=77.985u w=76.465u l=1u
X5535 BAT GATE DVDD DVDD pfet_06v0 ad=58.1096p pd=77.98u as=71.8724p ps=0.1548m w=76.46u l=1u
X5536 BAT GATE DVDD DVDD pfet_06v0 ad=47.6862p pd=64.265u as=47.6862p ps=64.265u w=62.745u l=1u
X5537 BAT GATE DVDD DVDD pfet_06v0 ad=58.1134p pd=77.985u as=58.1134p ps=77.985u w=76.465u l=1u
X5538 DVDD GATE BAT DVDD pfet_06v0 ad=58.1172p pd=77.99u as=58.1172p ps=77.99u w=76.47u l=1u
X5539 BAT GATE DVDD DVDD pfet_06v0 ad=35.511p pd=48.245u as=35.511p ps=48.245u w=46.725u l=1u
X5540 BAT GATE DVDD DVDD pfet_06v0 ad=35.511p pd=48.245u as=35.511p ps=48.245u w=46.725u l=1u
X5541 BAT GATE DVDD DVDD pfet_06v0 ad=58.1134p pd=77.985u as=58.1134p ps=77.985u w=76.465u l=1u
X5542 DVDD GATE BAT DVDD pfet_06v0 ad=35.511p pd=48.245u as=35.511p ps=48.245u w=46.725u l=1u
X5543 BAT GATE DVDD DVDD pfet_06v0 ad=58.1134p pd=77.985u as=58.1134p ps=77.985u w=76.465u l=1u
X5544 DVDD GATE BAT DVDD pfet_06v0 ad=43.9215p pd=95.32999u as=35.511p ps=48.245u w=46.725u l=1u
X5545 DVDD GATE BAT DVDD pfet_06v0 ad=35.511p pd=48.245u as=35.511p ps=48.245u w=46.725u l=1u
X5546 BAT GATE DVDD DVDD pfet_06v0 ad=58.1134p pd=77.985u as=58.1134p ps=77.985u w=76.465u l=1u
X5547 BAT GATE DVDD DVDD pfet_06v0 ad=35.511p pd=48.245u as=35.511p ps=48.245u w=46.725u l=1u
X5548 BAT GATE DVDD DVDD pfet_06v0 ad=58.1134p pd=77.985u as=58.1134p ps=77.985u w=76.465u l=1u
X5549 DVDD GATE BAT DVDD pfet_06v0 ad=71.8771p pd=0.15481m as=58.1134p ps=77.985u w=76.465u l=1u
X5550 DVDD GATE BAT DVDD pfet_06v0 ad=43.9215p pd=95.32999u as=35.511p ps=48.245u w=46.725u l=1u
X5551 BAT GATE DVDD DVDD pfet_06v0 ad=35.511p pd=48.245u as=35.511p ps=48.245u w=46.725u l=1u
X5552 DVDD GATE BAT DVDD pfet_06v0 ad=58.1134p pd=77.985u as=58.1134p ps=77.985u w=76.465u l=1u
X5553 DVDD GATE BAT DVDD pfet_06v0 ad=58.1096p pd=77.98u as=58.1096p ps=77.98u w=76.46u l=1u
X5554 DVDD GATE BAT DVDD pfet_06v0 ad=58.1134p pd=77.985u as=58.1134p ps=77.985u w=76.465u l=1u
X5555 DVDD GATE BAT DVDD pfet_06v0 ad=58.1134p pd=77.985u as=58.1134p ps=77.985u w=76.465u l=1u
X5556 BAT GATE DVDD DVDD pfet_06v0 ad=58.0754p pd=77.935u as=58.0754p ps=77.935u w=76.41499u l=1u
X5557 BAT GATE DVDD DVDD pfet_06v0 ad=35.511p pd=48.245u as=35.511p ps=48.245u w=46.725u l=1u
X5558 DVDD GATE BAT DVDD pfet_06v0 ad=71.8771p pd=0.15481m as=58.1134p ps=77.985u w=76.465u l=1u
X5559 DVDD GATE BAT DVDD pfet_06v0 ad=35.511p pd=48.245u as=35.511p ps=48.245u w=46.725u l=1u
X5560 DVDD GATE BAT DVDD pfet_06v0 ad=35.511p pd=48.245u as=35.511p ps=48.245u w=46.725u l=1u
X5561 DVDD GATE BAT DVDD pfet_06v0 ad=35.511p pd=48.245u as=35.511p ps=48.245u w=46.725u l=1u
X5562 BAT GATE DVDD DVDD pfet_06v0 ad=58.1134p pd=77.985u as=58.1134p ps=77.985u w=76.465u l=1u
X5563 DVDD GATE BAT DVDD pfet_06v0 ad=35.511p pd=48.245u as=35.511p ps=48.245u w=46.725u l=1u
X5564 BAT GATE DVDD DVDD pfet_06v0 ad=35.511p pd=48.245u as=43.9215p ps=95.32999u w=46.725u l=1u
X5565 BAT GATE DVDD DVDD pfet_06v0 ad=58.1172p pd=77.99u as=58.1172p ps=77.99u w=76.47u l=1u
X5566 BAT GATE DVDD DVDD pfet_06v0 ad=35.511p pd=48.245u as=35.511p ps=48.245u w=46.725u l=1u
X5567 DVDD GATE BAT DVDD pfet_06v0 ad=35.511p pd=48.245u as=35.511p ps=48.245u w=46.725u l=1u
X5568 DVDD GATE BAT DVDD pfet_06v0 ad=43.9215p pd=95.32999u as=35.511p ps=48.245u w=46.725u l=1u
X5569 DVDD GATE BAT DVDD pfet_06v0 ad=35.511p pd=48.245u as=35.511p ps=48.245u w=46.725u l=1u
X5570 DVDD GATE BAT DVDD pfet_06v0 ad=35.5072p pd=48.24u as=35.5072p ps=48.24u w=46.72u l=1u
X5571 DVDD GATE BAT DVDD pfet_06v0 ad=58.9803p pd=0.12737m as=47.6862p ps=64.265u w=62.745u l=1u
X5572 DVDD GATE BAT DVDD pfet_06v0 ad=35.511p pd=48.245u as=35.511p ps=48.245u w=46.725u l=1u
X5573 BAT GATE DVDD DVDD pfet_06v0 ad=35.511p pd=48.245u as=35.511p ps=48.245u w=46.725u l=1u
X5574 DVDD GATE BAT DVDD pfet_06v0 ad=35.511p pd=48.245u as=35.511p ps=48.245u w=46.725u l=1u
X5575 BAT GATE DVDD DVDD pfet_06v0 ad=58.1134p pd=77.985u as=58.1134p ps=77.985u w=76.465u l=1u
X5576 BAT GATE DVDD DVDD pfet_06v0 ad=35.511p pd=48.245u as=35.511p ps=48.245u w=46.725u l=1u
X5577 DVDD GATE BAT DVDD pfet_06v0 ad=35.511p pd=48.245u as=35.511p ps=48.245u w=46.725u l=1u
X5578 BAT GATE DVDD DVDD pfet_06v0 ad=58.1134p pd=77.985u as=58.1134p ps=77.985u w=76.465u l=1u
X5579 DVDD GATE BAT DVDD pfet_06v0 ad=58.1096p pd=77.98u as=58.1096p ps=77.98u w=76.46u l=1u
X5580 BAT GATE DVDD DVDD pfet_06v0 ad=58.1134p pd=77.985u as=58.1134p ps=77.985u w=76.465u l=1u
X5581 BAT GATE DVDD DVDD pfet_06v0 ad=35.511p pd=48.245u as=43.9215p ps=95.32999u w=46.725u l=1u
X5582 BAT GATE DVDD DVDD pfet_06v0 ad=58.1134p pd=77.985u as=58.1134p ps=77.985u w=76.465u l=1u
X5583 DVDD GATE BAT DVDD pfet_06v0 ad=71.8771p pd=0.15481m as=58.1134p ps=77.985u w=76.465u l=1u
X5584 BAT GATE DVDD DVDD pfet_06v0 ad=58.1096p pd=77.98u as=58.1096p ps=77.98u w=76.46u l=1u
X5585 BAT GATE DVDD DVDD pfet_06v0 ad=35.511p pd=48.245u as=43.9215p ps=95.32999u w=46.725u l=1u
X5586 DVDD GATE BAT DVDD pfet_06v0 ad=58.1134p pd=77.985u as=58.1134p ps=77.985u w=76.465u l=1u
X5587 BAT GATE DVDD DVDD pfet_06v0 ad=35.511p pd=48.245u as=35.511p ps=48.245u w=46.725u l=1u
X5588 BAT GATE DVDD DVDD pfet_06v0 ad=58.1552p pd=78.04u as=58.1552p ps=78.04u w=76.52u l=1u
X5589 DVDD GATE BAT DVDD pfet_06v0 ad=47.6862p pd=64.265u as=47.6862p ps=64.265u w=62.745u l=1u
X5590 DVDD GATE BAT DVDD pfet_06v0 ad=58.1134p pd=77.985u as=58.1134p ps=77.985u w=76.465u l=1u
X5591 BAT GATE DVDD DVDD pfet_06v0 ad=58.1134p pd=77.985u as=58.1134p ps=77.985u w=76.465u l=1u
X5592 DVDD GATE BAT DVDD pfet_06v0 ad=71.8771p pd=0.15481m as=58.1134p ps=77.985u w=76.465u l=1u
X5593 BAT GATE DVDD DVDD pfet_06v0 ad=49.3848p pd=66.5u as=49.3848p ps=66.5u w=64.98u l=1u
X5594 BAT GATE DVDD DVDD pfet_06v0 ad=35.511p pd=48.245u as=35.511p ps=48.245u w=46.725u l=1u
X5595 BAT GATE DVDD DVDD pfet_06v0 ad=35.511p pd=48.245u as=35.511p ps=48.245u w=46.725u l=1u
X5596 BAT GATE DVDD DVDD pfet_06v0 ad=58.1134p pd=77.985u as=58.1134p ps=77.985u w=76.465u l=1u
X5597 DVDD GATE BAT DVDD pfet_06v0 ad=58.1134p pd=77.985u as=58.1134p ps=77.985u w=76.465u l=1u
X5598 DVDD GATE BAT DVDD pfet_06v0 ad=58.1134p pd=77.985u as=58.1134p ps=77.985u w=76.465u l=1u
X5599 DVDD GATE BAT DVDD pfet_06v0 ad=58.1134p pd=77.985u as=58.1134p ps=77.985u w=76.465u l=1u
X5600 BAT GATE DVDD DVDD pfet_06v0 ad=35.511p pd=48.245u as=35.511p ps=48.245u w=46.725u l=1u
X5601 BAT GATE DVDD DVDD pfet_06v0 ad=35.511p pd=48.245u as=35.511p ps=48.245u w=46.725u l=1u
X5602 BAT GATE DVDD DVDD pfet_06v0 ad=58.1134p pd=77.985u as=71.8771p ps=0.15481m w=76.465u l=1u
X5603 BAT GATE DVDD DVDD pfet_06v0 ad=58.1134p pd=77.985u as=71.8771p ps=0.15481m w=76.465u l=1u
X5604 DVDD GATE BAT DVDD pfet_06v0 ad=35.511p pd=48.245u as=35.511p ps=48.245u w=46.725u l=1u
X5605 BAT GATE DVDD DVDD pfet_06v0 ad=58.1134p pd=77.985u as=58.1134p ps=77.985u w=76.465u l=1u
X5606 DVDD GATE BAT DVDD pfet_06v0 ad=35.511p pd=48.245u as=35.511p ps=48.245u w=46.725u l=1u
X5607 DVDD GATE BAT DVDD pfet_06v0 ad=43.9215p pd=95.32999u as=35.511p ps=48.245u w=46.725u l=1u
X5608 BAT GATE DVDD DVDD pfet_06v0 ad=58.1134p pd=77.985u as=58.1134p ps=77.985u w=76.465u l=1u
X5609 BAT GATE DVDD DVDD pfet_06v0 ad=35.511p pd=48.245u as=35.511p ps=48.245u w=46.725u l=1u
X5610 BAT GATE DVDD DVDD pfet_06v0 ad=58.1134p pd=77.985u as=58.1134p ps=77.985u w=76.465u l=1u
X5611 DVDD GATE BAT DVDD pfet_06v0 ad=58.1096p pd=77.98u as=58.1096p ps=77.98u w=76.46u l=1u
X5612 DVDD GATE BAT DVDD pfet_06v0 ad=71.8724p pd=0.1548m as=58.1096p ps=77.98u w=76.46u l=1u
X5613 DVDD GATE BAT DVDD pfet_06v0 ad=49.3848p pd=66.5u as=49.3848p ps=66.5u w=64.98u l=1u
X5614 BAT GATE DVDD DVDD pfet_06v0 ad=47.6862p pd=64.265u as=47.6862p ps=64.265u w=62.745u l=1u
X5615 BAT GATE DVDD DVDD pfet_06v0 ad=58.1134p pd=77.985u as=71.8771p ps=0.15481m w=76.465u l=1u
X5616 BAT GATE DVDD DVDD pfet_06v0 ad=58.0754p pd=77.935u as=71.8301p ps=0.15471m w=76.41499u l=1u
X5617 DVDD GATE BAT DVDD pfet_06v0 ad=58.1552p pd=78.04u as=58.1552p ps=78.04u w=76.52u l=1u
X5618 BAT GATE DVDD DVDD pfet_06v0 ad=35.5072p pd=48.24u as=35.5072p ps=48.24u w=46.72u l=1u
X5619 BAT GATE DVDD DVDD pfet_06v0 ad=35.511p pd=48.245u as=35.511p ps=48.245u w=46.725u l=1u
X5620 DVDD GATE BAT DVDD pfet_06v0 ad=43.9168p pd=95.32u as=35.5072p ps=48.24u w=46.72u l=1u
X5621 DVDD GATE BAT DVDD pfet_06v0 ad=58.1134p pd=77.985u as=58.1134p ps=77.985u w=76.465u l=1u
X5622 BAT GATE DVDD DVDD pfet_06v0 ad=35.511p pd=48.245u as=35.511p ps=48.245u w=46.725u l=1u
X5623 DVDD GATE BAT DVDD pfet_06v0 ad=35.511p pd=48.245u as=35.511p ps=48.245u w=46.725u l=1u
X5624 BAT GATE DVDD DVDD pfet_06v0 ad=58.1134p pd=77.985u as=58.1134p ps=77.985u w=76.465u l=1u
X5625 DVDD GATE BAT DVDD pfet_06v0 ad=58.0754p pd=77.935u as=58.0754p ps=77.935u w=76.41499u l=1u
X5626 BAT GATE DVDD DVDD pfet_06v0 ad=58.1134p pd=77.985u as=58.1134p ps=77.985u w=76.465u l=1u
X5627 BAT GATE DVDD DVDD pfet_06v0 ad=58.1134p pd=77.985u as=58.1134p ps=77.985u w=76.465u l=1u
X5628 BAT GATE DVDD DVDD pfet_06v0 ad=47.6862p pd=64.265u as=58.9803p ps=0.12737m w=62.745u l=1u
X5629 DVDD GATE BAT DVDD pfet_06v0 ad=71.8771p pd=0.15481m as=58.1134p ps=77.985u w=76.465u l=1u
X5630 DVDD GATE BAT DVDD pfet_06v0 ad=35.511p pd=48.245u as=35.511p ps=48.245u w=46.725u l=1u
X5631 DVDD GATE BAT DVDD pfet_06v0 ad=58.1172p pd=77.99u as=58.1172p ps=77.99u w=76.47u l=1u
X5632 BAT GATE DVDD DVDD pfet_06v0 ad=58.1134p pd=77.985u as=58.1134p ps=77.985u w=76.465u l=1u
X5633 DVDD GATE BAT DVDD pfet_06v0 ad=58.1134p pd=77.985u as=58.1134p ps=77.985u w=76.465u l=1u
X5634 BAT GATE DVDD DVDD pfet_06v0 ad=35.511p pd=48.245u as=35.511p ps=48.245u w=46.725u l=1u
X5635 DVDD GATE BAT DVDD pfet_06v0 ad=58.1134p pd=77.985u as=58.1134p ps=77.985u w=76.465u l=1u
X5636 BAT GATE DVDD DVDD pfet_06v0 ad=58.1134p pd=77.985u as=58.1134p ps=77.985u w=76.465u l=1u
X5637 DVDD GATE BAT DVDD pfet_06v0 ad=58.1134p pd=77.985u as=58.1134p ps=77.985u w=76.465u l=1u
X5638 BAT GATE DVDD DVDD pfet_06v0 ad=35.511p pd=48.245u as=43.9215p ps=95.32999u w=46.725u l=1u
X5639 DVDD GATE BAT DVDD pfet_06v0 ad=58.1134p pd=77.985u as=58.1134p ps=77.985u w=76.465u l=1u
X5640 BAT GATE DVDD DVDD pfet_06v0 ad=49.3848p pd=66.5u as=49.3848p ps=66.5u w=64.98u l=1u
X5641 DVDD GATE BAT DVDD pfet_06v0 ad=58.1134p pd=77.985u as=58.1134p ps=77.985u w=76.465u l=1u
X5642 BAT GATE DVDD DVDD pfet_06v0 ad=58.1172p pd=77.99u as=58.1172p ps=77.99u w=76.47u l=1u
X5643 DVDD GATE BAT DVDD pfet_06v0 ad=35.511p pd=48.245u as=35.511p ps=48.245u w=46.725u l=1u
X5644 DVDD GATE BAT DVDD pfet_06v0 ad=71.8724p pd=0.1548m as=58.1096p ps=77.98u w=76.46u l=1u
X5645 BAT GATE DVDD DVDD pfet_06v0 ad=47.6862p pd=64.265u as=58.9803p ps=0.12737m w=62.745u l=1u
X5646 BAT GATE DVDD DVDD pfet_06v0 ad=35.511p pd=48.245u as=35.511p ps=48.245u w=46.725u l=1u
X5647 BAT GATE DVDD DVDD pfet_06v0 ad=35.511p pd=48.245u as=35.511p ps=48.245u w=46.725u l=1u
X5648 DVDD GATE BAT DVDD pfet_06v0 ad=58.1096p pd=77.98u as=58.1096p ps=77.98u w=76.46u l=1u
X5649 BAT GATE DVDD DVDD pfet_06v0 ad=58.1134p pd=77.985u as=58.1134p ps=77.985u w=76.465u l=1u
X5650 DVDD GATE BAT DVDD pfet_06v0 ad=58.0754p pd=77.935u as=58.0754p ps=77.935u w=76.41499u l=1u
X5651 BAT GATE DVDD DVDD pfet_06v0 ad=35.511p pd=48.245u as=35.511p ps=48.245u w=46.725u l=1u
X5652 BAT GATE DVDD DVDD pfet_06v0 ad=58.1552p pd=78.04u as=58.1552p ps=78.04u w=76.52u l=1u
X5653 BAT GATE DVDD DVDD pfet_06v0 ad=35.511p pd=48.245u as=43.9215p ps=95.32999u w=46.725u l=1u
X5654 BAT GATE DVDD DVDD pfet_06v0 ad=35.511p pd=48.245u as=35.511p ps=48.245u w=46.725u l=1u
X5655 DVDD GATE BAT DVDD pfet_06v0 ad=58.1134p pd=77.985u as=58.1134p ps=77.985u w=76.465u l=1u
X5656 BAT GATE DVDD DVDD pfet_06v0 ad=35.5072p pd=48.24u as=35.5072p ps=48.24u w=46.72u l=1u
X5657 DVDD GATE BAT DVDD pfet_06v0 ad=35.511p pd=48.245u as=35.511p ps=48.245u w=46.725u l=1u
X5658 BAT GATE DVDD DVDD pfet_06v0 ad=35.511p pd=48.245u as=35.511p ps=48.245u w=46.725u l=1u
X5659 BAT GATE DVDD DVDD pfet_06v0 ad=58.1134p pd=77.985u as=58.1134p ps=77.985u w=76.465u l=1u
X5660 BAT GATE DVDD DVDD pfet_06v0 ad=35.511p pd=48.245u as=35.511p ps=48.245u w=46.725u l=1u
X5661 DVDD GATE BAT DVDD pfet_06v0 ad=58.0754p pd=77.935u as=58.0754p ps=77.935u w=76.41499u l=1u
X5662 DVDD GATE BAT DVDD pfet_06v0 ad=43.9215p pd=95.32999u as=35.511p ps=48.245u w=46.725u l=1u
X5663 BAT GATE DVDD DVDD pfet_06v0 ad=58.1134p pd=77.985u as=58.1134p ps=77.985u w=76.465u l=1u
X5664 BAT GATE DVDD DVDD pfet_06v0 ad=58.1134p pd=77.985u as=58.1134p ps=77.985u w=76.465u l=1u
X5665 BAT GATE DVDD DVDD pfet_06v0 ad=58.1134p pd=77.985u as=58.1134p ps=77.985u w=76.465u l=1u
X5666 BAT GATE DVDD DVDD pfet_06v0 ad=35.511p pd=48.245u as=43.9215p ps=95.32999u w=46.725u l=1u
X5667 BAT GATE DVDD DVDD pfet_06v0 ad=35.511p pd=48.245u as=35.511p ps=48.245u w=46.725u l=1u
X5668 BAT GATE DVDD DVDD pfet_06v0 ad=35.511p pd=48.245u as=43.9215p ps=95.32999u w=46.725u l=1u
X5669 DVDD GATE BAT DVDD pfet_06v0 ad=43.9215p pd=95.32999u as=35.511p ps=48.245u w=46.725u l=1u
X5670 DVDD GATE BAT DVDD pfet_06v0 ad=58.1134p pd=77.985u as=58.1134p ps=77.985u w=76.465u l=1u
X5671 DVDD GATE BAT DVDD pfet_06v0 ad=58.1172p pd=77.99u as=58.1172p ps=77.99u w=76.47u l=1u
X5672 BAT GATE DVDD DVDD pfet_06v0 ad=58.1096p pd=77.98u as=58.1096p ps=77.98u w=76.46u l=1u
X5673 BAT GATE DVDD DVDD pfet_06v0 ad=58.1172p pd=77.99u as=71.8818p ps=0.15482m w=76.47u l=1u
X5674 BAT GATE DVDD DVDD pfet_06v0 ad=35.511p pd=48.245u as=35.511p ps=48.245u w=46.725u l=1u
X5675 BAT GATE DVDD DVDD pfet_06v0 ad=35.511p pd=48.245u as=43.9215p ps=95.32999u w=46.725u l=1u
X5676 DVDD GATE BAT DVDD pfet_06v0 ad=35.511p pd=48.245u as=35.511p ps=48.245u w=46.725u l=1u
X5677 BAT GATE DVDD DVDD pfet_06v0 ad=35.511p pd=48.245u as=35.511p ps=48.245u w=46.725u l=1u
X5678 BAT GATE DVDD DVDD pfet_06v0 ad=35.511p pd=48.245u as=43.9215p ps=95.32999u w=46.725u l=1u
X5679 DVDD GATE BAT DVDD pfet_06v0 ad=71.8771p pd=0.15481m as=58.1134p ps=77.985u w=76.465u l=1u
X5680 DVDD GATE BAT DVDD pfet_06v0 ad=58.1552p pd=78.04u as=58.1552p ps=78.04u w=76.52u l=1u
X5681 DVDD GATE BAT DVDD pfet_06v0 ad=58.1134p pd=77.985u as=58.1134p ps=77.985u w=76.465u l=1u
X5682 DVDD GATE BAT DVDD pfet_06v0 ad=58.1134p pd=77.985u as=58.1134p ps=77.985u w=76.465u l=1u
X5683 BAT GATE DVDD DVDD pfet_06v0 ad=35.511p pd=48.245u as=35.511p ps=48.245u w=46.725u l=1u
X5684 DVDD GATE BAT DVDD pfet_06v0 ad=58.1172p pd=77.99u as=58.1172p ps=77.99u w=76.47u l=1u
X5685 DVDD GATE BAT DVDD pfet_06v0 ad=35.511p pd=48.245u as=35.511p ps=48.245u w=46.725u l=1u
X5686 DVDD GATE BAT DVDD pfet_06v0 ad=58.1096p pd=77.98u as=58.1096p ps=77.98u w=76.46u l=1u
X5687 DVDD GATE BAT DVDD pfet_06v0 ad=58.1134p pd=77.985u as=58.1134p ps=77.985u w=76.465u l=1u
X5688 BAT GATE DVDD DVDD pfet_06v0 ad=58.1134p pd=77.985u as=71.8771p ps=0.15481m w=76.465u l=1u
X5689 DVDD GATE BAT DVDD pfet_06v0 ad=58.1552p pd=78.04u as=58.1552p ps=78.04u w=76.52u l=1u
X5690 BAT GATE DVDD DVDD pfet_06v0 ad=58.1134p pd=77.985u as=58.1134p ps=77.985u w=76.465u l=1u
X5691 BAT GATE DVDD DVDD pfet_06v0 ad=35.511p pd=48.245u as=35.511p ps=48.245u w=46.725u l=1u
X5692 BAT GATE DVDD DVDD pfet_06v0 ad=58.1552p pd=78.04u as=58.1552p ps=78.04u w=76.52u l=1u
X5693 DVDD GATE BAT DVDD pfet_06v0 ad=47.6862p pd=64.265u as=47.6862p ps=64.265u w=62.745u l=1u
X5694 DVDD GATE BAT DVDD pfet_06v0 ad=35.511p pd=48.245u as=35.511p ps=48.245u w=46.725u l=1u
X5695 DVDD GATE BAT DVDD pfet_06v0 ad=35.511p pd=48.245u as=35.511p ps=48.245u w=46.725u l=1u
X5696 DVDD GATE BAT DVDD pfet_06v0 ad=58.1552p pd=78.04u as=58.1552p ps=78.04u w=76.52u l=1u
X5697 BAT GATE DVDD DVDD pfet_06v0 ad=58.1134p pd=77.985u as=58.1134p ps=77.985u w=76.465u l=1u
X5698 DVDD GATE BAT DVDD pfet_06v0 ad=35.511p pd=48.245u as=35.511p ps=48.245u w=46.725u l=1u
X5699 BAT GATE DVDD DVDD pfet_06v0 ad=58.1134p pd=77.985u as=58.1134p ps=77.985u w=76.465u l=1u
X5700 DVDD GATE BAT DVDD pfet_06v0 ad=71.8724p pd=0.1548m as=58.1096p ps=77.98u w=76.46u l=1u
X5701 DVDD GATE BAT DVDD pfet_06v0 ad=35.511p pd=48.245u as=35.511p ps=48.245u w=46.725u l=1u
X5702 DVDD GATE BAT DVDD pfet_06v0 ad=35.511p pd=48.245u as=35.511p ps=48.245u w=46.725u l=1u
X5703 DVDD GATE BAT DVDD pfet_06v0 ad=58.1134p pd=77.985u as=58.1134p ps=77.985u w=76.465u l=1u
X5704 DVDD GATE BAT DVDD pfet_06v0 ad=49.3848p pd=66.5u as=49.3848p ps=66.5u w=64.98u l=1u
X5705 BAT GATE DVDD DVDD pfet_06v0 ad=49.3848p pd=66.5u as=61.0812p ps=0.13184m w=64.98u l=1u
X5706 DVDD GATE BAT DVDD pfet_06v0 ad=35.511p pd=48.245u as=35.511p ps=48.245u w=46.725u l=1u
X5707 BAT GATE DVDD DVDD pfet_06v0 ad=47.6862p pd=64.265u as=47.6862p ps=64.265u w=62.745u l=1u
X5708 BAT GATE DVDD DVDD pfet_06v0 ad=35.511p pd=48.245u as=35.511p ps=48.245u w=46.725u l=1u
X5709 DVDD GATE BAT DVDD pfet_06v0 ad=35.511p pd=48.245u as=35.511p ps=48.245u w=46.725u l=1u
X5710 DVDD GATE BAT DVDD pfet_06v0 ad=43.9168p pd=95.32u as=35.5072p ps=48.24u w=46.72u l=1u
X5711 DVDD GATE BAT DVDD pfet_06v0 ad=35.5072p pd=48.24u as=35.5072p ps=48.24u w=46.72u l=1u
X5712 BAT GATE DVDD DVDD pfet_06v0 ad=58.1134p pd=77.985u as=58.1134p ps=77.985u w=76.465u l=1u
X5713 DVDD GATE BAT DVDD pfet_06v0 ad=49.3848p pd=66.5u as=49.3848p ps=66.5u w=64.98u l=1u
X5714 BAT GATE DVDD DVDD pfet_06v0 ad=35.511p pd=48.245u as=35.511p ps=48.245u w=46.725u l=1u
X5715 BAT GATE DVDD DVDD pfet_06v0 ad=58.1096p pd=77.98u as=58.1096p ps=77.98u w=76.46u l=1u
X5716 BAT GATE DVDD DVDD pfet_06v0 ad=58.1096p pd=77.98u as=58.1096p ps=77.98u w=76.46u l=1u
X5717 DVDD GATE BAT DVDD pfet_06v0 ad=58.1172p pd=77.99u as=58.1172p ps=77.99u w=76.47u l=1u
X5718 DVDD GATE BAT DVDD pfet_06v0 ad=58.1134p pd=77.985u as=58.1134p ps=77.985u w=76.465u l=1u
X5719 DVDD GATE BAT DVDD pfet_06v0 ad=58.1134p pd=77.985u as=58.1134p ps=77.985u w=76.465u l=1u
X5720 DVDD GATE BAT DVDD pfet_06v0 ad=43.9215p pd=95.32999u as=35.511p ps=48.245u w=46.725u l=1u
X5721 BAT GATE DVDD DVDD pfet_06v0 ad=58.1134p pd=77.985u as=58.1134p ps=77.985u w=76.465u l=1u
X5722 BAT GATE DVDD DVDD pfet_06v0 ad=58.1552p pd=78.04u as=58.1552p ps=78.04u w=76.52u l=1u
X5723 DVDD GATE BAT DVDD pfet_06v0 ad=35.511p pd=48.245u as=35.511p ps=48.245u w=46.725u l=1u
X5724 BAT GATE DVDD DVDD pfet_06v0 ad=35.511p pd=48.245u as=35.511p ps=48.245u w=46.725u l=1u
X5725 DVDD GATE BAT DVDD pfet_06v0 ad=47.6862p pd=64.265u as=47.6862p ps=64.265u w=62.745u l=1u
X5726 DVDD GATE BAT DVDD pfet_06v0 ad=58.1096p pd=77.98u as=58.1096p ps=77.98u w=76.46u l=1u
X5727 BAT GATE DVDD DVDD pfet_06v0 ad=35.511p pd=48.245u as=35.511p ps=48.245u w=46.725u l=1u
X5728 DVDD GATE BAT DVDD pfet_06v0 ad=35.511p pd=48.245u as=35.511p ps=48.245u w=46.725u l=1u
X5729 BAT GATE DVDD DVDD pfet_06v0 ad=35.511p pd=48.245u as=35.511p ps=48.245u w=46.725u l=1u
X5730 DVDD GATE BAT DVDD pfet_06v0 ad=58.1134p pd=77.985u as=58.1134p ps=77.985u w=76.465u l=1u
X5731 BAT GATE DVDD DVDD pfet_06v0 ad=35.511p pd=48.245u as=35.511p ps=48.245u w=46.725u l=1u
X5732 DVDD GATE BAT DVDD pfet_06v0 ad=71.8724p pd=0.1548m as=58.1096p ps=77.98u w=76.46u l=1u
X5733 BAT GATE DVDD DVDD pfet_06v0 ad=58.1134p pd=77.985u as=58.1134p ps=77.985u w=76.465u l=1u
X5734 BAT GATE DVDD DVDD pfet_06v0 ad=58.0754p pd=77.935u as=58.0754p ps=77.935u w=76.41499u l=1u
X5735 DVDD GATE BAT DVDD pfet_06v0 ad=43.9215p pd=95.32999u as=35.511p ps=48.245u w=46.725u l=1u
X5736 BAT GATE DVDD DVDD pfet_06v0 ad=58.0754p pd=77.935u as=58.0754p ps=77.935u w=76.41499u l=1u
X5737 BAT GATE DVDD DVDD pfet_06v0 ad=47.6862p pd=64.265u as=47.6862p ps=64.265u w=62.745u l=1u
X5738 DVDD GATE BAT DVDD pfet_06v0 ad=35.511p pd=48.245u as=35.511p ps=48.245u w=46.725u l=1u
X5739 BAT GATE DVDD DVDD pfet_06v0 ad=58.1172p pd=77.99u as=58.1172p ps=77.99u w=76.47u l=1u
X5740 BAT GATE DVDD DVDD pfet_06v0 ad=35.511p pd=48.245u as=35.511p ps=48.245u w=46.725u l=1u
X5741 DVDD GATE BAT DVDD pfet_06v0 ad=58.1172p pd=77.99u as=58.1172p ps=77.99u w=76.47u l=1u
X5742 BAT GATE DVDD DVDD pfet_06v0 ad=35.511p pd=48.245u as=35.511p ps=48.245u w=46.725u l=1u
X5743 DVDD GATE BAT DVDD pfet_06v0 ad=43.9215p pd=95.32999u as=35.511p ps=48.245u w=46.725u l=1u
X5744 DVDD GATE BAT DVDD pfet_06v0 ad=43.9168p pd=95.32u as=35.5072p ps=48.24u w=46.72u l=1u
X5745 DVDD GATE BAT DVDD pfet_06v0 ad=58.1134p pd=77.985u as=58.1134p ps=77.985u w=76.465u l=1u
X5746 DVDD GATE BAT DVDD pfet_06v0 ad=35.5072p pd=48.24u as=35.5072p ps=48.24u w=46.72u l=1u
X5747 BAT GATE DVDD DVDD pfet_06v0 ad=58.1134p pd=77.985u as=58.1134p ps=77.985u w=76.465u l=1u
X5748 DVDD GATE BAT DVDD pfet_06v0 ad=35.511p pd=48.245u as=35.511p ps=48.245u w=46.725u l=1u
X5749 BAT GATE DVDD DVDD pfet_06v0 ad=58.1134p pd=77.985u as=58.1134p ps=77.985u w=76.465u l=1u
X5750 BAT GATE DVDD DVDD pfet_06v0 ad=47.6862p pd=64.265u as=47.6862p ps=64.265u w=62.745u l=1u
X5751 BAT GATE DVDD DVDD pfet_06v0 ad=35.511p pd=48.245u as=35.511p ps=48.245u w=46.725u l=1u
X5752 BAT GATE DVDD DVDD pfet_06v0 ad=58.1134p pd=77.985u as=58.1134p ps=77.985u w=76.465u l=1u
X5753 BAT GATE DVDD DVDD pfet_06v0 ad=35.511p pd=48.245u as=35.511p ps=48.245u w=46.725u l=1u
X5754 DVDD GATE BAT DVDD pfet_06v0 ad=58.1134p pd=77.985u as=58.1134p ps=77.985u w=76.465u l=1u
X5755 BAT GATE DVDD DVDD pfet_06v0 ad=58.1552p pd=78.04u as=58.1552p ps=78.04u w=76.52u l=1u
X5756 DVDD GATE BAT DVDD pfet_06v0 ad=58.1134p pd=77.985u as=58.1134p ps=77.985u w=76.465u l=1u
X5757 DVDD GATE BAT DVDD pfet_06v0 ad=35.511p pd=48.245u as=35.511p ps=48.245u w=46.725u l=1u
X5758 DVDD GATE BAT DVDD pfet_06v0 ad=58.1552p pd=78.04u as=58.1552p ps=78.04u w=76.52u l=1u
X5759 BAT GATE DVDD DVDD pfet_06v0 ad=58.1552p pd=78.04u as=58.1552p ps=78.04u w=76.52u l=1u
X5760 BAT GATE DVDD DVDD pfet_06v0 ad=58.0754p pd=77.935u as=58.0754p ps=77.935u w=76.41499u l=1u
X5761 DVDD GATE BAT DVDD pfet_06v0 ad=35.511p pd=48.245u as=35.511p ps=48.245u w=46.725u l=1u
X5762 DVDD GATE BAT DVDD pfet_06v0 ad=35.511p pd=48.245u as=35.511p ps=48.245u w=46.725u l=1u
X5763 DVDD GATE BAT DVDD pfet_06v0 ad=35.511p pd=48.245u as=35.511p ps=48.245u w=46.725u l=1u
X5764 BAT GATE DVDD DVDD pfet_06v0 ad=35.511p pd=48.245u as=35.511p ps=48.245u w=46.725u l=1u
X5765 BAT GATE DVDD DVDD pfet_06v0 ad=35.511p pd=48.245u as=35.511p ps=48.245u w=46.725u l=1u
X5766 BAT GATE DVDD DVDD pfet_06v0 ad=58.1134p pd=77.985u as=71.8771p ps=0.15481m w=76.465u l=1u
X5767 BAT GATE DVDD DVDD pfet_06v0 ad=58.1134p pd=77.985u as=58.1134p ps=77.985u w=76.465u l=1u
X5768 DVDD GATE BAT DVDD pfet_06v0 ad=47.6862p pd=64.265u as=47.6862p ps=64.265u w=62.745u l=1u
X5769 DVDD GATE BAT DVDD pfet_06v0 ad=58.1134p pd=77.985u as=58.1134p ps=77.985u w=76.465u l=1u
X5770 DVDD GATE BAT DVDD pfet_06v0 ad=58.1134p pd=77.985u as=58.1134p ps=77.985u w=76.465u l=1u
X5771 DVDD GATE BAT DVDD pfet_06v0 ad=71.92879p pd=0.15492m as=58.1552p ps=78.04u w=76.52u l=1u
X5772 DVDD GATE BAT DVDD pfet_06v0 ad=43.9215p pd=95.32999u as=35.511p ps=48.245u w=46.725u l=1u
X5773 BAT GATE DVDD DVDD pfet_06v0 ad=58.1134p pd=77.985u as=58.1134p ps=77.985u w=76.465u l=1u
X5774 DVDD GATE BAT DVDD pfet_06v0 ad=58.1134p pd=77.985u as=58.1134p ps=77.985u w=76.465u l=1u
X5775 BAT GATE DVDD DVDD pfet_06v0 ad=35.511p pd=48.245u as=35.511p ps=48.245u w=46.725u l=1u
X5776 DVDD GATE BAT DVDD pfet_06v0 ad=71.8771p pd=0.15481m as=58.1134p ps=77.985u w=76.465u l=1u
X5777 BAT GATE DVDD DVDD pfet_06v0 ad=58.1552p pd=78.04u as=71.92879p ps=0.15492m w=76.52u l=1u
X5778 DVDD GATE BAT DVDD pfet_06v0 ad=43.9215p pd=95.32999u as=35.511p ps=48.245u w=46.725u l=1u
X5779 DVDD GATE BAT DVDD pfet_06v0 ad=35.511p pd=48.245u as=35.511p ps=48.245u w=46.725u l=1u
X5780 DVDD GATE BAT DVDD pfet_06v0 ad=35.511p pd=48.245u as=35.511p ps=48.245u w=46.725u l=1u
X5781 DVDD GATE BAT DVDD pfet_06v0 ad=58.1134p pd=77.985u as=58.1134p ps=77.985u w=76.465u l=1u
X5782 BAT GATE DVDD DVDD pfet_06v0 ad=35.511p pd=48.245u as=35.511p ps=48.245u w=46.725u l=1u
X5783 DVDD GATE BAT DVDD pfet_06v0 ad=35.5072p pd=48.24u as=35.5072p ps=48.24u w=46.72u l=1u
X5784 DVDD GATE BAT DVDD pfet_06v0 ad=71.8771p pd=0.15481m as=58.1134p ps=77.985u w=76.465u l=1u
X5785 BAT GATE DVDD DVDD pfet_06v0 ad=35.511p pd=48.245u as=35.511p ps=48.245u w=46.725u l=1u
X5786 BAT GATE DVDD DVDD pfet_06v0 ad=58.1134p pd=77.985u as=71.8771p ps=0.15481m w=76.465u l=1u
X5787 BAT GATE DVDD DVDD pfet_06v0 ad=58.0754p pd=77.935u as=58.0754p ps=77.935u w=76.41499u l=1u
X5788 DVDD GATE BAT DVDD pfet_06v0 ad=35.511p pd=48.245u as=35.511p ps=48.245u w=46.725u l=1u
X5789 DVDD GATE BAT DVDD pfet_06v0 ad=35.511p pd=48.245u as=35.511p ps=48.245u w=46.725u l=1u
X5790 BAT GATE DVDD DVDD pfet_06v0 ad=35.511p pd=48.245u as=35.511p ps=48.245u w=46.725u l=1u
X5791 BAT GATE DVDD DVDD pfet_06v0 ad=47.6862p pd=64.265u as=47.6862p ps=64.265u w=62.745u l=1u
X5792 DVDD GATE BAT DVDD pfet_06v0 ad=58.1134p pd=77.985u as=58.1134p ps=77.985u w=76.465u l=1u
X5793 DVDD GATE BAT DVDD pfet_06v0 ad=58.1134p pd=77.985u as=58.1134p ps=77.985u w=76.465u l=1u
X5794 BAT GATE DVDD DVDD pfet_06v0 ad=58.1552p pd=78.04u as=71.92879p ps=0.15492m w=76.52u l=1u
X5795 DVDD GATE BAT DVDD pfet_06v0 ad=58.1134p pd=77.985u as=58.1134p ps=77.985u w=76.465u l=1u
X5796 BAT GATE DVDD DVDD pfet_06v0 ad=35.511p pd=48.245u as=35.511p ps=48.245u w=46.725u l=1u
X5797 DVDD GATE BAT DVDD pfet_06v0 ad=43.9215p pd=95.32999u as=35.511p ps=48.245u w=46.725u l=1u
X5798 DVDD GATE BAT DVDD pfet_06v0 ad=35.511p pd=48.245u as=35.511p ps=48.245u w=46.725u l=1u
X5799 BAT GATE DVDD DVDD pfet_06v0 ad=35.511p pd=48.245u as=35.511p ps=48.245u w=46.725u l=1u
X5800 DVDD GATE BAT DVDD pfet_06v0 ad=58.1134p pd=77.985u as=58.1134p ps=77.985u w=76.465u l=1u
X5801 DVDD GATE BAT DVDD pfet_06v0 ad=58.1134p pd=77.985u as=58.1134p ps=77.985u w=76.465u l=1u
X5802 DVDD GATE BAT DVDD pfet_06v0 ad=58.9803p pd=0.12737m as=47.6862p ps=64.265u w=62.745u l=1u
X5803 BAT GATE DVDD DVDD pfet_06v0 ad=49.3848p pd=66.5u as=61.0812p ps=0.13184m w=64.98u l=1u
X5804 DVDD GATE BAT DVDD pfet_06v0 ad=71.8771p pd=0.15481m as=58.1134p ps=77.985u w=76.465u l=1u
X5805 DVDD GATE BAT DVDD pfet_06v0 ad=35.511p pd=48.245u as=35.511p ps=48.245u w=46.725u l=1u
X5806 BAT GATE DVDD DVDD pfet_06v0 ad=58.1096p pd=77.98u as=58.1096p ps=77.98u w=76.46u l=1u
X5807 DVDD GATE BAT DVDD pfet_06v0 ad=58.1134p pd=77.985u as=58.1134p ps=77.985u w=76.465u l=1u
X5808 BAT GATE DVDD DVDD pfet_06v0 ad=35.5072p pd=48.24u as=35.5072p ps=48.24u w=46.72u l=1u
X5809 DVDD GATE BAT DVDD pfet_06v0 ad=35.511p pd=48.245u as=35.511p ps=48.245u w=46.725u l=1u
X5810 DVDD GATE BAT DVDD pfet_06v0 ad=71.8724p pd=0.1548m as=58.1096p ps=77.98u w=76.46u l=1u
X5811 BAT GATE DVDD DVDD pfet_06v0 ad=35.511p pd=48.245u as=35.511p ps=48.245u w=46.725u l=1u
X5812 BAT GATE DVDD DVDD pfet_06v0 ad=58.1134p pd=77.985u as=58.1134p ps=77.985u w=76.465u l=1u
X5813 DVDD GATE BAT DVDD pfet_06v0 ad=58.1134p pd=77.985u as=58.1134p ps=77.985u w=76.465u l=1u
X5814 BAT GATE DVDD DVDD pfet_06v0 ad=49.3848p pd=66.5u as=49.3848p ps=66.5u w=64.98u l=1u
X5815 DVDD GATE BAT DVDD pfet_06v0 ad=35.5072p pd=48.24u as=35.5072p ps=48.24u w=46.72u l=1u
X5816 BAT GATE DVDD DVDD pfet_06v0 ad=47.6862p pd=64.265u as=47.6862p ps=64.265u w=62.745u l=1u
X5817 BAT GATE DVDD DVDD pfet_06v0 ad=58.1134p pd=77.985u as=71.8771p ps=0.15481m w=76.465u l=1u
X5818 DVDD GATE BAT DVDD pfet_06v0 ad=58.1552p pd=78.04u as=58.1552p ps=78.04u w=76.52u l=1u
X5819 DVDD GATE BAT DVDD pfet_06v0 ad=58.0754p pd=77.935u as=58.0754p ps=77.935u w=76.41499u l=1u
X5820 BAT GATE DVDD DVDD pfet_06v0 ad=35.511p pd=48.245u as=35.511p ps=48.245u w=46.725u l=1u
X5821 DVDD GATE BAT DVDD pfet_06v0 ad=71.8301p pd=0.15471m as=58.0754p ps=77.935u w=76.41499u l=1u
X5822 BAT GATE DVDD DVDD pfet_06v0 ad=47.6862p pd=64.265u as=47.6862p ps=64.265u w=62.745u l=1u
X5823 BAT GATE DVDD DVDD pfet_06v0 ad=35.511p pd=48.245u as=35.511p ps=48.245u w=46.725u l=1u
X5824 BAT GATE DVDD DVDD pfet_06v0 ad=35.511p pd=48.245u as=35.511p ps=48.245u w=46.725u l=1u
X5825 BAT GATE DVDD DVDD pfet_06v0 ad=47.6862p pd=64.265u as=47.6862p ps=64.265u w=62.745u l=1u
X5826 BAT GATE DVDD DVDD pfet_06v0 ad=35.511p pd=48.245u as=35.511p ps=48.245u w=46.725u l=1u
X5827 DVDD GATE BAT DVDD pfet_06v0 ad=58.1134p pd=77.985u as=58.1134p ps=77.985u w=76.465u l=1u
X5828 DVDD GATE BAT DVDD pfet_06v0 ad=47.6862p pd=64.265u as=47.6862p ps=64.265u w=62.745u l=1u
X5829 DVDD GATE BAT DVDD pfet_06v0 ad=71.8771p pd=0.15481m as=58.1134p ps=77.985u w=76.465u l=1u
X5830 BAT GATE DVDD DVDD pfet_06v0 ad=49.3848p pd=66.5u as=49.3848p ps=66.5u w=64.98u l=1u
X5831 BAT GATE DVDD DVDD pfet_06v0 ad=58.1134p pd=77.985u as=71.8771p ps=0.15481m w=76.465u l=1u
X5832 BAT GATE DVDD DVDD pfet_06v0 ad=58.1134p pd=77.985u as=58.1134p ps=77.985u w=76.465u l=1u
X5833 DVDD GATE BAT DVDD pfet_06v0 ad=58.1134p pd=77.985u as=58.1134p ps=77.985u w=76.465u l=1u
X5834 DVDD GATE BAT DVDD pfet_06v0 ad=71.8818p pd=0.15482m as=58.1172p ps=77.99u w=76.47u l=1u
X5835 BAT GATE DVDD DVDD pfet_06v0 ad=35.511p pd=48.245u as=35.511p ps=48.245u w=46.725u l=1u
X5836 DVDD GATE BAT DVDD pfet_06v0 ad=58.1134p pd=77.985u as=58.1134p ps=77.985u w=76.465u l=1u
X5837 DVDD GATE BAT DVDD pfet_06v0 ad=35.511p pd=48.245u as=35.511p ps=48.245u w=46.725u l=1u
X5838 BAT GATE DVDD DVDD pfet_06v0 ad=58.1096p pd=77.98u as=58.1096p ps=77.98u w=76.46u l=1u
X5839 DVDD GATE BAT DVDD pfet_06v0 ad=58.1096p pd=77.98u as=58.1096p ps=77.98u w=76.46u l=1u
X5840 DVDD GATE BAT DVDD pfet_06v0 ad=58.1134p pd=77.985u as=58.1134p ps=77.985u w=76.465u l=1u
X5841 BAT GATE DVDD DVDD pfet_06v0 ad=58.1134p pd=77.985u as=58.1134p ps=77.985u w=76.465u l=1u
X5842 DVDD GATE BAT DVDD pfet_06v0 ad=43.9215p pd=95.32999u as=35.511p ps=48.245u w=46.725u l=1u
X5843 DVDD GATE BAT DVDD pfet_06v0 ad=35.5072p pd=48.24u as=35.5072p ps=48.24u w=46.72u l=1u
X5844 BAT GATE DVDD DVDD pfet_06v0 ad=35.511p pd=48.245u as=35.511p ps=48.245u w=46.725u l=1u
X5845 BAT GATE DVDD DVDD pfet_06v0 ad=58.1172p pd=77.99u as=58.1172p ps=77.99u w=76.47u l=1u
X5846 DVDD GATE BAT DVDD pfet_06v0 ad=58.1134p pd=77.985u as=58.1134p ps=77.985u w=76.465u l=1u
X5847 DVDD GATE BAT DVDD pfet_06v0 ad=43.9215p pd=95.32999u as=35.511p ps=48.245u w=46.725u l=1u
X5848 DVDD GATE BAT DVDD pfet_06v0 ad=58.1134p pd=77.985u as=58.1134p ps=77.985u w=76.465u l=1u
X5849 BAT GATE DVDD DVDD pfet_06v0 ad=35.511p pd=48.245u as=35.511p ps=48.245u w=46.725u l=1u
X5850 DVDD GATE BAT DVDD pfet_06v0 ad=58.1134p pd=77.985u as=58.1134p ps=77.985u w=76.465u l=1u
X5851 BAT GATE DVDD DVDD pfet_06v0 ad=58.1134p pd=77.985u as=58.1134p ps=77.985u w=76.465u l=1u
X5852 DVDD GATE BAT DVDD pfet_06v0 ad=35.5072p pd=48.24u as=35.5072p ps=48.24u w=46.72u l=1u
X5853 BAT GATE DVDD DVDD pfet_06v0 ad=35.511p pd=48.245u as=35.511p ps=48.245u w=46.725u l=1u
X5854 DVDD GATE BAT DVDD pfet_06v0 ad=58.1134p pd=77.985u as=58.1134p ps=77.985u w=76.465u l=1u
X5855 BAT GATE DVDD DVDD pfet_06v0 ad=47.6862p pd=64.265u as=58.9803p ps=0.12737m w=62.745u l=1u
X5856 BAT GATE DVDD DVDD pfet_06v0 ad=58.1134p pd=77.985u as=58.1134p ps=77.985u w=76.465u l=1u
X5857 BAT GATE DVDD DVDD pfet_06v0 ad=58.1134p pd=77.985u as=71.8771p ps=0.15481m w=76.465u l=1u
X5858 DVDD GATE BAT DVDD pfet_06v0 ad=58.1172p pd=77.99u as=58.1172p ps=77.99u w=76.47u l=1u
X5859 BAT GATE DVDD DVDD pfet_06v0 ad=35.511p pd=48.245u as=35.511p ps=48.245u w=46.725u l=1u
X5860 DVDD GATE BAT DVDD pfet_06v0 ad=35.511p pd=48.245u as=35.511p ps=48.245u w=46.725u l=1u
X5861 BAT GATE DVDD DVDD pfet_06v0 ad=49.3848p pd=66.5u as=49.3848p ps=66.5u w=64.98u l=1u
X5862 BAT GATE DVDD DVDD pfet_06v0 ad=58.1134p pd=77.985u as=71.8771p ps=0.15481m w=76.465u l=1u
X5863 DVDD GATE BAT DVDD pfet_06v0 ad=35.511p pd=48.245u as=35.511p ps=48.245u w=46.725u l=1u
X5864 BAT GATE DVDD DVDD pfet_06v0 ad=58.1134p pd=77.985u as=58.1134p ps=77.985u w=76.465u l=1u
X5865 DVDD GATE BAT DVDD pfet_06v0 ad=58.1552p pd=78.04u as=58.1552p ps=78.04u w=76.52u l=1u
X5866 BAT GATE DVDD DVDD pfet_06v0 ad=35.511p pd=48.245u as=35.511p ps=48.245u w=46.725u l=1u
X5867 DVDD GATE BAT DVDD pfet_06v0 ad=58.1134p pd=77.985u as=58.1134p ps=77.985u w=76.465u l=1u
X5868 DVDD GATE BAT DVDD pfet_06v0 ad=58.1096p pd=77.98u as=58.1096p ps=77.98u w=76.46u l=1u
X5869 DVDD GATE BAT DVDD pfet_06v0 ad=58.1134p pd=77.985u as=58.1134p ps=77.985u w=76.465u l=1u
X5870 BAT GATE DVDD DVDD pfet_06v0 ad=58.0754p pd=77.935u as=71.8301p ps=0.15471m w=76.41499u l=1u
X5871 BAT GATE DVDD DVDD pfet_06v0 ad=35.511p pd=48.245u as=35.511p ps=48.245u w=46.725u l=1u
X5872 DVDD GATE BAT DVDD pfet_06v0 ad=58.1134p pd=77.985u as=58.1134p ps=77.985u w=76.465u l=1u
X5873 DVDD GATE BAT DVDD pfet_06v0 ad=35.511p pd=48.245u as=35.511p ps=48.245u w=46.725u l=1u
X5874 DVDD GATE BAT DVDD pfet_06v0 ad=35.511p pd=48.245u as=35.511p ps=48.245u w=46.725u l=1u
X5875 DVDD GATE BAT DVDD pfet_06v0 ad=71.8771p pd=0.15481m as=58.1134p ps=77.985u w=76.465u l=1u
X5876 BAT GATE DVDD DVDD pfet_06v0 ad=35.511p pd=48.245u as=35.511p ps=48.245u w=46.725u l=1u
X5877 DVDD GATE BAT DVDD pfet_06v0 ad=35.511p pd=48.245u as=35.511p ps=48.245u w=46.725u l=1u
X5878 DVDD GATE BAT DVDD pfet_06v0 ad=58.1134p pd=77.985u as=58.1134p ps=77.985u w=76.465u l=1u
X5879 BAT GATE DVDD DVDD pfet_06v0 ad=58.1172p pd=77.99u as=58.1172p ps=77.99u w=76.47u l=1u
X5880 DVDD GATE BAT DVDD pfet_06v0 ad=58.1134p pd=77.985u as=58.1134p ps=77.985u w=76.465u l=1u
X5881 DVDD GATE BAT DVDD pfet_06v0 ad=35.511p pd=48.245u as=35.511p ps=48.245u w=46.725u l=1u
X5882 DVDD GATE BAT DVDD pfet_06v0 ad=35.511p pd=48.245u as=35.511p ps=48.245u w=46.725u l=1u
X5883 DVDD GATE BAT DVDD pfet_06v0 ad=35.5072p pd=48.24u as=35.5072p ps=48.24u w=46.72u l=1u
X5884 DVDD GATE BAT DVDD pfet_06v0 ad=47.6862p pd=64.265u as=47.6862p ps=64.265u w=62.745u l=1u
X5885 BAT GATE DVDD DVDD pfet_06v0 ad=58.1134p pd=77.985u as=58.1134p ps=77.985u w=76.465u l=1u
X5886 DVDD GATE BAT DVDD pfet_06v0 ad=35.511p pd=48.245u as=35.511p ps=48.245u w=46.725u l=1u
X5887 BAT GATE DVDD DVDD pfet_06v0 ad=58.1134p pd=77.985u as=71.8771p ps=0.15481m w=76.465u l=1u
X5888 BAT GATE DVDD DVDD pfet_06v0 ad=35.511p pd=48.245u as=35.511p ps=48.245u w=46.725u l=1u
X5889 DVDD GATE BAT DVDD pfet_06v0 ad=35.511p pd=48.245u as=35.511p ps=48.245u w=46.725u l=1u
X5890 BAT GATE DVDD DVDD pfet_06v0 ad=58.1134p pd=77.985u as=58.1134p ps=77.985u w=76.465u l=1u
X5891 DVDD GATE BAT DVDD pfet_06v0 ad=58.1096p pd=77.98u as=58.1096p ps=77.98u w=76.46u l=1u
X5892 BAT GATE DVDD DVDD pfet_06v0 ad=58.1134p pd=77.985u as=58.1134p ps=77.985u w=76.465u l=1u
X5893 BAT GATE DVDD DVDD pfet_06v0 ad=58.1172p pd=77.99u as=58.1172p ps=77.99u w=76.47u l=1u
X5894 DVDD GATE BAT DVDD pfet_06v0 ad=43.9215p pd=95.32999u as=35.511p ps=48.245u w=46.725u l=1u
X5895 BAT GATE DVDD DVDD pfet_06v0 ad=35.511p pd=48.245u as=35.511p ps=48.245u w=46.725u l=1u
X5896 DVDD GATE BAT DVDD pfet_06v0 ad=58.1134p pd=77.985u as=58.1134p ps=77.985u w=76.465u l=1u
X5897 BAT GATE DVDD DVDD pfet_06v0 ad=58.1134p pd=77.985u as=58.1134p ps=77.985u w=76.465u l=1u
X5898 DVDD GATE BAT DVDD pfet_06v0 ad=47.6862p pd=64.265u as=47.6862p ps=64.265u w=62.745u l=1u
X5899 BAT GATE DVDD DVDD pfet_06v0 ad=47.6862p pd=64.265u as=47.6862p ps=64.265u w=62.745u l=1u
X5900 DVDD GATE BAT DVDD pfet_06v0 ad=58.1134p pd=77.985u as=58.1134p ps=77.985u w=76.465u l=1u
X5901 BAT GATE DVDD DVDD pfet_06v0 ad=49.3848p pd=66.5u as=49.3848p ps=66.5u w=64.98u l=1u
X5902 DVDD GATE BAT DVDD pfet_06v0 ad=71.8818p pd=0.15482m as=58.1172p ps=77.99u w=76.47u l=1u
X5903 DVDD GATE BAT DVDD pfet_06v0 ad=58.1134p pd=77.985u as=58.1134p ps=77.985u w=76.465u l=1u
X5904 DVDD GATE BAT DVDD pfet_06v0 ad=35.5072p pd=48.24u as=35.5072p ps=48.24u w=46.72u l=1u
X5905 BAT GATE DVDD DVDD pfet_06v0 ad=58.1134p pd=77.985u as=58.1134p ps=77.985u w=76.465u l=1u
X5906 DVDD GATE BAT DVDD pfet_06v0 ad=58.1134p pd=77.985u as=58.1134p ps=77.985u w=76.465u l=1u
X5907 DVDD GATE BAT DVDD pfet_06v0 ad=58.1134p pd=77.985u as=58.1134p ps=77.985u w=76.465u l=1u
X5908 BAT GATE DVDD DVDD pfet_06v0 ad=58.1134p pd=77.985u as=58.1134p ps=77.985u w=76.465u l=1u
X5909 BAT GATE DVDD DVDD pfet_06v0 ad=35.511p pd=48.245u as=35.511p ps=48.245u w=46.725u l=1u
X5910 DVDD GATE BAT DVDD pfet_06v0 ad=58.1134p pd=77.985u as=58.1134p ps=77.985u w=76.465u l=1u
X5911 BAT GATE DVDD DVDD pfet_06v0 ad=58.1096p pd=77.98u as=58.1096p ps=77.98u w=76.46u l=1u
X5912 DVDD GATE BAT DVDD pfet_06v0 ad=49.3848p pd=66.5u as=49.3848p ps=66.5u w=64.98u l=1u
X5913 BAT GATE DVDD DVDD pfet_06v0 ad=58.1134p pd=77.985u as=71.8771p ps=0.15481m w=76.465u l=1u
X5914 BAT GATE DVDD DVDD pfet_06v0 ad=35.511p pd=48.245u as=35.511p ps=48.245u w=46.725u l=1u
X5915 DVDD GATE BAT DVDD pfet_06v0 ad=35.511p pd=48.245u as=35.511p ps=48.245u w=46.725u l=1u
X5916 BAT GATE DVDD DVDD pfet_06v0 ad=35.5072p pd=48.24u as=35.5072p ps=48.24u w=46.72u l=1u
X5917 DVDD GATE BAT DVDD pfet_06v0 ad=58.1172p pd=77.99u as=58.1172p ps=77.99u w=76.47u l=1u
X5918 BAT GATE DVDD DVDD pfet_06v0 ad=58.1134p pd=77.985u as=58.1134p ps=77.985u w=76.465u l=1u
X5919 BAT GATE DVDD DVDD pfet_06v0 ad=35.5072p pd=48.24u as=35.5072p ps=48.24u w=46.72u l=1u
X5920 DVDD GATE BAT DVDD pfet_06v0 ad=35.511p pd=48.245u as=35.511p ps=48.245u w=46.725u l=1u
X5921 DVDD GATE BAT DVDD pfet_06v0 ad=58.1134p pd=77.985u as=58.1134p ps=77.985u w=76.465u l=1u
X5922 DVDD GATE BAT DVDD pfet_06v0 ad=49.3848p pd=66.5u as=49.3848p ps=66.5u w=64.98u l=1u
X5923 DVDD GATE BAT DVDD pfet_06v0 ad=47.6862p pd=64.265u as=47.6862p ps=64.265u w=62.745u l=1u
X5924 DVDD GATE BAT DVDD pfet_06v0 ad=58.1096p pd=77.98u as=58.1096p ps=77.98u w=76.46u l=1u
X5925 DVDD GATE BAT DVDD pfet_06v0 ad=58.9803p pd=0.12737m as=47.6862p ps=64.265u w=62.745u l=1u
X5926 DVDD GATE BAT DVDD pfet_06v0 ad=35.511p pd=48.245u as=35.511p ps=48.245u w=46.725u l=1u
X5927 DVDD GATE BAT DVDD pfet_06v0 ad=35.511p pd=48.245u as=35.511p ps=48.245u w=46.725u l=1u
X5928 BAT GATE DVDD DVDD pfet_06v0 ad=58.1172p pd=77.99u as=58.1172p ps=77.99u w=76.47u l=1u
X5929 BAT GATE DVDD DVDD pfet_06v0 ad=47.6862p pd=64.265u as=47.6862p ps=64.265u w=62.745u l=1u
X5930 DVDD GATE BAT DVDD pfet_06v0 ad=43.9215p pd=95.32999u as=35.511p ps=48.245u w=46.725u l=1u
X5931 DVDD GATE BAT DVDD pfet_06v0 ad=58.1134p pd=77.985u as=58.1134p ps=77.985u w=76.465u l=1u
X5932 BAT GATE DVDD DVDD pfet_06v0 ad=35.511p pd=48.245u as=35.511p ps=48.245u w=46.725u l=1u
X5933 DVDD GATE BAT DVDD pfet_06v0 ad=58.1134p pd=77.985u as=58.1134p ps=77.985u w=76.465u l=1u
X5934 DVDD GATE BAT DVDD pfet_06v0 ad=58.1552p pd=78.04u as=58.1552p ps=78.04u w=76.52u l=1u
X5935 BAT GATE DVDD DVDD pfet_06v0 ad=35.511p pd=48.245u as=35.511p ps=48.245u w=46.725u l=1u
X5936 DVDD GATE BAT DVDD pfet_06v0 ad=43.9215p pd=95.32999u as=35.511p ps=48.245u w=46.725u l=1u
X5937 DVDD GATE BAT DVDD pfet_06v0 ad=35.5072p pd=48.24u as=35.5072p ps=48.24u w=46.72u l=1u
X5938 DVDD GATE BAT DVDD pfet_06v0 ad=58.1134p pd=77.985u as=58.1134p ps=77.985u w=76.465u l=1u
X5939 BAT GATE DVDD DVDD pfet_06v0 ad=35.511p pd=48.245u as=35.511p ps=48.245u w=46.725u l=1u
X5940 BAT GATE DVDD DVDD pfet_06v0 ad=35.511p pd=48.245u as=43.9215p ps=95.32999u w=46.725u l=1u
X5941 BAT GATE DVDD DVDD pfet_06v0 ad=35.511p pd=48.245u as=35.511p ps=48.245u w=46.725u l=1u
X5942 DVDD GATE BAT DVDD pfet_06v0 ad=35.511p pd=48.245u as=35.511p ps=48.245u w=46.725u l=1u
X5943 BAT GATE DVDD DVDD pfet_06v0 ad=58.1134p pd=77.985u as=71.8771p ps=0.15481m w=76.465u l=1u
X5944 BAT GATE DVDD DVDD pfet_06v0 ad=58.1134p pd=77.985u as=58.1134p ps=77.985u w=76.465u l=1u
X5945 DVDD GATE BAT DVDD pfet_06v0 ad=58.0754p pd=77.935u as=58.0754p ps=77.935u w=76.41499u l=1u
X5946 BAT GATE DVDD DVDD pfet_06v0 ad=58.1134p pd=77.985u as=58.1134p ps=77.985u w=76.465u l=1u
X5947 DVDD GATE BAT DVDD pfet_06v0 ad=58.1134p pd=77.985u as=58.1134p ps=77.985u w=76.465u l=1u
X5948 BAT GATE DVDD DVDD pfet_06v0 ad=58.1134p pd=77.985u as=58.1134p ps=77.985u w=76.465u l=1u
X5949 BAT GATE DVDD DVDD pfet_06v0 ad=35.511p pd=48.245u as=35.511p ps=48.245u w=46.725u l=1u
X5950 BAT GATE DVDD DVDD pfet_06v0 ad=35.511p pd=48.245u as=35.511p ps=48.245u w=46.725u l=1u
X5951 BAT GATE DVDD DVDD pfet_06v0 ad=35.511p pd=48.245u as=35.511p ps=48.245u w=46.725u l=1u
X5952 DVDD GATE BAT DVDD pfet_06v0 ad=35.511p pd=48.245u as=35.511p ps=48.245u w=46.725u l=1u
X5953 BAT GATE DVDD DVDD pfet_06v0 ad=35.511p pd=48.245u as=43.9215p ps=95.32999u w=46.725u l=1u
X5954 DVDD GATE BAT DVDD pfet_06v0 ad=71.8771p pd=0.15481m as=58.1134p ps=77.985u w=76.465u l=1u
X5955 DVDD GATE BAT DVDD pfet_06v0 ad=35.511p pd=48.245u as=35.511p ps=48.245u w=46.725u l=1u
X5956 DVDD GATE BAT DVDD pfet_06v0 ad=58.1172p pd=77.99u as=58.1172p ps=77.99u w=76.47u l=1u
X5957 DVDD GATE BAT DVDD pfet_06v0 ad=43.9215p pd=95.32999u as=35.511p ps=48.245u w=46.725u l=1u
X5958 BAT GATE DVDD DVDD pfet_06v0 ad=58.1134p pd=77.985u as=58.1134p ps=77.985u w=76.465u l=1u
X5959 BAT GATE DVDD DVDD pfet_06v0 ad=35.511p pd=48.245u as=35.511p ps=48.245u w=46.725u l=1u
X5960 BAT GATE DVDD DVDD pfet_06v0 ad=35.511p pd=48.245u as=35.511p ps=48.245u w=46.725u l=1u
X5961 DVDD GATE BAT DVDD pfet_06v0 ad=35.511p pd=48.245u as=35.511p ps=48.245u w=46.725u l=1u
X5962 BAT GATE DVDD DVDD pfet_06v0 ad=58.1134p pd=77.985u as=58.1134p ps=77.985u w=76.465u l=1u
X5963 DVDD GATE BAT DVDD pfet_06v0 ad=58.1172p pd=77.99u as=58.1172p ps=77.99u w=76.47u l=1u
X5964 DVDD GATE BAT DVDD pfet_06v0 ad=58.1134p pd=77.985u as=58.1134p ps=77.985u w=76.465u l=1u
X5965 DVDD GATE BAT DVDD pfet_06v0 ad=58.1134p pd=77.985u as=58.1134p ps=77.985u w=76.465u l=1u
X5966 BAT GATE DVDD DVDD pfet_06v0 ad=49.3848p pd=66.5u as=61.0812p ps=0.13184m w=64.98u l=1u
X5967 DVDD GATE BAT DVDD pfet_06v0 ad=35.511p pd=48.245u as=35.511p ps=48.245u w=46.725u l=1u
X5968 DVDD GATE BAT DVDD pfet_06v0 ad=58.1134p pd=77.985u as=58.1134p ps=77.985u w=76.465u l=1u
X5969 DVDD GATE BAT DVDD pfet_06v0 ad=35.511p pd=48.245u as=35.511p ps=48.245u w=46.725u l=1u
X5970 BAT GATE DVDD DVDD pfet_06v0 ad=58.1172p pd=77.99u as=71.8818p ps=0.15482m w=76.47u l=1u
X5971 DVDD GATE BAT DVDD pfet_06v0 ad=35.511p pd=48.245u as=35.511p ps=48.245u w=46.725u l=1u
X5972 BAT GATE DVDD DVDD pfet_06v0 ad=58.1134p pd=77.985u as=58.1134p ps=77.985u w=76.465u l=1u
X5973 DVDD GATE BAT DVDD pfet_06v0 ad=71.8771p pd=0.15481m as=58.1134p ps=77.985u w=76.465u l=1u
X5974 DVDD GATE BAT DVDD pfet_06v0 ad=58.1096p pd=77.98u as=58.1096p ps=77.98u w=76.46u l=1u
X5975 DVDD GATE BAT DVDD pfet_06v0 ad=58.1096p pd=77.98u as=58.1096p ps=77.98u w=76.46u l=1u
X5976 BAT GATE DVDD DVDD pfet_06v0 ad=58.1172p pd=77.99u as=58.1172p ps=77.99u w=76.47u l=1u
X5977 DVDD GATE BAT DVDD pfet_06v0 ad=58.1552p pd=78.04u as=58.1552p ps=78.04u w=76.52u l=1u
X5978 BAT GATE DVDD DVDD pfet_06v0 ad=58.1134p pd=77.985u as=58.1134p ps=77.985u w=76.465u l=1u
X5979 DVDD GATE BAT DVDD pfet_06v0 ad=35.511p pd=48.245u as=35.511p ps=48.245u w=46.725u l=1u
X5980 BAT GATE DVDD DVDD pfet_06v0 ad=35.511p pd=48.245u as=35.511p ps=48.245u w=46.725u l=1u
X5981 BAT GATE DVDD DVDD pfet_06v0 ad=58.1552p pd=78.04u as=58.1552p ps=78.04u w=76.52u l=1u
X5982 DVDD GATE BAT DVDD pfet_06v0 ad=58.1552p pd=78.04u as=58.1552p ps=78.04u w=76.52u l=1u
X5983 DVDD GATE BAT DVDD pfet_06v0 ad=58.1134p pd=77.985u as=58.1134p ps=77.985u w=76.465u l=1u
X5984 BAT GATE DVDD DVDD pfet_06v0 ad=35.5072p pd=48.24u as=35.5072p ps=48.24u w=46.72u l=1u
X5985 DVDD GATE BAT DVDD pfet_06v0 ad=35.511p pd=48.245u as=35.511p ps=48.245u w=46.725u l=1u
X5986 DVDD GATE BAT DVDD pfet_06v0 ad=58.1134p pd=77.985u as=58.1134p ps=77.985u w=76.465u l=1u
X5987 BAT GATE DVDD DVDD pfet_06v0 ad=58.1134p pd=77.985u as=58.1134p ps=77.985u w=76.465u l=1u
X5988 DVDD GATE BAT DVDD pfet_06v0 ad=35.511p pd=48.245u as=35.511p ps=48.245u w=46.725u l=1u
X5989 DVDD GATE BAT DVDD pfet_06v0 ad=35.511p pd=48.245u as=35.511p ps=48.245u w=46.725u l=1u
X5990 DVDD GATE BAT DVDD pfet_06v0 ad=61.0812p pd=0.13184m as=49.3848p ps=66.5u w=64.98u l=1u
X5991 DVDD GATE BAT DVDD pfet_06v0 ad=58.1134p pd=77.985u as=58.1134p ps=77.985u w=76.465u l=1u
X5992 DVDD GATE BAT DVDD pfet_06v0 ad=58.1172p pd=77.99u as=58.1172p ps=77.99u w=76.47u l=1u
X5993 DVDD GATE BAT DVDD pfet_06v0 ad=58.1552p pd=78.04u as=58.1552p ps=78.04u w=76.52u l=1u
X5994 BAT GATE DVDD DVDD pfet_06v0 ad=35.511p pd=48.245u as=35.511p ps=48.245u w=46.725u l=1u
X5995 BAT GATE DVDD DVDD pfet_06v0 ad=58.1134p pd=77.985u as=58.1134p ps=77.985u w=76.465u l=1u
X5996 DVDD GATE BAT DVDD pfet_06v0 ad=58.1134p pd=77.985u as=58.1134p ps=77.985u w=76.465u l=1u
X5997 BAT GATE DVDD DVDD pfet_06v0 ad=35.511p pd=48.245u as=43.9215p ps=95.32999u w=46.725u l=1u
X5998 DVDD GATE BAT DVDD pfet_06v0 ad=58.1134p pd=77.985u as=58.1134p ps=77.985u w=76.465u l=1u
X5999 DVDD GATE BAT DVDD pfet_06v0 ad=58.1134p pd=77.985u as=58.1134p ps=77.985u w=76.465u l=1u
X6000 BAT GATE DVDD DVDD pfet_06v0 ad=58.1096p pd=77.98u as=58.1096p ps=77.98u w=76.46u l=1u
X6001 BAT GATE DVDD DVDD pfet_06v0 ad=35.511p pd=48.245u as=35.511p ps=48.245u w=46.725u l=1u
X6002 BAT GATE DVDD DVDD pfet_06v0 ad=35.511p pd=48.245u as=35.511p ps=48.245u w=46.725u l=1u
X6003 BAT GATE DVDD DVDD pfet_06v0 ad=49.3848p pd=66.5u as=49.3848p ps=66.5u w=64.98u l=1u
X6004 DVDD GATE BAT DVDD pfet_06v0 ad=58.1096p pd=77.98u as=58.1096p ps=77.98u w=76.46u l=1u
X6005 BAT GATE DVDD DVDD pfet_06v0 ad=35.511p pd=48.245u as=35.511p ps=48.245u w=46.725u l=1u
X6006 DVDD GATE BAT DVDD pfet_06v0 ad=58.1134p pd=77.985u as=58.1134p ps=77.985u w=76.465u l=1u
X6007 BAT GATE DVDD DVDD pfet_06v0 ad=35.511p pd=48.245u as=35.511p ps=48.245u w=46.725u l=1u
X6008 BAT GATE DVDD DVDD pfet_06v0 ad=58.1552p pd=78.04u as=71.92879p ps=0.15492m w=76.52u l=1u
X6009 DVDD GATE BAT DVDD pfet_06v0 ad=35.511p pd=48.245u as=35.511p ps=48.245u w=46.725u l=1u
X6010 BAT GATE DVDD DVDD pfet_06v0 ad=58.1134p pd=77.985u as=58.1134p ps=77.985u w=76.465u l=1u
X6011 DVDD GATE BAT DVDD pfet_06v0 ad=35.511p pd=48.245u as=35.511p ps=48.245u w=46.725u l=1u
X6012 BAT GATE DVDD DVDD pfet_06v0 ad=35.511p pd=48.245u as=35.511p ps=48.245u w=46.725u l=1u
X6013 DVDD GATE BAT DVDD pfet_06v0 ad=35.511p pd=48.245u as=35.511p ps=48.245u w=46.725u l=1u
X6014 BAT GATE DVDD DVDD pfet_06v0 ad=49.3848p pd=66.5u as=49.3848p ps=66.5u w=64.98u l=1u
X6015 DVDD GATE BAT DVDD pfet_06v0 ad=47.6862p pd=64.265u as=47.6862p ps=64.265u w=62.745u l=1u
X6016 BAT GATE DVDD DVDD pfet_06v0 ad=47.6862p pd=64.265u as=47.6862p ps=64.265u w=62.745u l=1u
X6017 DVDD GATE BAT DVDD pfet_06v0 ad=58.9803p pd=0.12737m as=47.6862p ps=64.265u w=62.745u l=1u
X6018 BAT GATE DVDD DVDD pfet_06v0 ad=35.511p pd=48.245u as=35.511p ps=48.245u w=46.725u l=1u
X6019 BAT GATE DVDD DVDD pfet_06v0 ad=35.511p pd=48.245u as=35.511p ps=48.245u w=46.725u l=1u
X6020 BAT GATE DVDD DVDD pfet_06v0 ad=47.6862p pd=64.265u as=47.6862p ps=64.265u w=62.745u l=1u
X6021 BAT GATE DVDD DVDD pfet_06v0 ad=35.511p pd=48.245u as=35.511p ps=48.245u w=46.725u l=1u
X6022 DVDD GATE BAT DVDD pfet_06v0 ad=35.511p pd=48.245u as=35.511p ps=48.245u w=46.725u l=1u
X6023 DVDD GATE BAT DVDD pfet_06v0 ad=71.8771p pd=0.15481m as=58.1134p ps=77.985u w=76.465u l=1u
X6024 BAT GATE DVDD DVDD pfet_06v0 ad=58.1134p pd=77.985u as=58.1134p ps=77.985u w=76.465u l=1u
X6025 BAT GATE DVDD DVDD pfet_06v0 ad=35.511p pd=48.245u as=43.9215p ps=95.32999u w=46.725u l=1u
X6026 BAT GATE DVDD DVDD pfet_06v0 ad=58.1134p pd=77.985u as=58.1134p ps=77.985u w=76.465u l=1u
X6027 DVDD GATE BAT DVDD pfet_06v0 ad=35.511p pd=48.245u as=35.511p ps=48.245u w=46.725u l=1u
X6028 DVDD GATE BAT DVDD pfet_06v0 ad=58.1134p pd=77.985u as=58.1134p ps=77.985u w=76.465u l=1u
X6029 BAT GATE DVDD DVDD pfet_06v0 ad=58.1134p pd=77.985u as=58.1134p ps=77.985u w=76.465u l=1u
X6030 DVDD GATE BAT DVDD pfet_06v0 ad=49.3848p pd=66.5u as=49.3848p ps=66.5u w=64.98u l=1u
X6031 BAT GATE DVDD DVDD pfet_06v0 ad=35.511p pd=48.245u as=43.9215p ps=95.32999u w=46.725u l=1u
X6032 BAT GATE DVDD DVDD pfet_06v0 ad=58.1134p pd=77.985u as=71.8771p ps=0.15481m w=76.465u l=1u
X6033 BAT GATE DVDD DVDD pfet_06v0 ad=35.5072p pd=48.24u as=35.5072p ps=48.24u w=46.72u l=1u
X6034 DVDD GATE BAT DVDD pfet_06v0 ad=58.1172p pd=77.99u as=58.1172p ps=77.99u w=76.47u l=1u
X6035 BAT GATE DVDD DVDD pfet_06v0 ad=35.511p pd=48.245u as=35.511p ps=48.245u w=46.725u l=1u
X6036 DVDD GATE BAT DVDD pfet_06v0 ad=47.6862p pd=64.265u as=47.6862p ps=64.265u w=62.745u l=1u
X6037 DVDD GATE BAT DVDD pfet_06v0 ad=43.9215p pd=95.32999u as=35.511p ps=48.245u w=46.725u l=1u
X6038 DVDD GATE BAT DVDD pfet_06v0 ad=35.511p pd=48.245u as=35.511p ps=48.245u w=46.725u l=1u
X6039 BAT GATE DVDD DVDD pfet_06v0 ad=58.1552p pd=78.04u as=71.92879p ps=0.15492m w=76.52u l=1u
X6040 BAT GATE DVDD DVDD pfet_06v0 ad=35.511p pd=48.245u as=43.9215p ps=95.32999u w=46.725u l=1u
X6041 DVDD GATE BAT DVDD pfet_06v0 ad=35.511p pd=48.245u as=35.511p ps=48.245u w=46.725u l=1u
X6042 BAT GATE DVDD DVDD pfet_06v0 ad=58.0754p pd=77.935u as=58.0754p ps=77.935u w=76.41499u l=1u
X6043 DVDD GATE BAT DVDD pfet_06v0 ad=47.6862p pd=64.265u as=47.6862p ps=64.265u w=62.745u l=1u
X6044 DVDD GATE BAT DVDD pfet_06v0 ad=58.1096p pd=77.98u as=58.1096p ps=77.98u w=76.46u l=1u
X6045 BAT GATE DVDD DVDD pfet_06v0 ad=35.511p pd=48.245u as=35.511p ps=48.245u w=46.725u l=1u
X6046 BAT GATE DVDD DVDD pfet_06v0 ad=35.511p pd=48.245u as=43.9215p ps=95.32999u w=46.725u l=1u
X6047 DVDD GATE BAT DVDD pfet_06v0 ad=35.511p pd=48.245u as=35.511p ps=48.245u w=46.725u l=1u
X6048 BAT GATE DVDD DVDD pfet_06v0 ad=58.0754p pd=77.935u as=58.0754p ps=77.935u w=76.41499u l=1u
X6049 BAT GATE DVDD DVDD pfet_06v0 ad=58.1134p pd=77.985u as=58.1134p ps=77.985u w=76.465u l=1u
X6050 DVDD GATE BAT DVDD pfet_06v0 ad=35.511p pd=48.245u as=35.511p ps=48.245u w=46.725u l=1u
X6051 BAT GATE DVDD DVDD pfet_06v0 ad=58.1134p pd=77.985u as=58.1134p ps=77.985u w=76.465u l=1u
X6052 BAT GATE DVDD DVDD pfet_06v0 ad=58.1172p pd=77.99u as=71.8818p ps=0.15482m w=76.47u l=1u
X6053 BAT GATE DVDD DVDD pfet_06v0 ad=58.1172p pd=77.99u as=58.1172p ps=77.99u w=76.47u l=1u
X6054 DVDD GATE BAT DVDD pfet_06v0 ad=58.1172p pd=77.99u as=58.1172p ps=77.99u w=76.47u l=1u
X6055 DVDD GATE BAT DVDD pfet_06v0 ad=35.511p pd=48.245u as=35.511p ps=48.245u w=46.725u l=1u
X6056 BAT GATE DVDD DVDD pfet_06v0 ad=35.511p pd=48.245u as=35.511p ps=48.245u w=46.725u l=1u
X6057 DVDD GATE BAT DVDD pfet_06v0 ad=71.92879p pd=0.15492m as=58.1552p ps=78.04u w=76.52u l=1u
X6058 DVDD GATE BAT DVDD pfet_06v0 ad=35.511p pd=48.245u as=35.511p ps=48.245u w=46.725u l=1u
X6059 DVDD GATE BAT DVDD pfet_06v0 ad=35.511p pd=48.245u as=35.511p ps=48.245u w=46.725u l=1u
X6060 BAT GATE DVDD DVDD pfet_06v0 ad=58.1134p pd=77.985u as=58.1134p ps=77.985u w=76.465u l=1u
X6061 BAT GATE DVDD DVDD pfet_06v0 ad=47.6862p pd=64.265u as=47.6862p ps=64.265u w=62.745u l=1u
X6062 DVDD GATE BAT DVDD pfet_06v0 ad=58.1134p pd=77.985u as=58.1134p ps=77.985u w=76.465u l=1u
X6063 BAT GATE DVDD DVDD pfet_06v0 ad=35.511p pd=48.245u as=43.9215p ps=95.32999u w=46.725u l=1u
X6064 DVDD GATE BAT DVDD pfet_06v0 ad=35.5072p pd=48.24u as=35.5072p ps=48.24u w=46.72u l=1u
X6065 BAT GATE DVDD DVDD pfet_06v0 ad=35.511p pd=48.245u as=43.9215p ps=95.32999u w=46.725u l=1u
X6066 BAT GATE DVDD DVDD pfet_06v0 ad=35.511p pd=48.245u as=35.511p ps=48.245u w=46.725u l=1u
X6067 BAT GATE DVDD DVDD pfet_06v0 ad=58.1134p pd=77.985u as=58.1134p ps=77.985u w=76.465u l=1u
X6068 BAT GATE DVDD DVDD pfet_06v0 ad=35.511p pd=48.245u as=35.511p ps=48.245u w=46.725u l=1u
X6069 BAT GATE DVDD DVDD pfet_06v0 ad=58.1134p pd=77.985u as=71.8771p ps=0.15481m w=76.465u l=1u
X6070 DVDD GATE BAT DVDD pfet_06v0 ad=58.1134p pd=77.985u as=58.1134p ps=77.985u w=76.465u l=1u
X6071 BAT GATE DVDD DVDD pfet_06v0 ad=58.1134p pd=77.985u as=58.1134p ps=77.985u w=76.465u l=1u
X6072 BAT GATE DVDD DVDD pfet_06v0 ad=58.1552p pd=78.04u as=71.92879p ps=0.15492m w=76.52u l=1u
X6073 DVDD GATE BAT DVDD pfet_06v0 ad=58.1134p pd=77.985u as=58.1134p ps=77.985u w=76.465u l=1u
X6074 BAT GATE DVDD DVDD pfet_06v0 ad=58.1552p pd=78.04u as=58.1552p ps=78.04u w=76.52u l=1u
X6075 BAT GATE DVDD DVDD pfet_06v0 ad=58.1134p pd=77.985u as=58.1134p ps=77.985u w=76.465u l=1u
X6076 DVDD GATE BAT DVDD pfet_06v0 ad=71.8771p pd=0.15481m as=58.1134p ps=77.985u w=76.465u l=1u
X6077 DVDD GATE BAT DVDD pfet_06v0 ad=35.511p pd=48.245u as=35.511p ps=48.245u w=46.725u l=1u
X6078 DVDD GATE BAT DVDD pfet_06v0 ad=58.1552p pd=78.04u as=58.1552p ps=78.04u w=76.52u l=1u
X6079 BAT GATE DVDD DVDD pfet_06v0 ad=35.511p pd=48.245u as=35.511p ps=48.245u w=46.725u l=1u
X6080 BAT GATE DVDD DVDD pfet_06v0 ad=58.1552p pd=78.04u as=58.1552p ps=78.04u w=76.52u l=1u
X6081 BAT GATE DVDD DVDD pfet_06v0 ad=35.511p pd=48.245u as=35.511p ps=48.245u w=46.725u l=1u
X6082 BAT GATE DVDD DVDD pfet_06v0 ad=35.511p pd=48.245u as=35.511p ps=48.245u w=46.725u l=1u
X6083 BAT GATE DVDD DVDD pfet_06v0 ad=58.1134p pd=77.985u as=71.8771p ps=0.15481m w=76.465u l=1u
X6084 DVDD GATE BAT DVDD pfet_06v0 ad=58.1134p pd=77.985u as=58.1134p ps=77.985u w=76.465u l=1u
X6085 BAT GATE DVDD DVDD pfet_06v0 ad=58.0754p pd=77.935u as=58.0754p ps=77.935u w=76.41499u l=1u
X6086 DVDD GATE BAT DVDD pfet_06v0 ad=58.1552p pd=78.04u as=58.1552p ps=78.04u w=76.52u l=1u
X6087 BAT GATE DVDD DVDD pfet_06v0 ad=35.511p pd=48.245u as=35.511p ps=48.245u w=46.725u l=1u
X6088 BAT GATE DVDD DVDD pfet_06v0 ad=58.1134p pd=77.985u as=58.1134p ps=77.985u w=76.465u l=1u
X6089 DVDD GATE BAT DVDD pfet_06v0 ad=49.3848p pd=66.5u as=49.3848p ps=66.5u w=64.98u l=1u
X6090 BAT GATE DVDD DVDD pfet_06v0 ad=35.511p pd=48.245u as=35.511p ps=48.245u w=46.725u l=1u
X6091 DVDD GATE BAT DVDD pfet_06v0 ad=58.1134p pd=77.985u as=58.1134p ps=77.985u w=76.465u l=1u
X6092 DVDD GATE BAT DVDD pfet_06v0 ad=58.1134p pd=77.985u as=58.1134p ps=77.985u w=76.465u l=1u
X6093 BAT GATE DVDD DVDD pfet_06v0 ad=58.1134p pd=77.985u as=71.8771p ps=0.15481m w=76.465u l=1u
X6094 BAT GATE DVDD DVDD pfet_06v0 ad=58.1096p pd=77.98u as=58.1096p ps=77.98u w=76.46u l=1u
X6095 DVDD GATE BAT DVDD pfet_06v0 ad=49.3848p pd=66.5u as=49.3848p ps=66.5u w=64.98u l=1u
X6096 DVDD GATE BAT DVDD pfet_06v0 ad=58.1096p pd=77.98u as=58.1096p ps=77.98u w=76.46u l=1u
X6097 DVDD GATE BAT DVDD pfet_06v0 ad=35.511p pd=48.245u as=35.511p ps=48.245u w=46.725u l=1u
X6098 DVDD GATE BAT DVDD pfet_06v0 ad=58.1134p pd=77.985u as=58.1134p ps=77.985u w=76.465u l=1u
X6099 BAT GATE DVDD DVDD pfet_06v0 ad=35.511p pd=48.245u as=35.511p ps=48.245u w=46.725u l=1u
X6100 DVDD GATE BAT DVDD pfet_06v0 ad=35.511p pd=48.245u as=35.511p ps=48.245u w=46.725u l=1u
X6101 DVDD GATE BAT DVDD pfet_06v0 ad=35.511p pd=48.245u as=35.511p ps=48.245u w=46.725u l=1u
X6102 BAT GATE DVDD DVDD pfet_06v0 ad=58.1134p pd=77.985u as=58.1134p ps=77.985u w=76.465u l=1u
X6103 BAT GATE DVDD DVDD pfet_06v0 ad=58.1134p pd=77.985u as=58.1134p ps=77.985u w=76.465u l=1u
X6104 BAT GATE DVDD DVDD pfet_06v0 ad=58.1134p pd=77.985u as=58.1134p ps=77.985u w=76.465u l=1u
X6105 DVDD GATE BAT DVDD pfet_06v0 ad=35.511p pd=48.245u as=35.511p ps=48.245u w=46.725u l=1u
X6106 BAT GATE DVDD DVDD pfet_06v0 ad=35.511p pd=48.245u as=35.511p ps=48.245u w=46.725u l=1u
X6107 BAT GATE DVDD DVDD pfet_06v0 ad=58.0754p pd=77.935u as=58.0754p ps=77.935u w=76.41499u l=1u
X6108 BAT GATE DVDD DVDD pfet_06v0 ad=58.1134p pd=77.985u as=58.1134p ps=77.985u w=76.465u l=1u
X6109 DVDD GATE BAT DVDD pfet_06v0 ad=71.8771p pd=0.15481m as=58.1134p ps=77.985u w=76.465u l=1u
X6110 DVDD GATE BAT DVDD pfet_06v0 ad=35.511p pd=48.245u as=35.511p ps=48.245u w=46.725u l=1u
X6111 DVDD GATE BAT DVDD pfet_06v0 ad=35.511p pd=48.245u as=35.511p ps=48.245u w=46.725u l=1u
X6112 BAT GATE DVDD DVDD pfet_06v0 ad=35.511p pd=48.245u as=35.511p ps=48.245u w=46.725u l=1u
X6113 BAT GATE DVDD DVDD pfet_06v0 ad=35.5072p pd=48.24u as=35.5072p ps=48.24u w=46.72u l=1u
X6114 BAT GATE DVDD DVDD pfet_06v0 ad=47.6862p pd=64.265u as=47.6862p ps=64.265u w=62.745u l=1u
X6115 BAT GATE DVDD DVDD pfet_06v0 ad=58.1096p pd=77.98u as=58.1096p ps=77.98u w=76.46u l=1u
X6116 DVDD GATE BAT DVDD pfet_06v0 ad=58.1134p pd=77.985u as=58.1134p ps=77.985u w=76.465u l=1u
X6117 DVDD GATE BAT DVDD pfet_06v0 ad=43.9215p pd=95.32999u as=35.511p ps=48.245u w=46.725u l=1u
X6118 DVDD GATE BAT DVDD pfet_06v0 ad=35.511p pd=48.245u as=35.511p ps=48.245u w=46.725u l=1u
X6119 BAT GATE DVDD DVDD pfet_06v0 ad=35.511p pd=48.245u as=43.9215p ps=95.32999u w=46.725u l=1u
X6120 DVDD GATE BAT DVDD pfet_06v0 ad=35.511p pd=48.245u as=35.511p ps=48.245u w=46.725u l=1u
X6121 BAT GATE DVDD DVDD pfet_06v0 ad=35.511p pd=48.245u as=35.511p ps=48.245u w=46.725u l=1u
X6122 DVDD GATE BAT DVDD pfet_06v0 ad=71.8301p pd=0.15471m as=58.0754p ps=77.935u w=76.41499u l=1u
X6123 BAT GATE DVDD DVDD pfet_06v0 ad=47.6862p pd=64.265u as=47.6862p ps=64.265u w=62.745u l=1u
X6124 BAT GATE DVDD DVDD pfet_06v0 ad=35.511p pd=48.245u as=35.511p ps=48.245u w=46.725u l=1u
X6125 DVDD GATE BAT DVDD pfet_06v0 ad=47.6862p pd=64.265u as=47.6862p ps=64.265u w=62.745u l=1u
X6126 BAT GATE DVDD DVDD pfet_06v0 ad=47.6862p pd=64.265u as=47.6862p ps=64.265u w=62.745u l=1u
X6127 BAT GATE DVDD DVDD pfet_06v0 ad=35.511p pd=48.245u as=35.511p ps=48.245u w=46.725u l=1u
X6128 DVDD GATE BAT DVDD pfet_06v0 ad=35.511p pd=48.245u as=35.511p ps=48.245u w=46.725u l=1u
X6129 BAT GATE DVDD DVDD pfet_06v0 ad=58.1172p pd=77.99u as=58.1172p ps=77.99u w=76.47u l=1u
X6130 BAT GATE DVDD DVDD pfet_06v0 ad=58.1134p pd=77.985u as=58.1134p ps=77.985u w=76.465u l=1u
X6131 BAT GATE DVDD DVDD pfet_06v0 ad=35.5072p pd=48.24u as=35.5072p ps=48.24u w=46.72u l=1u
X6132 DVDD GATE BAT DVDD pfet_06v0 ad=71.8771p pd=0.15481m as=58.1134p ps=77.985u w=76.465u l=1u
X6133 DVDD GATE BAT DVDD pfet_06v0 ad=58.1096p pd=77.98u as=58.1096p ps=77.98u w=76.46u l=1u
X6134 DVDD GATE BAT DVDD pfet_06v0 ad=58.9803p pd=0.12737m as=47.6862p ps=64.265u w=62.745u l=1u
X6135 BAT GATE DVDD DVDD pfet_06v0 ad=58.1134p pd=77.985u as=71.8771p ps=0.15481m w=76.465u l=1u
X6136 DVDD GATE BAT DVDD pfet_06v0 ad=58.1134p pd=77.985u as=58.1134p ps=77.985u w=76.465u l=1u
X6137 BAT GATE DVDD DVDD pfet_06v0 ad=49.3848p pd=66.5u as=49.3848p ps=66.5u w=64.98u l=1u
X6138 DVDD GATE BAT DVDD pfet_06v0 ad=35.511p pd=48.245u as=35.511p ps=48.245u w=46.725u l=1u
X6139 DVDD GATE BAT DVDD pfet_06v0 ad=35.5072p pd=48.24u as=35.5072p ps=48.24u w=46.72u l=1u
X6140 DVDD GATE BAT DVDD pfet_06v0 ad=71.8771p pd=0.15481m as=58.1134p ps=77.985u w=76.465u l=1u
X6141 BAT GATE DVDD DVDD pfet_06v0 ad=58.1134p pd=77.985u as=58.1134p ps=77.985u w=76.465u l=1u
X6142 DVDD GATE BAT DVDD pfet_06v0 ad=58.1552p pd=78.04u as=58.1552p ps=78.04u w=76.52u l=1u
X6143 DVDD GATE BAT DVDD pfet_06v0 ad=58.0754p pd=77.935u as=58.0754p ps=77.935u w=76.41499u l=1u
X6144 DVDD GATE BAT DVDD pfet_06v0 ad=58.1134p pd=77.985u as=58.1134p ps=77.985u w=76.465u l=1u
X6145 DVDD GATE BAT DVDD pfet_06v0 ad=58.1552p pd=78.04u as=58.1552p ps=78.04u w=76.52u l=1u
X6146 BAT GATE DVDD DVDD pfet_06v0 ad=35.511p pd=48.245u as=35.511p ps=48.245u w=46.725u l=1u
X6147 DVDD GATE BAT DVDD pfet_06v0 ad=58.0754p pd=77.935u as=58.0754p ps=77.935u w=76.41499u l=1u
X6148 BAT GATE DVDD DVDD pfet_06v0 ad=47.6862p pd=64.265u as=58.9803p ps=0.12737m w=62.745u l=1u
X6149 BAT GATE DVDD DVDD pfet_06v0 ad=58.1134p pd=77.985u as=71.8771p ps=0.15481m w=76.465u l=1u
X6150 BAT GATE DVDD DVDD pfet_06v0 ad=35.511p pd=48.245u as=35.511p ps=48.245u w=46.725u l=1u
X6151 BAT GATE DVDD DVDD pfet_06v0 ad=58.1134p pd=77.985u as=71.8771p ps=0.15481m w=76.465u l=1u
X6152 DVDD GATE BAT DVDD pfet_06v0 ad=43.9215p pd=95.32999u as=35.511p ps=48.245u w=46.725u l=1u
X6153 BAT GATE DVDD DVDD pfet_06v0 ad=35.511p pd=48.245u as=35.511p ps=48.245u w=46.725u l=1u
X6154 DVDD GATE BAT DVDD pfet_06v0 ad=58.1134p pd=77.985u as=58.1134p ps=77.985u w=76.465u l=1u
X6155 BAT GATE DVDD DVDD pfet_06v0 ad=47.6862p pd=64.265u as=47.6862p ps=64.265u w=62.745u l=1u
X6156 BAT GATE DVDD DVDD pfet_06v0 ad=35.511p pd=48.245u as=35.511p ps=48.245u w=46.725u l=1u
X6157 DVDD GATE BAT DVDD pfet_06v0 ad=47.6862p pd=64.265u as=47.6862p ps=64.265u w=62.745u l=1u
X6158 DVDD GATE BAT DVDD pfet_06v0 ad=58.1134p pd=77.985u as=58.1134p ps=77.985u w=76.465u l=1u
X6159 BAT GATE DVDD DVDD pfet_06v0 ad=35.511p pd=48.245u as=35.511p ps=48.245u w=46.725u l=1u
X6160 DVDD GATE BAT DVDD pfet_06v0 ad=58.1134p pd=77.985u as=58.1134p ps=77.985u w=76.465u l=1u
X6161 BAT GATE DVDD DVDD pfet_06v0 ad=35.511p pd=48.245u as=35.511p ps=48.245u w=46.725u l=1u
X6162 BAT GATE DVDD DVDD pfet_06v0 ad=35.511p pd=48.245u as=35.511p ps=48.245u w=46.725u l=1u
X6163 BAT GATE DVDD DVDD pfet_06v0 ad=58.1096p pd=77.98u as=58.1096p ps=77.98u w=76.46u l=1u
X6164 BAT GATE DVDD DVDD pfet_06v0 ad=58.1134p pd=77.985u as=58.1134p ps=77.985u w=76.465u l=1u
X6165 DVDD GATE BAT DVDD pfet_06v0 ad=35.511p pd=48.245u as=35.511p ps=48.245u w=46.725u l=1u
X6166 DVDD GATE BAT DVDD pfet_06v0 ad=49.3848p pd=66.5u as=49.3848p ps=66.5u w=64.98u l=1u
X6167 DVDD GATE BAT DVDD pfet_06v0 ad=35.511p pd=48.245u as=35.511p ps=48.245u w=46.725u l=1u
X6168 BAT GATE DVDD DVDD pfet_06v0 ad=35.5072p pd=48.24u as=35.5072p ps=48.24u w=46.72u l=1u
X6169 BAT GATE DVDD DVDD pfet_06v0 ad=35.511p pd=48.245u as=43.9215p ps=95.32999u w=46.725u l=1u
X6170 DVDD GATE BAT DVDD pfet_06v0 ad=58.1134p pd=77.985u as=58.1134p ps=77.985u w=76.465u l=1u
X6171 BAT GATE DVDD DVDD pfet_06v0 ad=35.511p pd=48.245u as=35.511p ps=48.245u w=46.725u l=1u
X6172 BAT GATE DVDD DVDD pfet_06v0 ad=35.511p pd=48.245u as=35.511p ps=48.245u w=46.725u l=1u
X6173 DVDD GATE BAT DVDD pfet_06v0 ad=58.1134p pd=77.985u as=58.1134p ps=77.985u w=76.465u l=1u
X6174 DVDD GATE BAT DVDD pfet_06v0 ad=35.511p pd=48.245u as=35.511p ps=48.245u w=46.725u l=1u
X6175 BAT GATE DVDD DVDD pfet_06v0 ad=35.511p pd=48.245u as=35.511p ps=48.245u w=46.725u l=1u
X6176 DVDD GATE BAT DVDD pfet_06v0 ad=58.1134p pd=77.985u as=58.1134p ps=77.985u w=76.465u l=1u
X6177 BAT GATE DVDD DVDD pfet_06v0 ad=58.1134p pd=77.985u as=58.1134p ps=77.985u w=76.465u l=1u
X6178 DVDD GATE BAT DVDD pfet_06v0 ad=43.9215p pd=95.32999u as=35.511p ps=48.245u w=46.725u l=1u
X6179 DVDD GATE BAT DVDD pfet_06v0 ad=58.1134p pd=77.985u as=58.1134p ps=77.985u w=76.465u l=1u
X6180 DVDD GATE BAT DVDD pfet_06v0 ad=58.1552p pd=78.04u as=58.1552p ps=78.04u w=76.52u l=1u
X6181 BAT GATE DVDD DVDD pfet_06v0 ad=35.511p pd=48.245u as=43.9215p ps=95.32999u w=46.725u l=1u
X6182 DVDD GATE BAT DVDD pfet_06v0 ad=35.511p pd=48.245u as=35.511p ps=48.245u w=46.725u l=1u
X6183 BAT GATE DVDD DVDD pfet_06v0 ad=58.1172p pd=77.99u as=58.1172p ps=77.99u w=76.47u l=1u
X6184 BAT GATE DVDD DVDD pfet_06v0 ad=58.1134p pd=77.985u as=71.8771p ps=0.15481m w=76.465u l=1u
X6185 DVDD GATE BAT DVDD pfet_06v0 ad=35.511p pd=48.245u as=35.511p ps=48.245u w=46.725u l=1u
X6186 DVDD GATE BAT DVDD pfet_06v0 ad=35.511p pd=48.245u as=35.511p ps=48.245u w=46.725u l=1u
X6187 DVDD GATE BAT DVDD pfet_06v0 ad=35.511p pd=48.245u as=35.511p ps=48.245u w=46.725u l=1u
X6188 BAT GATE DVDD DVDD pfet_06v0 ad=58.1134p pd=77.985u as=58.1134p ps=77.985u w=76.465u l=1u
X6189 BAT GATE DVDD DVDD pfet_06v0 ad=58.1134p pd=77.985u as=58.1134p ps=77.985u w=76.465u l=1u
X6190 BAT GATE DVDD DVDD pfet_06v0 ad=35.511p pd=48.245u as=35.511p ps=48.245u w=46.725u l=1u
X6191 BAT GATE DVDD DVDD pfet_06v0 ad=58.1134p pd=77.985u as=58.1134p ps=77.985u w=76.465u l=1u
X6192 BAT GATE DVDD DVDD pfet_06v0 ad=49.3848p pd=66.5u as=49.3848p ps=66.5u w=64.98u l=1u
X6193 DVDD GATE BAT DVDD pfet_06v0 ad=35.511p pd=48.245u as=35.511p ps=48.245u w=46.725u l=1u
X6194 BAT GATE DVDD DVDD pfet_06v0 ad=58.1134p pd=77.985u as=58.1134p ps=77.985u w=76.465u l=1u
X6195 BAT GATE DVDD DVDD pfet_06v0 ad=35.511p pd=48.245u as=35.511p ps=48.245u w=46.725u l=1u
X6196 BAT GATE DVDD DVDD pfet_06v0 ad=58.1134p pd=77.985u as=58.1134p ps=77.985u w=76.465u l=1u
X6197 DVDD GATE BAT DVDD pfet_06v0 ad=58.1134p pd=77.985u as=58.1134p ps=77.985u w=76.465u l=1u
X6198 DVDD GATE BAT DVDD pfet_06v0 ad=58.1096p pd=77.98u as=58.1096p ps=77.98u w=76.46u l=1u
X6199 BAT GATE DVDD DVDD pfet_06v0 ad=35.511p pd=48.245u as=35.511p ps=48.245u w=46.725u l=1u
X6200 DVDD GATE BAT DVDD pfet_06v0 ad=58.1134p pd=77.985u as=58.1134p ps=77.985u w=76.465u l=1u
X6201 DVDD GATE BAT DVDD pfet_06v0 ad=35.511p pd=48.245u as=35.511p ps=48.245u w=46.725u l=1u
X6202 DVDD GATE BAT DVDD pfet_06v0 ad=35.511p pd=48.245u as=35.511p ps=48.245u w=46.725u l=1u
X6203 BAT GATE DVDD DVDD pfet_06v0 ad=35.5072p pd=48.24u as=35.5072p ps=48.24u w=46.72u l=1u
X6204 BAT GATE DVDD DVDD pfet_06v0 ad=35.511p pd=48.245u as=35.511p ps=48.245u w=46.725u l=1u
X6205 DVDD GATE BAT DVDD pfet_06v0 ad=58.1134p pd=77.985u as=58.1134p ps=77.985u w=76.465u l=1u
X6206 DVDD GATE BAT DVDD pfet_06v0 ad=35.511p pd=48.245u as=35.511p ps=48.245u w=46.725u l=1u
X6207 DVDD GATE BAT DVDD pfet_06v0 ad=58.1134p pd=77.985u as=58.1134p ps=77.985u w=76.465u l=1u
X6208 BAT GATE DVDD DVDD pfet_06v0 ad=58.1552p pd=78.04u as=58.1552p ps=78.04u w=76.52u l=1u
X6209 BAT GATE DVDD DVDD pfet_06v0 ad=58.1172p pd=77.99u as=71.8818p ps=0.15482m w=76.47u l=1u
X6210 DVDD GATE BAT DVDD pfet_06v0 ad=58.1134p pd=77.985u as=58.1134p ps=77.985u w=76.465u l=1u
X6211 DVDD GATE BAT DVDD pfet_06v0 ad=47.6862p pd=64.265u as=47.6862p ps=64.265u w=62.745u l=1u
X6212 DVDD GATE BAT DVDD pfet_06v0 ad=35.5072p pd=48.24u as=35.5072p ps=48.24u w=46.72u l=1u
X6213 BAT GATE DVDD DVDD pfet_06v0 ad=58.1134p pd=77.985u as=58.1134p ps=77.985u w=76.465u l=1u
X6214 BAT GATE DVDD DVDD pfet_06v0 ad=35.511p pd=48.245u as=35.511p ps=48.245u w=46.725u l=1u
X6215 DVDD GATE BAT DVDD pfet_06v0 ad=71.8771p pd=0.15481m as=58.1134p ps=77.985u w=76.465u l=1u
X6216 BAT GATE DVDD DVDD pfet_06v0 ad=35.511p pd=48.245u as=43.9215p ps=95.32999u w=46.725u l=1u
X6217 DVDD GATE BAT DVDD pfet_06v0 ad=35.511p pd=48.245u as=35.511p ps=48.245u w=46.725u l=1u
X6218 BAT GATE DVDD DVDD pfet_06v0 ad=58.1134p pd=77.985u as=71.8771p ps=0.15481m w=76.465u l=1u
X6219 DVDD GATE BAT DVDD pfet_06v0 ad=43.9215p pd=95.32999u as=35.511p ps=48.245u w=46.725u l=1u
X6220 BAT GATE DVDD DVDD pfet_06v0 ad=35.511p pd=48.245u as=35.511p ps=48.245u w=46.725u l=1u
X6221 BAT GATE DVDD DVDD pfet_06v0 ad=58.1096p pd=77.98u as=58.1096p ps=77.98u w=76.46u l=1u
X6222 BAT GATE DVDD DVDD pfet_06v0 ad=58.1134p pd=77.985u as=58.1134p ps=77.985u w=76.465u l=1u
X6223 BAT GATE DVDD DVDD pfet_06v0 ad=47.6862p pd=64.265u as=47.6862p ps=64.265u w=62.745u l=1u
X6224 DVDD GATE BAT DVDD pfet_06v0 ad=58.1134p pd=77.985u as=58.1134p ps=77.985u w=76.465u l=1u
X6225 BAT GATE DVDD DVDD pfet_06v0 ad=49.3848p pd=66.5u as=61.0812p ps=0.13184m w=64.98u l=1u
X6226 BAT GATE DVDD DVDD pfet_06v0 ad=58.1134p pd=77.985u as=58.1134p ps=77.985u w=76.465u l=1u
X6227 BAT GATE DVDD DVDD pfet_06v0 ad=58.1096p pd=77.98u as=58.1096p ps=77.98u w=76.46u l=1u
X6228 BAT GATE DVDD DVDD pfet_06v0 ad=58.1134p pd=77.985u as=58.1134p ps=77.985u w=76.465u l=1u
X6229 DVDD GATE BAT DVDD pfet_06v0 ad=35.511p pd=48.245u as=35.511p ps=48.245u w=46.725u l=1u
X6230 DVDD GATE BAT DVDD pfet_06v0 ad=49.3848p pd=66.5u as=49.3848p ps=66.5u w=64.98u l=1u
X6231 DVDD GATE BAT DVDD pfet_06v0 ad=35.511p pd=48.245u as=35.511p ps=48.245u w=46.725u l=1u
X6232 BAT GATE DVDD DVDD pfet_06v0 ad=35.5072p pd=48.24u as=35.5072p ps=48.24u w=46.72u l=1u
X6233 DVDD GATE BAT DVDD pfet_06v0 ad=35.511p pd=48.245u as=35.511p ps=48.245u w=46.725u l=1u
X6234 DVDD GATE BAT DVDD pfet_06v0 ad=58.1172p pd=77.99u as=58.1172p ps=77.99u w=76.47u l=1u
X6235 BAT GATE DVDD DVDD pfet_06v0 ad=58.1134p pd=77.985u as=58.1134p ps=77.985u w=76.465u l=1u
X6236 BAT GATE DVDD DVDD pfet_06v0 ad=35.511p pd=48.245u as=35.511p ps=48.245u w=46.725u l=1u
X6237 DVDD GATE BAT DVDD pfet_06v0 ad=35.511p pd=48.245u as=35.511p ps=48.245u w=46.725u l=1u
X6238 BAT GATE DVDD DVDD pfet_06v0 ad=35.5072p pd=48.24u as=35.5072p ps=48.24u w=46.72u l=1u
X6239 DVDD GATE BAT DVDD pfet_06v0 ad=58.1134p pd=77.985u as=58.1134p ps=77.985u w=76.465u l=1u
X6240 DVDD GATE BAT DVDD pfet_06v0 ad=47.6862p pd=64.265u as=47.6862p ps=64.265u w=62.745u l=1u
X6241 DVDD GATE BAT DVDD pfet_06v0 ad=71.8771p pd=0.15481m as=58.1134p ps=77.985u w=76.465u l=1u
X6242 DVDD GATE BAT DVDD pfet_06v0 ad=35.511p pd=48.245u as=35.511p ps=48.245u w=46.725u l=1u
X6243 DVDD GATE BAT DVDD pfet_06v0 ad=58.1096p pd=77.98u as=58.1096p ps=77.98u w=76.46u l=1u
X6244 BAT GATE DVDD DVDD pfet_06v0 ad=58.1172p pd=77.99u as=58.1172p ps=77.99u w=76.47u l=1u
X6245 DVDD GATE BAT DVDD pfet_06v0 ad=35.511p pd=48.245u as=35.511p ps=48.245u w=46.725u l=1u
X6246 DVDD GATE BAT DVDD pfet_06v0 ad=58.1134p pd=77.985u as=58.1134p ps=77.985u w=76.465u l=1u
X6247 BAT GATE DVDD DVDD pfet_06v0 ad=35.511p pd=48.245u as=35.511p ps=48.245u w=46.725u l=1u
X6248 BAT GATE DVDD DVDD pfet_06v0 ad=35.5072p pd=48.24u as=35.5072p ps=48.24u w=46.72u l=1u
X6249 BAT GATE DVDD DVDD pfet_06v0 ad=35.511p pd=48.245u as=43.9215p ps=95.32999u w=46.725u l=1u
X6250 DVDD GATE BAT DVDD pfet_06v0 ad=58.1134p pd=77.985u as=58.1134p ps=77.985u w=76.465u l=1u
X6251 DVDD GATE BAT DVDD pfet_06v0 ad=35.511p pd=48.245u as=35.511p ps=48.245u w=46.725u l=1u
X6252 BAT GATE DVDD DVDD pfet_06v0 ad=35.511p pd=48.245u as=43.9215p ps=95.32999u w=46.725u l=1u
X6253 DVDD GATE BAT DVDD pfet_06v0 ad=43.9215p pd=95.32999u as=35.511p ps=48.245u w=46.725u l=1u
X6254 DVDD GATE BAT DVDD pfet_06v0 ad=35.5072p pd=48.24u as=35.5072p ps=48.24u w=46.72u l=1u
X6255 DVDD GATE BAT DVDD pfet_06v0 ad=58.1134p pd=77.985u as=58.1134p ps=77.985u w=76.465u l=1u
X6256 BAT GATE DVDD DVDD pfet_06v0 ad=35.511p pd=48.245u as=35.511p ps=48.245u w=46.725u l=1u
X6257 BAT GATE DVDD DVDD pfet_06v0 ad=35.511p pd=48.245u as=35.511p ps=48.245u w=46.725u l=1u
X6258 BAT GATE DVDD DVDD pfet_06v0 ad=58.1134p pd=77.985u as=58.1134p ps=77.985u w=76.465u l=1u
X6259 DVDD GATE BAT DVDD pfet_06v0 ad=58.0754p pd=77.935u as=58.0754p ps=77.935u w=76.41499u l=1u
X6260 BAT GATE DVDD DVDD pfet_06v0 ad=35.511p pd=48.245u as=35.511p ps=48.245u w=46.725u l=1u
X6261 BAT GATE DVDD DVDD pfet_06v0 ad=35.511p pd=48.245u as=35.511p ps=48.245u w=46.725u l=1u
X6262 DVDD GATE BAT DVDD pfet_06v0 ad=43.9215p pd=95.32999u as=35.511p ps=48.245u w=46.725u l=1u
X6263 BAT GATE DVDD DVDD pfet_06v0 ad=58.1552p pd=78.04u as=71.92879p ps=0.15492m w=76.52u l=1u
X6264 BAT GATE DVDD DVDD pfet_06v0 ad=58.1134p pd=77.985u as=58.1134p ps=77.985u w=76.465u l=1u
X6265 DVDD GATE BAT DVDD pfet_06v0 ad=35.511p pd=48.245u as=35.511p ps=48.245u w=46.725u l=1u
X6266 DVDD GATE BAT DVDD pfet_06v0 ad=58.1172p pd=77.99u as=58.1172p ps=77.99u w=76.47u l=1u
X6267 BAT GATE DVDD DVDD pfet_06v0 ad=35.511p pd=48.245u as=35.511p ps=48.245u w=46.725u l=1u
X6268 BAT GATE DVDD DVDD pfet_06v0 ad=58.1134p pd=77.985u as=58.1134p ps=77.985u w=76.465u l=1u
X6269 BAT GATE DVDD DVDD pfet_06v0 ad=58.1134p pd=77.985u as=58.1134p ps=77.985u w=76.465u l=1u
X6270 DVDD GATE BAT DVDD pfet_06v0 ad=35.511p pd=48.245u as=35.511p ps=48.245u w=46.725u l=1u
X6271 BAT GATE DVDD DVDD pfet_06v0 ad=35.511p pd=48.245u as=35.511p ps=48.245u w=46.725u l=1u
X6272 BAT GATE DVDD DVDD pfet_06v0 ad=58.1552p pd=78.04u as=58.1552p ps=78.04u w=76.52u l=1u
X6273 BAT GATE DVDD DVDD pfet_06v0 ad=35.5072p pd=48.24u as=43.9168p ps=95.32u w=46.72u l=1u
X6274 BAT GATE DVDD DVDD pfet_06v0 ad=58.1134p pd=77.985u as=71.8771p ps=0.15481m w=76.465u l=1u
X6275 DVDD GATE BAT DVDD pfet_06v0 ad=58.1172p pd=77.99u as=58.1172p ps=77.99u w=76.47u l=1u
X6276 DVDD GATE BAT DVDD pfet_06v0 ad=58.1134p pd=77.985u as=58.1134p ps=77.985u w=76.465u l=1u
X6277 BAT GATE DVDD DVDD pfet_06v0 ad=35.511p pd=48.245u as=35.511p ps=48.245u w=46.725u l=1u
X6278 DVDD GATE BAT DVDD pfet_06v0 ad=71.8771p pd=0.15481m as=58.1134p ps=77.985u w=76.465u l=1u
X6279 DVDD GATE BAT DVDD pfet_06v0 ad=71.8771p pd=0.15481m as=58.1134p ps=77.985u w=76.465u l=1u
X6280 DVDD GATE BAT DVDD pfet_06v0 ad=58.1134p pd=77.985u as=58.1134p ps=77.985u w=76.465u l=1u
X6281 DVDD GATE BAT DVDD pfet_06v0 ad=35.511p pd=48.245u as=35.511p ps=48.245u w=46.725u l=1u
X6282 DVDD GATE BAT DVDD pfet_06v0 ad=71.8771p pd=0.15481m as=58.1134p ps=77.985u w=76.465u l=1u
X6283 DVDD GATE BAT DVDD pfet_06v0 ad=71.8771p pd=0.15481m as=58.1134p ps=77.985u w=76.465u l=1u
X6284 DVDD GATE BAT DVDD pfet_06v0 ad=58.1134p pd=77.985u as=58.1134p ps=77.985u w=76.465u l=1u
X6285 DVDD GATE BAT DVDD pfet_06v0 ad=35.511p pd=48.245u as=35.511p ps=48.245u w=46.725u l=1u
X6286 BAT GATE DVDD DVDD pfet_06v0 ad=58.1134p pd=77.985u as=58.1134p ps=77.985u w=76.465u l=1u
X6287 DVDD GATE BAT DVDD pfet_06v0 ad=58.1134p pd=77.985u as=58.1134p ps=77.985u w=76.465u l=1u
X6288 DVDD GATE BAT DVDD pfet_06v0 ad=71.8818p pd=0.15482m as=58.1172p ps=77.99u w=76.47u l=1u
X6289 DVDD GATE BAT DVDD pfet_06v0 ad=58.1134p pd=77.985u as=58.1134p ps=77.985u w=76.465u l=1u
X6290 BAT GATE DVDD DVDD pfet_06v0 ad=58.1134p pd=77.985u as=58.1134p ps=77.985u w=76.465u l=1u
X6291 BAT GATE DVDD DVDD pfet_06v0 ad=58.1134p pd=77.985u as=58.1134p ps=77.985u w=76.465u l=1u
X6292 BAT GATE DVDD DVDD pfet_06v0 ad=58.1552p pd=78.04u as=58.1552p ps=78.04u w=76.52u l=1u
X6293 BAT GATE DVDD DVDD pfet_06v0 ad=35.511p pd=48.245u as=35.511p ps=48.245u w=46.725u l=1u
X6294 DVDD GATE BAT DVDD pfet_06v0 ad=71.8771p pd=0.15481m as=58.1134p ps=77.985u w=76.465u l=1u
X6295 BAT GATE DVDD DVDD pfet_06v0 ad=35.5072p pd=48.24u as=35.5072p ps=48.24u w=46.72u l=1u
X6296 DVDD GATE BAT DVDD pfet_06v0 ad=35.511p pd=48.245u as=35.511p ps=48.245u w=46.725u l=1u
X6297 DVDD GATE BAT DVDD pfet_06v0 ad=71.8771p pd=0.15481m as=58.1134p ps=77.985u w=76.465u l=1u
X6298 DVDD GATE BAT DVDD pfet_06v0 ad=58.1134p pd=77.985u as=58.1134p ps=77.985u w=76.465u l=1u
X6299 DVDD GATE BAT DVDD pfet_06v0 ad=71.8771p pd=0.15481m as=58.1134p ps=77.985u w=76.465u l=1u
X6300 BAT GATE DVDD DVDD pfet_06v0 ad=58.1134p pd=77.985u as=58.1134p ps=77.985u w=76.465u l=1u
X6301 DVDD GATE BAT DVDD pfet_06v0 ad=35.511p pd=48.245u as=35.511p ps=48.245u w=46.725u l=1u
X6302 BAT GATE DVDD DVDD pfet_06v0 ad=58.1134p pd=77.985u as=58.1134p ps=77.985u w=76.465u l=1u
X6303 BAT GATE DVDD DVDD pfet_06v0 ad=49.3848p pd=66.5u as=49.3848p ps=66.5u w=64.98u l=1u
X6304 DVDD GATE BAT DVDD pfet_06v0 ad=49.3848p pd=66.5u as=49.3848p ps=66.5u w=64.98u l=1u
X6305 BAT GATE DVDD DVDD pfet_06v0 ad=58.1134p pd=77.985u as=58.1134p ps=77.985u w=76.465u l=1u
X6306 DVDD GATE BAT DVDD pfet_06v0 ad=35.511p pd=48.245u as=35.511p ps=48.245u w=46.725u l=1u
X6307 DVDD GATE BAT DVDD pfet_06v0 ad=58.1552p pd=78.04u as=58.1552p ps=78.04u w=76.52u l=1u
X6308 DVDD GATE BAT DVDD pfet_06v0 ad=58.1134p pd=77.985u as=58.1134p ps=77.985u w=76.465u l=1u
X6309 DVDD GATE BAT DVDD pfet_06v0 ad=43.9215p pd=95.32999u as=35.511p ps=48.245u w=46.725u l=1u
X6310 DVDD GATE BAT DVDD pfet_06v0 ad=43.9215p pd=95.32999u as=35.511p ps=48.245u w=46.725u l=1u
X6311 BAT GATE DVDD DVDD pfet_06v0 ad=49.3848p pd=66.5u as=49.3848p ps=66.5u w=64.98u l=1u
X6312 BAT GATE DVDD DVDD pfet_06v0 ad=58.1134p pd=77.985u as=58.1134p ps=77.985u w=76.465u l=1u
X6313 BAT GATE DVDD DVDD pfet_06v0 ad=35.511p pd=48.245u as=35.511p ps=48.245u w=46.725u l=1u
X6314 BAT GATE DVDD DVDD pfet_06v0 ad=35.511p pd=48.245u as=35.511p ps=48.245u w=46.725u l=1u
X6315 BAT GATE DVDD DVDD pfet_06v0 ad=58.1096p pd=77.98u as=58.1096p ps=77.98u w=76.46u l=1u
X6316 BAT GATE DVDD DVDD pfet_06v0 ad=35.511p pd=48.245u as=35.511p ps=48.245u w=46.725u l=1u
X6317 BAT GATE DVDD DVDD pfet_06v0 ad=58.1096p pd=77.98u as=71.8724p ps=0.1548m w=76.46u l=1u
X6318 DVDD GATE BAT DVDD pfet_06v0 ad=71.8818p pd=0.15482m as=58.1172p ps=77.99u w=76.47u l=1u
X6319 DVDD GATE BAT DVDD pfet_06v0 ad=58.1096p pd=77.98u as=58.1096p ps=77.98u w=76.46u l=1u
X6320 BAT GATE DVDD DVDD pfet_06v0 ad=35.511p pd=48.245u as=43.9215p ps=95.32999u w=46.725u l=1u
X6321 BAT GATE DVDD DVDD pfet_06v0 ad=35.511p pd=48.245u as=43.9215p ps=95.32999u w=46.725u l=1u
X6322 BAT GATE DVDD DVDD pfet_06v0 ad=58.0754p pd=77.935u as=71.8301p ps=0.15471m w=76.41499u l=1u
X6323 DVDD GATE BAT DVDD pfet_06v0 ad=43.9215p pd=95.32999u as=35.511p ps=48.245u w=46.725u l=1u
X6324 BAT GATE DVDD DVDD pfet_06v0 ad=58.0754p pd=77.935u as=58.0754p ps=77.935u w=76.41499u l=1u
X6325 BAT GATE DVDD DVDD pfet_06v0 ad=35.5072p pd=48.24u as=43.9168p ps=95.32u w=46.72u l=1u
X6326 DVDD GATE BAT DVDD pfet_06v0 ad=43.9215p pd=95.32999u as=35.511p ps=48.245u w=46.725u l=1u
X6327 BAT GATE DVDD DVDD pfet_06v0 ad=35.511p pd=48.245u as=43.9215p ps=95.32999u w=46.725u l=1u
X6328 BAT GATE DVDD DVDD pfet_06v0 ad=35.511p pd=48.245u as=35.511p ps=48.245u w=46.725u l=1u
X6329 BAT GATE DVDD DVDD pfet_06v0 ad=58.0754p pd=77.935u as=58.0754p ps=77.935u w=76.41499u l=1u
X6330 BAT GATE DVDD DVDD pfet_06v0 ad=49.3848p pd=66.5u as=49.3848p ps=66.5u w=64.98u l=1u
X6331 DVDD GATE BAT DVDD pfet_06v0 ad=47.6862p pd=64.265u as=47.6862p ps=64.265u w=62.745u l=1u
X6332 DVDD GATE BAT DVDD pfet_06v0 ad=35.511p pd=48.245u as=35.511p ps=48.245u w=46.725u l=1u
X6333 BAT GATE DVDD DVDD pfet_06v0 ad=47.6862p pd=64.265u as=47.6862p ps=64.265u w=62.745u l=1u
X6334 DVDD GATE BAT DVDD pfet_06v0 ad=47.6862p pd=64.265u as=47.6862p ps=64.265u w=62.745u l=1u
X6335 DVDD GATE BAT DVDD pfet_06v0 ad=58.0754p pd=77.935u as=58.0754p ps=77.935u w=76.41499u l=1u
X6336 BAT GATE DVDD DVDD pfet_06v0 ad=35.511p pd=48.245u as=43.9215p ps=95.32999u w=46.725u l=1u
X6337 DVDD GATE BAT DVDD pfet_06v0 ad=35.511p pd=48.245u as=35.511p ps=48.245u w=46.725u l=1u
X6338 BAT GATE DVDD DVDD pfet_06v0 ad=35.511p pd=48.245u as=35.511p ps=48.245u w=46.725u l=1u
X6339 DVDD GATE BAT DVDD pfet_06v0 ad=58.1134p pd=77.985u as=58.1134p ps=77.985u w=76.465u l=1u
X6340 DVDD GATE BAT DVDD pfet_06v0 ad=58.1134p pd=77.985u as=58.1134p ps=77.985u w=76.465u l=1u
X6341 BAT GATE DVDD DVDD pfet_06v0 ad=35.511p pd=48.245u as=35.511p ps=48.245u w=46.725u l=1u
X6342 DVDD GATE BAT DVDD pfet_06v0 ad=43.9215p pd=95.32999u as=35.511p ps=48.245u w=46.725u l=1u
X6343 BAT GATE DVDD DVDD pfet_06v0 ad=58.1134p pd=77.985u as=58.1134p ps=77.985u w=76.465u l=1u
X6344 BAT GATE DVDD DVDD pfet_06v0 ad=58.1134p pd=77.985u as=58.1134p ps=77.985u w=76.465u l=1u
X6345 BAT GATE DVDD DVDD pfet_06v0 ad=47.6862p pd=64.265u as=47.6862p ps=64.265u w=62.745u l=1u
X6346 DVDD GATE BAT DVDD pfet_06v0 ad=58.1134p pd=77.985u as=58.1134p ps=77.985u w=76.465u l=1u
X6347 BAT GATE DVDD DVDD pfet_06v0 ad=35.511p pd=48.245u as=35.511p ps=48.245u w=46.725u l=1u
X6348 DVDD GATE BAT DVDD pfet_06v0 ad=35.511p pd=48.245u as=35.511p ps=48.245u w=46.725u l=1u
X6349 BAT GATE DVDD DVDD pfet_06v0 ad=58.1134p pd=77.985u as=58.1134p ps=77.985u w=76.465u l=1u
X6350 DVDD GATE BAT DVDD pfet_06v0 ad=49.3848p pd=66.5u as=49.3848p ps=66.5u w=64.98u l=1u
X6351 BAT GATE DVDD DVDD pfet_06v0 ad=35.511p pd=48.245u as=35.511p ps=48.245u w=46.725u l=1u
X6352 BAT GATE DVDD DVDD pfet_06v0 ad=35.5072p pd=48.24u as=35.5072p ps=48.24u w=46.72u l=1u
X6353 DVDD GATE BAT DVDD pfet_06v0 ad=58.1172p pd=77.99u as=58.1172p ps=77.99u w=76.47u l=1u
X6354 BAT GATE DVDD DVDD pfet_06v0 ad=35.511p pd=48.245u as=35.511p ps=48.245u w=46.725u l=1u
X6355 DVDD GATE BAT DVDD pfet_06v0 ad=58.1134p pd=77.985u as=58.1134p ps=77.985u w=76.465u l=1u
X6356 DVDD GATE BAT DVDD pfet_06v0 ad=35.5072p pd=48.24u as=35.5072p ps=48.24u w=46.72u l=1u
X6357 DVDD GATE BAT DVDD pfet_06v0 ad=35.511p pd=48.245u as=35.511p ps=48.245u w=46.725u l=1u
X6358 DVDD GATE BAT DVDD pfet_06v0 ad=35.511p pd=48.245u as=35.511p ps=48.245u w=46.725u l=1u
X6359 BAT GATE DVDD DVDD pfet_06v0 ad=58.1552p pd=78.04u as=58.1552p ps=78.04u w=76.52u l=1u
X6360 BAT GATE DVDD DVDD pfet_06v0 ad=58.1096p pd=77.98u as=58.1096p ps=77.98u w=76.46u l=1u
X6361 DVDD GATE BAT DVDD pfet_06v0 ad=58.1172p pd=77.99u as=58.1172p ps=77.99u w=76.47u l=1u
X6362 DVDD GATE BAT DVDD pfet_06v0 ad=35.511p pd=48.245u as=35.511p ps=48.245u w=46.725u l=1u
X6363 DVDD GATE BAT DVDD pfet_06v0 ad=71.92879p pd=0.15492m as=58.1552p ps=78.04u w=76.52u l=1u
X6364 BAT GATE DVDD DVDD pfet_06v0 ad=58.1134p pd=77.985u as=58.1134p ps=77.985u w=76.465u l=1u
X6365 BAT GATE DVDD DVDD pfet_06v0 ad=35.511p pd=48.245u as=35.511p ps=48.245u w=46.725u l=1u
X6366 DVDD GATE BAT DVDD pfet_06v0 ad=43.9168p pd=95.32u as=35.5072p ps=48.24u w=46.72u l=1u
X6367 BAT GATE DVDD DVDD pfet_06v0 ad=35.511p pd=48.245u as=35.511p ps=48.245u w=46.725u l=1u
X6368 DVDD GATE BAT DVDD pfet_06v0 ad=71.8771p pd=0.15481m as=58.1134p ps=77.985u w=76.465u l=1u
X6369 BAT GATE DVDD DVDD pfet_06v0 ad=58.0754p pd=77.935u as=58.0754p ps=77.935u w=76.41499u l=1u
X6370 BAT GATE DVDD DVDD pfet_06v0 ad=35.5072p pd=48.24u as=35.5072p ps=48.24u w=46.72u l=1u
X6371 BAT GATE DVDD DVDD pfet_06v0 ad=58.1134p pd=77.985u as=58.1134p ps=77.985u w=76.465u l=1u
X6372 BAT GATE DVDD DVDD pfet_06v0 ad=58.1134p pd=77.985u as=58.1134p ps=77.985u w=76.465u l=1u
X6373 DVDD GATE BAT DVDD pfet_06v0 ad=35.511p pd=48.245u as=35.511p ps=48.245u w=46.725u l=1u
X6374 BAT GATE DVDD DVDD pfet_06v0 ad=58.1134p pd=77.985u as=58.1134p ps=77.985u w=76.465u l=1u
X6375 BAT GATE DVDD DVDD pfet_06v0 ad=58.1172p pd=77.99u as=58.1172p ps=77.99u w=76.47u l=1u
X6376 DVDD GATE BAT DVDD pfet_06v0 ad=58.1552p pd=78.04u as=58.1552p ps=78.04u w=76.52u l=1u
X6377 DVDD GATE BAT DVDD pfet_06v0 ad=35.511p pd=48.245u as=35.511p ps=48.245u w=46.725u l=1u
X6378 BAT GATE DVDD DVDD pfet_06v0 ad=58.1134p pd=77.985u as=58.1134p ps=77.985u w=76.465u l=1u
X6379 BAT GATE DVDD DVDD pfet_06v0 ad=47.6862p pd=64.265u as=47.6862p ps=64.265u w=62.745u l=1u
X6380 DVDD GATE BAT DVDD pfet_06v0 ad=43.9215p pd=95.32999u as=35.511p ps=48.245u w=46.725u l=1u
X6381 BAT GATE DVDD DVDD pfet_06v0 ad=35.511p pd=48.245u as=35.511p ps=48.245u w=46.725u l=1u
X6382 BAT GATE DVDD DVDD pfet_06v0 ad=58.1134p pd=77.985u as=58.1134p ps=77.985u w=76.465u l=1u
X6383 BAT GATE DVDD DVDD pfet_06v0 ad=58.1134p pd=77.985u as=58.1134p ps=77.985u w=76.465u l=1u
X6384 DVDD GATE BAT DVDD pfet_06v0 ad=58.1134p pd=77.985u as=58.1134p ps=77.985u w=76.465u l=1u
X6385 BAT GATE DVDD DVDD pfet_06v0 ad=58.1134p pd=77.985u as=58.1134p ps=77.985u w=76.465u l=1u
X6386 DVDD GATE BAT DVDD pfet_06v0 ad=49.3848p pd=66.5u as=49.3848p ps=66.5u w=64.98u l=1u
X6387 DVDD GATE BAT DVDD pfet_06v0 ad=58.1134p pd=77.985u as=58.1134p ps=77.985u w=76.465u l=1u
X6388 BAT GATE DVDD DVDD pfet_06v0 ad=58.1096p pd=77.98u as=58.1096p ps=77.98u w=76.46u l=1u
X6389 DVDD GATE BAT DVDD pfet_06v0 ad=35.511p pd=48.245u as=35.511p ps=48.245u w=46.725u l=1u
X6390 BAT GATE DVDD DVDD pfet_06v0 ad=58.1134p pd=77.985u as=58.1134p ps=77.985u w=76.465u l=1u
X6391 BAT GATE DVDD DVDD pfet_06v0 ad=58.1134p pd=77.985u as=58.1134p ps=77.985u w=76.465u l=1u
X6392 BAT GATE DVDD DVDD pfet_06v0 ad=58.1134p pd=77.985u as=71.8771p ps=0.15481m w=76.465u l=1u
X6393 DVDD GATE BAT DVDD pfet_06v0 ad=58.1134p pd=77.985u as=58.1134p ps=77.985u w=76.465u l=1u
X6394 DVDD GATE BAT DVDD pfet_06v0 ad=35.511p pd=48.245u as=35.511p ps=48.245u w=46.725u l=1u
X6395 DVDD GATE BAT DVDD pfet_06v0 ad=58.1552p pd=78.04u as=58.1552p ps=78.04u w=76.52u l=1u
X6396 BAT GATE DVDD DVDD pfet_06v0 ad=35.511p pd=48.245u as=35.511p ps=48.245u w=46.725u l=1u
X6397 BAT GATE DVDD DVDD pfet_06v0 ad=35.511p pd=48.245u as=35.511p ps=48.245u w=46.725u l=1u
X6398 DVDD GATE BAT DVDD pfet_06v0 ad=71.8771p pd=0.15481m as=58.1134p ps=77.985u w=76.465u l=1u
X6399 BAT GATE DVDD DVDD pfet_06v0 ad=35.511p pd=48.245u as=35.511p ps=48.245u w=46.725u l=1u
X6400 BAT GATE DVDD DVDD pfet_06v0 ad=58.1552p pd=78.04u as=58.1552p ps=78.04u w=76.52u l=1u
X6401 BAT GATE DVDD DVDD pfet_06v0 ad=58.1134p pd=77.985u as=58.1134p ps=77.985u w=76.465u l=1u
X6402 BAT GATE DVDD DVDD pfet_06v0 ad=35.511p pd=48.245u as=35.511p ps=48.245u w=46.725u l=1u
X6403 BAT GATE DVDD DVDD pfet_06v0 ad=58.1134p pd=77.985u as=58.1134p ps=77.985u w=76.465u l=1u
X6404 DVDD GATE BAT DVDD pfet_06v0 ad=49.3848p pd=66.5u as=49.3848p ps=66.5u w=64.98u l=1u
X6405 BAT GATE DVDD DVDD pfet_06v0 ad=58.0754p pd=77.935u as=58.0754p ps=77.935u w=76.41499u l=1u
X6406 DVDD GATE BAT DVDD pfet_06v0 ad=58.1134p pd=77.985u as=58.1134p ps=77.985u w=76.465u l=1u
X6407 BAT GATE DVDD DVDD pfet_06v0 ad=47.6862p pd=64.265u as=47.6862p ps=64.265u w=62.745u l=1u
X6408 DVDD GATE BAT DVDD pfet_06v0 ad=49.3848p pd=66.5u as=49.3848p ps=66.5u w=64.98u l=1u
X6409 DVDD GATE BAT DVDD pfet_06v0 ad=35.511p pd=48.245u as=35.511p ps=48.245u w=46.725u l=1u
X6410 DVDD GATE BAT DVDD pfet_06v0 ad=58.9803p pd=0.12737m as=47.6862p ps=64.265u w=62.745u l=1u
X6411 DVDD GATE BAT DVDD pfet_06v0 ad=58.1134p pd=77.985u as=58.1134p ps=77.985u w=76.465u l=1u
X6412 DVDD GATE BAT DVDD pfet_06v0 ad=43.9215p pd=95.32999u as=35.511p ps=48.245u w=46.725u l=1u
X6413 DVDD GATE BAT DVDD pfet_06v0 ad=58.1134p pd=77.985u as=58.1134p ps=77.985u w=76.465u l=1u
X6414 BAT GATE DVDD DVDD pfet_06v0 ad=35.511p pd=48.245u as=35.511p ps=48.245u w=46.725u l=1u
X6415 DVDD GATE BAT DVDD pfet_06v0 ad=35.511p pd=48.245u as=35.511p ps=48.245u w=46.725u l=1u
X6416 DVDD GATE BAT DVDD pfet_06v0 ad=49.3848p pd=66.5u as=49.3848p ps=66.5u w=64.98u l=1u
X6417 BAT GATE DVDD DVDD pfet_06v0 ad=58.1096p pd=77.98u as=71.8724p ps=0.1548m w=76.46u l=1u
X6418 DVDD GATE BAT DVDD pfet_06v0 ad=71.8771p pd=0.15481m as=58.1134p ps=77.985u w=76.465u l=1u
X6419 DVDD GATE BAT DVDD pfet_06v0 ad=71.8771p pd=0.15481m as=58.1134p ps=77.985u w=76.465u l=1u
X6420 DVDD GATE BAT DVDD pfet_06v0 ad=35.511p pd=48.245u as=35.511p ps=48.245u w=46.725u l=1u
X6421 DVDD GATE BAT DVDD pfet_06v0 ad=35.5072p pd=48.24u as=35.5072p ps=48.24u w=46.72u l=1u
X6422 DVDD GATE BAT DVDD pfet_06v0 ad=35.511p pd=48.245u as=35.511p ps=48.245u w=46.725u l=1u
X6423 BAT GATE DVDD DVDD pfet_06v0 ad=58.1172p pd=77.99u as=58.1172p ps=77.99u w=76.47u l=1u
X6424 BAT GATE DVDD DVDD pfet_06v0 ad=58.1134p pd=77.985u as=58.1134p ps=77.985u w=76.465u l=1u
X6425 DVDD GATE BAT DVDD pfet_06v0 ad=49.3848p pd=66.5u as=49.3848p ps=66.5u w=64.98u l=1u
X6426 DVDD GATE BAT DVDD pfet_06v0 ad=35.511p pd=48.245u as=35.511p ps=48.245u w=46.725u l=1u
X6427 DVDD GATE BAT DVDD pfet_06v0 ad=35.511p pd=48.245u as=35.511p ps=48.245u w=46.725u l=1u
X6428 DVDD GATE BAT DVDD pfet_06v0 ad=35.511p pd=48.245u as=35.511p ps=48.245u w=46.725u l=1u
X6429 BAT GATE DVDD DVDD pfet_06v0 ad=58.1134p pd=77.985u as=58.1134p ps=77.985u w=76.465u l=1u
X6430 DVDD GATE BAT DVDD pfet_06v0 ad=58.9803p pd=0.12737m as=47.6862p ps=64.265u w=62.745u l=1u
X6431 BAT GATE DVDD DVDD pfet_06v0 ad=58.1134p pd=77.985u as=71.8771p ps=0.15481m w=76.465u l=1u
X6432 BAT GATE DVDD DVDD pfet_06v0 ad=58.0754p pd=77.935u as=71.8301p ps=0.15471m w=76.41499u l=1u
X6433 BAT GATE DVDD DVDD pfet_06v0 ad=35.5072p pd=48.24u as=43.9168p ps=95.32u w=46.72u l=1u
X6434 BAT GATE DVDD DVDD pfet_06v0 ad=47.6862p pd=64.265u as=47.6862p ps=64.265u w=62.745u l=1u
X6435 BAT GATE DVDD DVDD pfet_06v0 ad=58.1096p pd=77.98u as=58.1096p ps=77.98u w=76.46u l=1u
X6436 DVDD GATE BAT DVDD pfet_06v0 ad=43.9168p pd=95.32u as=35.5072p ps=48.24u w=46.72u l=1u
X6437 DVDD GATE BAT DVDD pfet_06v0 ad=35.511p pd=48.245u as=35.511p ps=48.245u w=46.725u l=1u
X6438 BAT GATE DVDD DVDD pfet_06v0 ad=58.1096p pd=77.98u as=71.8724p ps=0.1548m w=76.46u l=1u
X6439 BAT GATE DVDD DVDD pfet_06v0 ad=35.511p pd=48.245u as=43.9215p ps=95.32999u w=46.725u l=1u
X6440 DVDD GATE BAT DVDD pfet_06v0 ad=35.511p pd=48.245u as=35.511p ps=48.245u w=46.725u l=1u
X6441 DVDD GATE BAT DVDD pfet_06v0 ad=71.8771p pd=0.15481m as=58.1134p ps=77.985u w=76.465u l=1u
X6442 DVDD GATE BAT DVDD pfet_06v0 ad=43.9215p pd=95.32999u as=35.511p ps=48.245u w=46.725u l=1u
X6443 DVDD GATE BAT DVDD pfet_06v0 ad=58.0754p pd=77.935u as=58.0754p ps=77.935u w=76.41499u l=1u
X6444 BAT GATE DVDD DVDD pfet_06v0 ad=35.511p pd=48.245u as=35.511p ps=48.245u w=46.725u l=1u
X6445 BAT GATE DVDD DVDD pfet_06v0 ad=35.511p pd=48.245u as=43.9215p ps=95.32999u w=46.725u l=1u
X6446 BAT GATE DVDD DVDD pfet_06v0 ad=35.511p pd=48.245u as=35.511p ps=48.245u w=46.725u l=1u
X6447 BAT GATE DVDD DVDD pfet_06v0 ad=35.511p pd=48.245u as=35.511p ps=48.245u w=46.725u l=1u
X6448 DVDD GATE BAT DVDD pfet_06v0 ad=71.8818p pd=0.15482m as=58.1172p ps=77.99u w=76.47u l=1u
X6449 BAT GATE DVDD DVDD pfet_06v0 ad=35.5072p pd=48.24u as=43.9168p ps=95.32u w=46.72u l=1u
X6450 BAT GATE DVDD DVDD pfet_06v0 ad=58.1096p pd=77.98u as=58.1096p ps=77.98u w=76.46u l=1u
X6451 BAT GATE DVDD DVDD pfet_06v0 ad=58.1172p pd=77.99u as=58.1172p ps=77.99u w=76.47u l=1u
X6452 BAT GATE DVDD DVDD pfet_06v0 ad=35.511p pd=48.245u as=35.511p ps=48.245u w=46.725u l=1u
X6453 DVDD GATE BAT DVDD pfet_06v0 ad=71.8771p pd=0.15481m as=58.1134p ps=77.985u w=76.465u l=1u
X6454 BAT GATE DVDD DVDD pfet_06v0 ad=58.1134p pd=77.985u as=58.1134p ps=77.985u w=76.465u l=1u
X6455 BAT GATE DVDD DVDD pfet_06v0 ad=35.5072p pd=48.24u as=35.5072p ps=48.24u w=46.72u l=1u
X6456 DVDD GATE BAT DVDD pfet_06v0 ad=58.1096p pd=77.98u as=58.1096p ps=77.98u w=76.46u l=1u
X6457 DVDD GATE BAT DVDD pfet_06v0 ad=71.8771p pd=0.15481m as=58.1134p ps=77.985u w=76.465u l=1u
X6458 DVDD GATE BAT DVDD pfet_06v0 ad=47.6862p pd=64.265u as=47.6862p ps=64.265u w=62.745u l=1u
X6459 DVDD GATE BAT DVDD pfet_06v0 ad=58.1134p pd=77.985u as=58.1134p ps=77.985u w=76.465u l=1u
X6460 BAT GATE DVDD DVDD pfet_06v0 ad=49.3848p pd=66.5u as=49.3848p ps=66.5u w=64.98u l=1u
X6461 DVDD GATE BAT DVDD pfet_06v0 ad=35.511p pd=48.245u as=35.511p ps=48.245u w=46.725u l=1u
X6462 DVDD GATE BAT DVDD pfet_06v0 ad=35.511p pd=48.245u as=35.511p ps=48.245u w=46.725u l=1u
X6463 BAT GATE DVDD DVDD pfet_06v0 ad=35.511p pd=48.245u as=43.9215p ps=95.32999u w=46.725u l=1u
X6464 DVDD GATE BAT DVDD pfet_06v0 ad=35.5072p pd=48.24u as=35.5072p ps=48.24u w=46.72u l=1u
X6465 DVDD GATE BAT DVDD pfet_06v0 ad=58.1134p pd=77.985u as=58.1134p ps=77.985u w=76.465u l=1u
X6466 BAT GATE DVDD DVDD pfet_06v0 ad=58.1134p pd=77.985u as=58.1134p ps=77.985u w=76.465u l=1u
X6467 DVDD GATE BAT DVDD pfet_06v0 ad=58.1134p pd=77.985u as=58.1134p ps=77.985u w=76.465u l=1u
X6468 DVDD GATE BAT DVDD pfet_06v0 ad=58.1134p pd=77.985u as=58.1134p ps=77.985u w=76.465u l=1u
X6469 DVDD GATE BAT DVDD pfet_06v0 ad=58.1552p pd=78.04u as=58.1552p ps=78.04u w=76.52u l=1u
X6470 BAT GATE DVDD DVDD pfet_06v0 ad=35.511p pd=48.245u as=35.511p ps=48.245u w=46.725u l=1u
X6471 BAT GATE DVDD DVDD pfet_06v0 ad=58.1552p pd=78.04u as=58.1552p ps=78.04u w=76.52u l=1u
X6472 DVDD GATE BAT DVDD pfet_06v0 ad=71.92879p pd=0.15492m as=58.1552p ps=78.04u w=76.52u l=1u
X6473 BAT GATE DVDD DVDD pfet_06v0 ad=58.0754p pd=77.935u as=58.0754p ps=77.935u w=76.41499u l=1u
X6474 DVDD GATE BAT DVDD pfet_06v0 ad=58.1134p pd=77.985u as=58.1134p ps=77.985u w=76.465u l=1u
X6475 DVDD GATE BAT DVDD pfet_06v0 ad=35.511p pd=48.245u as=35.511p ps=48.245u w=46.725u l=1u
X6476 BAT GATE DVDD DVDD pfet_06v0 ad=35.5072p pd=48.24u as=35.5072p ps=48.24u w=46.72u l=1u
X6477 DVDD GATE BAT DVDD pfet_06v0 ad=35.511p pd=48.245u as=35.511p ps=48.245u w=46.725u l=1u
X6478 DVDD GATE BAT DVDD pfet_06v0 ad=35.5072p pd=48.24u as=35.5072p ps=48.24u w=46.72u l=1u
X6479 DVDD GATE BAT DVDD pfet_06v0 ad=58.1134p pd=77.985u as=58.1134p ps=77.985u w=76.465u l=1u
X6480 BAT GATE DVDD DVDD pfet_06v0 ad=58.1096p pd=77.98u as=71.8724p ps=0.1548m w=76.46u l=1u
X6481 DVDD GATE BAT DVDD pfet_06v0 ad=58.1134p pd=77.985u as=58.1134p ps=77.985u w=76.465u l=1u
X6482 BAT GATE DVDD DVDD pfet_06v0 ad=47.6862p pd=64.265u as=47.6862p ps=64.265u w=62.745u l=1u
X6483 BAT GATE DVDD DVDD pfet_06v0 ad=35.511p pd=48.245u as=43.9215p ps=95.32999u w=46.725u l=1u
X6484 BAT GATE DVDD DVDD pfet_06v0 ad=35.511p pd=48.245u as=35.511p ps=48.245u w=46.725u l=1u
X6485 DVDD GATE BAT DVDD pfet_06v0 ad=71.8301p pd=0.15471m as=58.0754p ps=77.935u w=76.41499u l=1u
X6486 BAT GATE DVDD DVDD pfet_06v0 ad=58.1134p pd=77.985u as=71.8771p ps=0.15481m w=76.465u l=1u
X6487 DVDD GATE BAT DVDD pfet_06v0 ad=58.1134p pd=77.985u as=58.1134p ps=77.985u w=76.465u l=1u
X6488 BAT GATE DVDD DVDD pfet_06v0 ad=58.1134p pd=77.985u as=58.1134p ps=77.985u w=76.465u l=1u
X6489 DVDD GATE BAT DVDD pfet_06v0 ad=58.1134p pd=77.985u as=58.1134p ps=77.985u w=76.465u l=1u
X6490 DVDD GATE BAT DVDD pfet_06v0 ad=43.9215p pd=95.32999u as=35.511p ps=48.245u w=46.725u l=1u
X6491 BAT GATE DVDD DVDD pfet_06v0 ad=35.511p pd=48.245u as=35.511p ps=48.245u w=46.725u l=1u
X6492 BAT GATE DVDD DVDD pfet_06v0 ad=35.511p pd=48.245u as=43.9215p ps=95.32999u w=46.725u l=1u
X6493 DVDD GATE BAT DVDD pfet_06v0 ad=58.1134p pd=77.985u as=58.1134p ps=77.985u w=76.465u l=1u
X6494 DVDD GATE BAT DVDD pfet_06v0 ad=58.1134p pd=77.985u as=58.1134p ps=77.985u w=76.465u l=1u
X6495 BAT GATE DVDD DVDD pfet_06v0 ad=49.3848p pd=66.5u as=49.3848p ps=66.5u w=64.98u l=1u
X6496 BAT GATE DVDD DVDD pfet_06v0 ad=58.1134p pd=77.985u as=58.1134p ps=77.985u w=76.465u l=1u
X6497 BAT GATE DVDD DVDD pfet_06v0 ad=35.511p pd=48.245u as=35.511p ps=48.245u w=46.725u l=1u
X6498 BAT GATE DVDD DVDD pfet_06v0 ad=49.3848p pd=66.5u as=49.3848p ps=66.5u w=64.98u l=1u
X6499 BAT GATE DVDD DVDD pfet_06v0 ad=58.1096p pd=77.98u as=58.1096p ps=77.98u w=76.46u l=1u
X6500 BAT GATE DVDD DVDD pfet_06v0 ad=58.1134p pd=77.985u as=58.1134p ps=77.985u w=76.465u l=1u
X6501 DVDD GATE BAT DVDD pfet_06v0 ad=35.511p pd=48.245u as=35.511p ps=48.245u w=46.725u l=1u
X6502 BAT GATE DVDD DVDD pfet_06v0 ad=35.511p pd=48.245u as=35.511p ps=48.245u w=46.725u l=1u
X6503 DVDD GATE BAT DVDD pfet_06v0 ad=43.9215p pd=95.32999u as=35.511p ps=48.245u w=46.725u l=1u
X6504 BAT GATE DVDD DVDD pfet_06v0 ad=35.511p pd=48.245u as=35.511p ps=48.245u w=46.725u l=1u
X6505 DVDD GATE BAT DVDD pfet_06v0 ad=58.1134p pd=77.985u as=58.1134p ps=77.985u w=76.465u l=1u
X6506 BAT GATE DVDD DVDD pfet_06v0 ad=35.511p pd=48.245u as=35.511p ps=48.245u w=46.725u l=1u
X6507 DVDD GATE BAT DVDD pfet_06v0 ad=35.511p pd=48.245u as=35.511p ps=48.245u w=46.725u l=1u
X6508 BAT GATE DVDD DVDD pfet_06v0 ad=35.511p pd=48.245u as=35.511p ps=48.245u w=46.725u l=1u
X6509 DVDD GATE BAT DVDD pfet_06v0 ad=58.1134p pd=77.985u as=58.1134p ps=77.985u w=76.465u l=1u
X6510 DVDD GATE BAT DVDD pfet_06v0 ad=43.9215p pd=95.32999u as=35.511p ps=48.245u w=46.725u l=1u
X6511 DVDD GATE BAT DVDD pfet_06v0 ad=61.0812p pd=0.13184m as=49.3848p ps=66.5u w=64.98u l=1u
X6512 DVDD GATE BAT DVDD pfet_06v0 ad=58.1134p pd=77.985u as=58.1134p ps=77.985u w=76.465u l=1u
X6513 BAT GATE DVDD DVDD pfet_06v0 ad=58.1134p pd=77.985u as=58.1134p ps=77.985u w=76.465u l=1u
X6514 DVDD GATE BAT DVDD pfet_06v0 ad=35.511p pd=48.245u as=35.511p ps=48.245u w=46.725u l=1u
X6515 DVDD GATE BAT DVDD pfet_06v0 ad=35.511p pd=48.245u as=35.511p ps=48.245u w=46.725u l=1u
X6516 BAT GATE DVDD DVDD pfet_06v0 ad=58.1172p pd=77.99u as=71.8818p ps=0.15482m w=76.47u l=1u
X6517 DVDD GATE BAT DVDD pfet_06v0 ad=71.8771p pd=0.15481m as=58.1134p ps=77.985u w=76.465u l=1u
X6518 BAT GATE DVDD DVDD pfet_06v0 ad=58.1134p pd=77.985u as=58.1134p ps=77.985u w=76.465u l=1u
X6519 DVDD GATE BAT DVDD pfet_06v0 ad=35.511p pd=48.245u as=35.511p ps=48.245u w=46.725u l=1u
X6520 BAT GATE DVDD DVDD pfet_06v0 ad=35.511p pd=48.245u as=43.9215p ps=95.32999u w=46.725u l=1u
X6521 BAT GATE DVDD DVDD pfet_06v0 ad=58.1134p pd=77.985u as=58.1134p ps=77.985u w=76.465u l=1u
X6522 BAT GATE DVDD DVDD pfet_06v0 ad=49.3848p pd=66.5u as=61.0812p ps=0.13184m w=64.98u l=1u
X6523 BAT GATE DVDD DVDD pfet_06v0 ad=58.1134p pd=77.985u as=71.8771p ps=0.15481m w=76.465u l=1u
X6524 DVDD GATE BAT DVDD pfet_06v0 ad=35.511p pd=48.245u as=35.511p ps=48.245u w=46.725u l=1u
X6525 BAT GATE DVDD DVDD pfet_06v0 ad=35.511p pd=48.245u as=35.511p ps=48.245u w=46.725u l=1u
X6526 BAT GATE DVDD DVDD pfet_06v0 ad=58.1134p pd=77.985u as=58.1134p ps=77.985u w=76.465u l=1u
X6527 BAT GATE DVDD DVDD pfet_06v0 ad=58.1552p pd=78.04u as=58.1552p ps=78.04u w=76.52u l=1u
X6528 BAT GATE DVDD DVDD pfet_06v0 ad=35.511p pd=48.245u as=35.511p ps=48.245u w=46.725u l=1u
X6529 BAT GATE DVDD DVDD pfet_06v0 ad=58.1134p pd=77.985u as=58.1134p ps=77.985u w=76.465u l=1u
X6530 BAT GATE DVDD DVDD pfet_06v0 ad=35.511p pd=48.245u as=35.511p ps=48.245u w=46.725u l=1u
X6531 BAT GATE DVDD DVDD pfet_06v0 ad=35.5072p pd=48.24u as=35.5072p ps=48.24u w=46.72u l=1u
X6532 BAT GATE DVDD DVDD pfet_06v0 ad=49.3848p pd=66.5u as=61.0812p ps=0.13184m w=64.98u l=1u
X6533 BAT GATE DVDD DVDD pfet_06v0 ad=35.511p pd=48.245u as=35.511p ps=48.245u w=46.725u l=1u
X6534 DVDD GATE BAT DVDD pfet_06v0 ad=58.1134p pd=77.985u as=58.1134p ps=77.985u w=76.465u l=1u
X6535 DVDD GATE BAT DVDD pfet_06v0 ad=58.1134p pd=77.985u as=58.1134p ps=77.985u w=76.465u l=1u
X6536 DVDD GATE BAT DVDD pfet_06v0 ad=58.1134p pd=77.985u as=58.1134p ps=77.985u w=76.465u l=1u
X6537 BAT GATE DVDD DVDD pfet_06v0 ad=35.511p pd=48.245u as=43.9215p ps=95.32999u w=46.725u l=1u
X6538 BAT GATE DVDD DVDD pfet_06v0 ad=58.1552p pd=78.04u as=58.1552p ps=78.04u w=76.52u l=1u
X6539 DVDD GATE BAT DVDD pfet_06v0 ad=43.9215p pd=95.32999u as=35.511p ps=48.245u w=46.725u l=1u
X6540 DVDD GATE BAT DVDD pfet_06v0 ad=47.6862p pd=64.265u as=47.6862p ps=64.265u w=62.745u l=1u
X6541 DVDD GATE BAT DVDD pfet_06v0 ad=43.9215p pd=95.32999u as=35.511p ps=48.245u w=46.725u l=1u
X6542 BAT GATE DVDD DVDD pfet_06v0 ad=35.511p pd=48.245u as=35.511p ps=48.245u w=46.725u l=1u
X6543 DVDD GATE BAT DVDD pfet_06v0 ad=58.1134p pd=77.985u as=58.1134p ps=77.985u w=76.465u l=1u
X6544 DVDD GATE BAT DVDD pfet_06v0 ad=58.1134p pd=77.985u as=58.1134p ps=77.985u w=76.465u l=1u
X6545 DVDD GATE BAT DVDD pfet_06v0 ad=58.1134p pd=77.985u as=58.1134p ps=77.985u w=76.465u l=1u
X6546 DVDD GATE BAT DVDD pfet_06v0 ad=35.511p pd=48.245u as=35.511p ps=48.245u w=46.725u l=1u
X6547 BAT GATE DVDD DVDD pfet_06v0 ad=58.1134p pd=77.985u as=58.1134p ps=77.985u w=76.465u l=1u
X6548 BAT GATE DVDD DVDD pfet_06v0 ad=35.511p pd=48.245u as=35.511p ps=48.245u w=46.725u l=1u
X6549 BAT GATE DVDD DVDD pfet_06v0 ad=58.1096p pd=77.98u as=58.1096p ps=77.98u w=76.46u l=1u
X6550 BAT GATE DVDD DVDD pfet_06v0 ad=58.1134p pd=77.985u as=71.8771p ps=0.15481m w=76.465u l=1u
X6551 DVDD GATE BAT DVDD pfet_06v0 ad=58.1096p pd=77.98u as=58.1096p ps=77.98u w=76.46u l=1u
X6552 BAT GATE DVDD DVDD pfet_06v0 ad=35.511p pd=48.245u as=35.511p ps=48.245u w=46.725u l=1u
X6553 BAT GATE DVDD DVDD pfet_06v0 ad=47.6862p pd=64.265u as=47.6862p ps=64.265u w=62.745u l=1u
X6554 DVDD GATE BAT DVDD pfet_06v0 ad=43.9215p pd=95.32999u as=35.511p ps=48.245u w=46.725u l=1u
X6555 DVDD GATE BAT DVDD pfet_06v0 ad=35.511p pd=48.245u as=35.511p ps=48.245u w=46.725u l=1u
X6556 BAT GATE DVDD DVDD pfet_06v0 ad=58.1134p pd=77.985u as=58.1134p ps=77.985u w=76.465u l=1u
X6557 DVDD GATE BAT DVDD pfet_06v0 ad=49.3848p pd=66.5u as=49.3848p ps=66.5u w=64.98u l=1u
X6558 BAT GATE DVDD DVDD pfet_06v0 ad=35.511p pd=48.245u as=35.511p ps=48.245u w=46.725u l=1u
X6559 DVDD GATE BAT DVDD pfet_06v0 ad=71.8771p pd=0.15481m as=58.1134p ps=77.985u w=76.465u l=1u
X6560 BAT GATE DVDD DVDD pfet_06v0 ad=58.1134p pd=77.985u as=58.1134p ps=77.985u w=76.465u l=1u
X6561 BAT GATE DVDD DVDD pfet_06v0 ad=58.1134p pd=77.985u as=58.1134p ps=77.985u w=76.465u l=1u
X6562 DVDD GATE BAT DVDD pfet_06v0 ad=71.8724p pd=0.1548m as=58.1096p ps=77.98u w=76.46u l=1u
X6563 DVDD GATE BAT DVDD pfet_06v0 ad=49.3848p pd=66.5u as=49.3848p ps=66.5u w=64.98u l=1u
X6564 DVDD GATE BAT DVDD pfet_06v0 ad=71.8771p pd=0.15481m as=58.1134p ps=77.985u w=76.465u l=1u
X6565 BAT GATE DVDD DVDD pfet_06v0 ad=58.1096p pd=77.98u as=58.1096p ps=77.98u w=76.46u l=1u
X6566 BAT GATE DVDD DVDD pfet_06v0 ad=58.0754p pd=77.935u as=71.8301p ps=0.15471m w=76.41499u l=1u
X6567 BAT GATE DVDD DVDD pfet_06v0 ad=58.1134p pd=77.985u as=58.1134p ps=77.985u w=76.465u l=1u
X6568 DVDD GATE BAT DVDD pfet_06v0 ad=35.511p pd=48.245u as=35.511p ps=48.245u w=46.725u l=1u
X6569 DVDD GATE BAT DVDD pfet_06v0 ad=35.511p pd=48.245u as=35.511p ps=48.245u w=46.725u l=1u
X6570 DVDD GATE BAT DVDD pfet_06v0 ad=43.9215p pd=95.32999u as=35.511p ps=48.245u w=46.725u l=1u
X6571 BAT GATE DVDD DVDD pfet_06v0 ad=58.1134p pd=77.985u as=58.1134p ps=77.985u w=76.465u l=1u
X6572 BAT GATE DVDD DVDD pfet_06v0 ad=35.511p pd=48.245u as=35.511p ps=48.245u w=46.725u l=1u
X6573 BAT GATE DVDD DVDD pfet_06v0 ad=35.511p pd=48.245u as=35.511p ps=48.245u w=46.725u l=1u
X6574 DVDD GATE BAT DVDD pfet_06v0 ad=58.1134p pd=77.985u as=58.1134p ps=77.985u w=76.465u l=1u
X6575 DVDD GATE BAT DVDD pfet_06v0 ad=58.1172p pd=77.99u as=58.1172p ps=77.99u w=76.47u l=1u
X6576 BAT GATE DVDD DVDD pfet_06v0 ad=58.1552p pd=78.04u as=58.1552p ps=78.04u w=76.52u l=1u
X6577 DVDD GATE BAT DVDD pfet_06v0 ad=35.511p pd=48.245u as=35.511p ps=48.245u w=46.725u l=1u
X6578 DVDD GATE BAT DVDD pfet_06v0 ad=35.511p pd=48.245u as=35.511p ps=48.245u w=46.725u l=1u
X6579 BAT GATE DVDD DVDD pfet_06v0 ad=35.511p pd=48.245u as=35.511p ps=48.245u w=46.725u l=1u
X6580 DVDD GATE BAT DVDD pfet_06v0 ad=58.1134p pd=77.985u as=58.1134p ps=77.985u w=76.465u l=1u
X6581 DVDD GATE BAT DVDD pfet_06v0 ad=58.1134p pd=77.985u as=58.1134p ps=77.985u w=76.465u l=1u
X6582 BAT GATE DVDD DVDD pfet_06v0 ad=58.1134p pd=77.985u as=71.8771p ps=0.15481m w=76.465u l=1u
X6583 BAT GATE DVDD DVDD pfet_06v0 ad=58.1172p pd=77.99u as=58.1172p ps=77.99u w=76.47u l=1u
X6584 DVDD GATE BAT DVDD pfet_06v0 ad=35.511p pd=48.245u as=35.511p ps=48.245u w=46.725u l=1u
X6585 BAT GATE DVDD DVDD pfet_06v0 ad=35.5072p pd=48.24u as=43.9168p ps=95.32u w=46.72u l=1u
X6586 BAT GATE DVDD DVDD pfet_06v0 ad=58.1172p pd=77.99u as=58.1172p ps=77.99u w=76.47u l=1u
X6587 BAT GATE DVDD DVDD pfet_06v0 ad=35.511p pd=48.245u as=35.511p ps=48.245u w=46.725u l=1u
X6588 BAT GATE DVDD DVDD pfet_06v0 ad=58.1134p pd=77.985u as=58.1134p ps=77.985u w=76.465u l=1u
X6589 DVDD GATE BAT DVDD pfet_06v0 ad=58.1134p pd=77.985u as=58.1134p ps=77.985u w=76.465u l=1u
X6590 DVDD GATE BAT DVDD pfet_06v0 ad=71.8771p pd=0.15481m as=58.1134p ps=77.985u w=76.465u l=1u
X6591 DVDD GATE BAT DVDD pfet_06v0 ad=58.1134p pd=77.985u as=58.1134p ps=77.985u w=76.465u l=1u
X6592 DVDD GATE BAT DVDD pfet_06v0 ad=35.511p pd=48.245u as=35.511p ps=48.245u w=46.725u l=1u
X6593 DVDD GATE BAT DVDD pfet_06v0 ad=58.1134p pd=77.985u as=58.1134p ps=77.985u w=76.465u l=1u
X6594 DVDD GATE BAT DVDD pfet_06v0 ad=35.511p pd=48.245u as=35.511p ps=48.245u w=46.725u l=1u
X6595 BAT GATE DVDD DVDD pfet_06v0 ad=58.1134p pd=77.985u as=58.1134p ps=77.985u w=76.465u l=1u
X6596 BAT GATE DVDD DVDD pfet_06v0 ad=58.1134p pd=77.985u as=58.1134p ps=77.985u w=76.465u l=1u
X6597 BAT GATE DVDD DVDD pfet_06v0 ad=58.1134p pd=77.985u as=58.1134p ps=77.985u w=76.465u l=1u
X6598 DVDD GATE BAT DVDD pfet_06v0 ad=58.0754p pd=77.935u as=58.0754p ps=77.935u w=76.41499u l=1u
X6599 DVDD GATE BAT DVDD pfet_06v0 ad=58.1552p pd=78.04u as=58.1552p ps=78.04u w=76.52u l=1u
X6600 DVDD GATE BAT DVDD pfet_06v0 ad=43.9215p pd=95.32999u as=35.511p ps=48.245u w=46.725u l=1u
X6601 BAT GATE DVDD DVDD pfet_06v0 ad=35.511p pd=48.245u as=35.511p ps=48.245u w=46.725u l=1u
X6602 BAT GATE DVDD DVDD pfet_06v0 ad=35.511p pd=48.245u as=35.511p ps=48.245u w=46.725u l=1u
X6603 BAT GATE DVDD DVDD pfet_06v0 ad=58.1134p pd=77.985u as=58.1134p ps=77.985u w=76.465u l=1u
X6604 BAT GATE DVDD DVDD pfet_06v0 ad=58.1172p pd=77.99u as=58.1172p ps=77.99u w=76.47u l=1u
X6605 DVDD GATE BAT DVDD pfet_06v0 ad=35.511p pd=48.245u as=35.511p ps=48.245u w=46.725u l=1u
X6606 BAT GATE DVDD DVDD pfet_06v0 ad=58.1134p pd=77.985u as=58.1134p ps=77.985u w=76.465u l=1u
X6607 DVDD GATE BAT DVDD pfet_06v0 ad=58.1172p pd=77.99u as=58.1172p ps=77.99u w=76.47u l=1u
X6608 DVDD GATE BAT DVDD pfet_06v0 ad=71.92879p pd=0.15492m as=58.1552p ps=78.04u w=76.52u l=1u
X6609 BAT GATE DVDD DVDD pfet_06v0 ad=58.1134p pd=77.985u as=58.1134p ps=77.985u w=76.465u l=1u
X6610 DVDD GATE BAT DVDD pfet_06v0 ad=43.9215p pd=95.32999u as=35.511p ps=48.245u w=46.725u l=1u
X6611 DVDD GATE BAT DVDD pfet_06v0 ad=35.511p pd=48.245u as=35.511p ps=48.245u w=46.725u l=1u
X6612 BAT GATE DVDD DVDD pfet_06v0 ad=35.511p pd=48.245u as=35.511p ps=48.245u w=46.725u l=1u
X6613 BAT GATE DVDD DVDD pfet_06v0 ad=58.1552p pd=78.04u as=58.1552p ps=78.04u w=76.52u l=1u
X6614 DVDD GATE BAT DVDD pfet_06v0 ad=71.8771p pd=0.15481m as=58.1134p ps=77.985u w=76.465u l=1u
X6615 BAT GATE DVDD DVDD pfet_06v0 ad=35.511p pd=48.245u as=35.511p ps=48.245u w=46.725u l=1u
X6616 DVDD GATE BAT DVDD pfet_06v0 ad=58.1134p pd=77.985u as=58.1134p ps=77.985u w=76.465u l=1u
X6617 DVDD GATE BAT DVDD pfet_06v0 ad=58.1552p pd=78.04u as=58.1552p ps=78.04u w=76.52u l=1u
X6618 DVDD GATE BAT DVDD pfet_06v0 ad=35.511p pd=48.245u as=35.511p ps=48.245u w=46.725u l=1u
X6619 BAT GATE DVDD DVDD pfet_06v0 ad=35.511p pd=48.245u as=35.511p ps=48.245u w=46.725u l=1u
X6620 DVDD GATE BAT DVDD pfet_06v0 ad=58.1134p pd=77.985u as=58.1134p ps=77.985u w=76.465u l=1u
X6621 DVDD GATE BAT DVDD pfet_06v0 ad=58.1134p pd=77.985u as=58.1134p ps=77.985u w=76.465u l=1u
X6622 DVDD GATE BAT DVDD pfet_06v0 ad=58.1134p pd=77.985u as=58.1134p ps=77.985u w=76.465u l=1u
X6623 DVDD GATE BAT DVDD pfet_06v0 ad=58.1096p pd=77.98u as=58.1096p ps=77.98u w=76.46u l=1u
X6624 BAT GATE DVDD DVDD pfet_06v0 ad=58.1134p pd=77.985u as=58.1134p ps=77.985u w=76.465u l=1u
X6625 BAT GATE DVDD DVDD pfet_06v0 ad=58.1552p pd=78.04u as=58.1552p ps=78.04u w=76.52u l=1u
X6626 BAT GATE DVDD DVDD pfet_06v0 ad=35.511p pd=48.245u as=43.9215p ps=95.32999u w=46.725u l=1u
X6627 BAT GATE DVDD DVDD pfet_06v0 ad=35.5072p pd=48.24u as=35.5072p ps=48.24u w=46.72u l=1u
X6628 DVDD GATE BAT DVDD pfet_06v0 ad=35.511p pd=48.245u as=35.511p ps=48.245u w=46.725u l=1u
X6629 DVDD GATE BAT DVDD pfet_06v0 ad=71.8724p pd=0.1548m as=58.1096p ps=77.98u w=76.46u l=1u
X6630 DVDD GATE BAT DVDD pfet_06v0 ad=58.1134p pd=77.985u as=58.1134p ps=77.985u w=76.465u l=1u
X6631 DVDD GATE BAT DVDD pfet_06v0 ad=58.1134p pd=77.985u as=58.1134p ps=77.985u w=76.465u l=1u
X6632 DVDD GATE BAT DVDD pfet_06v0 ad=58.0754p pd=77.935u as=58.0754p ps=77.935u w=76.41499u l=1u
X6633 BAT GATE DVDD DVDD pfet_06v0 ad=58.1134p pd=77.985u as=58.1134p ps=77.985u w=76.465u l=1u
X6634 BAT GATE DVDD DVDD pfet_06v0 ad=35.511p pd=48.245u as=35.511p ps=48.245u w=46.725u l=1u
X6635 BAT GATE DVDD DVDD pfet_06v0 ad=49.3848p pd=66.5u as=49.3848p ps=66.5u w=64.98u l=1u
X6636 BAT GATE DVDD DVDD pfet_06v0 ad=58.1134p pd=77.985u as=71.8771p ps=0.15481m w=76.465u l=1u
X6637 BAT GATE DVDD DVDD pfet_06v0 ad=58.1134p pd=77.985u as=71.8771p ps=0.15481m w=76.465u l=1u
X6638 BAT GATE DVDD DVDD pfet_06v0 ad=35.511p pd=48.245u as=35.511p ps=48.245u w=46.725u l=1u
X6639 DVDD GATE BAT DVDD pfet_06v0 ad=58.1552p pd=78.04u as=58.1552p ps=78.04u w=76.52u l=1u
X6640 DVDD GATE BAT DVDD pfet_06v0 ad=35.511p pd=48.245u as=35.511p ps=48.245u w=46.725u l=1u
X6641 BAT GATE DVDD DVDD pfet_06v0 ad=35.511p pd=48.245u as=35.511p ps=48.245u w=46.725u l=1u
X6642 BAT GATE DVDD DVDD pfet_06v0 ad=58.0754p pd=77.935u as=58.0754p ps=77.935u w=76.41499u l=1u
X6643 BAT GATE DVDD DVDD pfet_06v0 ad=58.1134p pd=77.985u as=58.1134p ps=77.985u w=76.465u l=1u
X6644 DVDD GATE BAT DVDD pfet_06v0 ad=35.511p pd=48.245u as=35.511p ps=48.245u w=46.725u l=1u
X6645 BAT GATE DVDD DVDD pfet_06v0 ad=35.511p pd=48.245u as=35.511p ps=48.245u w=46.725u l=1u
X6646 BAT GATE DVDD DVDD pfet_06v0 ad=58.1134p pd=77.985u as=58.1134p ps=77.985u w=76.465u l=1u
X6647 DVDD GATE BAT DVDD pfet_06v0 ad=35.511p pd=48.245u as=35.511p ps=48.245u w=46.725u l=1u
X6648 BAT GATE DVDD DVDD pfet_06v0 ad=58.1134p pd=77.985u as=58.1134p ps=77.985u w=76.465u l=1u
X6649 BAT GATE DVDD DVDD pfet_06v0 ad=58.1134p pd=77.985u as=58.1134p ps=77.985u w=76.465u l=1u
X6650 BAT GATE DVDD DVDD pfet_06v0 ad=58.1096p pd=77.98u as=58.1096p ps=77.98u w=76.46u l=1u
X6651 BAT GATE DVDD DVDD pfet_06v0 ad=35.511p pd=48.245u as=35.511p ps=48.245u w=46.725u l=1u
X6652 BAT GATE DVDD DVDD pfet_06v0 ad=35.511p pd=48.245u as=35.511p ps=48.245u w=46.725u l=1u
X6653 DVDD GATE BAT DVDD pfet_06v0 ad=58.1134p pd=77.985u as=58.1134p ps=77.985u w=76.465u l=1u
X6654 BAT GATE DVDD DVDD pfet_06v0 ad=35.511p pd=48.245u as=35.511p ps=48.245u w=46.725u l=1u
X6655 DVDD GATE BAT DVDD pfet_06v0 ad=58.1172p pd=77.99u as=58.1172p ps=77.99u w=76.47u l=1u
X6656 DVDD GATE BAT DVDD pfet_06v0 ad=58.1096p pd=77.98u as=58.1096p ps=77.98u w=76.46u l=1u
X6657 BAT GATE DVDD DVDD pfet_06v0 ad=47.6862p pd=64.265u as=47.6862p ps=64.265u w=62.745u l=1u
X6658 DVDD GATE BAT DVDD pfet_06v0 ad=35.5072p pd=48.24u as=35.5072p ps=48.24u w=46.72u l=1u
X6659 DVDD GATE BAT DVDD pfet_06v0 ad=43.9215p pd=95.32999u as=35.511p ps=48.245u w=46.725u l=1u
X6660 BAT GATE DVDD DVDD pfet_06v0 ad=35.511p pd=48.245u as=35.511p ps=48.245u w=46.725u l=1u
X6661 BAT GATE DVDD DVDD pfet_06v0 ad=35.511p pd=48.245u as=35.511p ps=48.245u w=46.725u l=1u
X6662 DVDD GATE BAT DVDD pfet_06v0 ad=35.511p pd=48.245u as=35.511p ps=48.245u w=46.725u l=1u
X6663 BAT GATE DVDD DVDD pfet_06v0 ad=35.5072p pd=48.24u as=35.5072p ps=48.24u w=46.72u l=1u
X6664 DVDD GATE BAT DVDD pfet_06v0 ad=35.511p pd=48.245u as=35.511p ps=48.245u w=46.725u l=1u
X6665 BAT GATE DVDD DVDD pfet_06v0 ad=58.1134p pd=77.985u as=58.1134p ps=77.985u w=76.465u l=1u
X6666 BAT GATE DVDD DVDD pfet_06v0 ad=58.1096p pd=77.98u as=58.1096p ps=77.98u w=76.46u l=1u
X6667 BAT GATE DVDD DVDD pfet_06v0 ad=58.0754p pd=77.935u as=58.0754p ps=77.935u w=76.41499u l=1u
X6668 BAT GATE DVDD DVDD pfet_06v0 ad=49.3848p pd=66.5u as=61.0812p ps=0.13184m w=64.98u l=1u
X6669 DVDD GATE BAT DVDD pfet_06v0 ad=58.1096p pd=77.98u as=58.1096p ps=77.98u w=76.46u l=1u
X6670 DVDD GATE BAT DVDD pfet_06v0 ad=58.1552p pd=78.04u as=58.1552p ps=78.04u w=76.52u l=1u
X6671 DVDD GATE BAT DVDD pfet_06v0 ad=47.6862p pd=64.265u as=47.6862p ps=64.265u w=62.745u l=1u
X6672 BAT GATE DVDD DVDD pfet_06v0 ad=35.511p pd=48.245u as=35.511p ps=48.245u w=46.725u l=1u
X6673 DVDD GATE BAT DVDD pfet_06v0 ad=35.511p pd=48.245u as=35.511p ps=48.245u w=46.725u l=1u
X6674 BAT GATE DVDD DVDD pfet_06v0 ad=35.511p pd=48.245u as=35.511p ps=48.245u w=46.725u l=1u
X6675 DVDD GATE BAT DVDD pfet_06v0 ad=35.511p pd=48.245u as=35.511p ps=48.245u w=46.725u l=1u
X6676 DVDD GATE BAT DVDD pfet_06v0 ad=71.8771p pd=0.15481m as=58.1134p ps=77.985u w=76.465u l=1u
X6677 DVDD GATE BAT DVDD pfet_06v0 ad=58.1134p pd=77.985u as=58.1134p ps=77.985u w=76.465u l=1u
X6678 DVDD GATE BAT DVDD pfet_06v0 ad=35.511p pd=48.245u as=35.511p ps=48.245u w=46.725u l=1u
X6679 BAT GATE DVDD DVDD pfet_06v0 ad=58.1134p pd=77.985u as=58.1134p ps=77.985u w=76.465u l=1u
X6680 DVDD GATE BAT DVDD pfet_06v0 ad=58.1134p pd=77.985u as=58.1134p ps=77.985u w=76.465u l=1u
X6681 DVDD GATE BAT DVDD pfet_06v0 ad=35.5072p pd=48.24u as=35.5072p ps=48.24u w=46.72u l=1u
X6682 BAT GATE DVDD DVDD pfet_06v0 ad=58.1134p pd=77.985u as=58.1134p ps=77.985u w=76.465u l=1u
X6683 BAT GATE DVDD DVDD pfet_06v0 ad=47.6862p pd=64.265u as=47.6862p ps=64.265u w=62.745u l=1u
X6684 BAT GATE DVDD DVDD pfet_06v0 ad=58.1134p pd=77.985u as=58.1134p ps=77.985u w=76.465u l=1u
X6685 DVDD GATE BAT DVDD pfet_06v0 ad=49.3848p pd=66.5u as=49.3848p ps=66.5u w=64.98u l=1u
X6686 DVDD GATE BAT DVDD pfet_06v0 ad=35.511p pd=48.245u as=35.511p ps=48.245u w=46.725u l=1u
X6687 BAT GATE DVDD DVDD pfet_06v0 ad=35.511p pd=48.245u as=35.511p ps=48.245u w=46.725u l=1u
X6688 DVDD GATE BAT DVDD pfet_06v0 ad=58.1172p pd=77.99u as=58.1172p ps=77.99u w=76.47u l=1u
X6689 DVDD GATE BAT DVDD pfet_06v0 ad=35.511p pd=48.245u as=35.511p ps=48.245u w=46.725u l=1u
X6690 BAT GATE DVDD DVDD pfet_06v0 ad=35.511p pd=48.245u as=35.511p ps=48.245u w=46.725u l=1u
X6691 BAT GATE DVDD DVDD pfet_06v0 ad=58.1134p pd=77.985u as=58.1134p ps=77.985u w=76.465u l=1u
X6692 DVDD GATE BAT DVDD pfet_06v0 ad=58.1134p pd=77.985u as=58.1134p ps=77.985u w=76.465u l=1u
X6693 DVDD GATE BAT DVDD pfet_06v0 ad=58.1134p pd=77.985u as=58.1134p ps=77.985u w=76.465u l=1u
X6694 BAT GATE DVDD DVDD pfet_06v0 ad=58.1552p pd=78.04u as=58.1552p ps=78.04u w=76.52u l=1u
X6695 BAT GATE DVDD DVDD pfet_06v0 ad=58.1134p pd=77.985u as=58.1134p ps=77.985u w=76.465u l=1u
X6696 DVDD GATE BAT DVDD pfet_06v0 ad=58.1552p pd=78.04u as=58.1552p ps=78.04u w=76.52u l=1u
X6697 DVDD GATE BAT DVDD pfet_06v0 ad=35.511p pd=48.245u as=35.511p ps=48.245u w=46.725u l=1u
X6698 DVDD GATE BAT DVDD pfet_06v0 ad=35.5072p pd=48.24u as=35.5072p ps=48.24u w=46.72u l=1u
X6699 BAT GATE DVDD DVDD pfet_06v0 ad=35.511p pd=48.245u as=35.511p ps=48.245u w=46.725u l=1u
X6700 BAT GATE DVDD DVDD pfet_06v0 ad=35.511p pd=48.245u as=35.511p ps=48.245u w=46.725u l=1u
X6701 DVDD GATE BAT DVDD pfet_06v0 ad=58.1134p pd=77.985u as=58.1134p ps=77.985u w=76.465u l=1u
X6702 BAT GATE DVDD DVDD pfet_06v0 ad=58.0754p pd=77.935u as=58.0754p ps=77.935u w=76.41499u l=1u
X6703 BAT GATE DVDD DVDD pfet_06v0 ad=35.5072p pd=48.24u as=43.9168p ps=95.32u w=46.72u l=1u
X6704 BAT GATE DVDD DVDD pfet_06v0 ad=58.1134p pd=77.985u as=58.1134p ps=77.985u w=76.465u l=1u
X6705 BAT GATE DVDD DVDD pfet_06v0 ad=58.1134p pd=77.985u as=58.1134p ps=77.985u w=76.465u l=1u
X6706 BAT GATE DVDD DVDD pfet_06v0 ad=35.511p pd=48.245u as=35.511p ps=48.245u w=46.725u l=1u
X6707 DVDD GATE BAT DVDD pfet_06v0 ad=58.1134p pd=77.985u as=58.1134p ps=77.985u w=76.465u l=1u
X6708 BAT GATE DVDD DVDD pfet_06v0 ad=58.0754p pd=77.935u as=58.0754p ps=77.935u w=76.41499u l=1u
X6709 BAT GATE DVDD DVDD pfet_06v0 ad=35.511p pd=48.245u as=35.511p ps=48.245u w=46.725u l=1u
X6710 BAT GATE DVDD DVDD pfet_06v0 ad=58.1172p pd=77.99u as=58.1172p ps=77.99u w=76.47u l=1u
X6711 BAT GATE DVDD DVDD pfet_06v0 ad=35.511p pd=48.245u as=35.511p ps=48.245u w=46.725u l=1u
X6712 BAT GATE DVDD DVDD pfet_06v0 ad=58.1552p pd=78.04u as=58.1552p ps=78.04u w=76.52u l=1u
X6713 BAT GATE DVDD DVDD pfet_06v0 ad=58.1134p pd=77.985u as=71.8771p ps=0.15481m w=76.465u l=1u
X6714 DVDD GATE BAT DVDD pfet_06v0 ad=58.1552p pd=78.04u as=58.1552p ps=78.04u w=76.52u l=1u
X6715 BAT GATE DVDD DVDD pfet_06v0 ad=58.1134p pd=77.985u as=58.1134p ps=77.985u w=76.465u l=1u
X6716 BAT GATE DVDD DVDD pfet_06v0 ad=58.1134p pd=77.985u as=58.1134p ps=77.985u w=76.465u l=1u
X6717 DVDD GATE BAT DVDD pfet_06v0 ad=35.511p pd=48.245u as=35.511p ps=48.245u w=46.725u l=1u
X6718 BAT GATE DVDD DVDD pfet_06v0 ad=58.1134p pd=77.985u as=58.1134p ps=77.985u w=76.465u l=1u
X6719 BAT GATE DVDD DVDD pfet_06v0 ad=35.511p pd=48.245u as=35.511p ps=48.245u w=46.725u l=1u
X6720 DVDD GATE BAT DVDD pfet_06v0 ad=35.511p pd=48.245u as=35.511p ps=48.245u w=46.725u l=1u
X6721 DVDD GATE BAT DVDD pfet_06v0 ad=49.3848p pd=66.5u as=49.3848p ps=66.5u w=64.98u l=1u
X6722 BAT GATE DVDD DVDD pfet_06v0 ad=58.1134p pd=77.985u as=58.1134p ps=77.985u w=76.465u l=1u
X6723 DVDD GATE BAT DVDD pfet_06v0 ad=49.3848p pd=66.5u as=49.3848p ps=66.5u w=64.98u l=1u
X6724 BAT GATE DVDD DVDD pfet_06v0 ad=35.511p pd=48.245u as=35.511p ps=48.245u w=46.725u l=1u
X6725 DVDD GATE BAT DVDD pfet_06v0 ad=35.511p pd=48.245u as=35.511p ps=48.245u w=46.725u l=1u
X6726 DVDD GATE BAT DVDD pfet_06v0 ad=58.1134p pd=77.985u as=58.1134p ps=77.985u w=76.465u l=1u
X6727 BAT GATE DVDD DVDD pfet_06v0 ad=58.1134p pd=77.985u as=58.1134p ps=77.985u w=76.465u l=1u
X6728 DVDD GATE BAT DVDD pfet_06v0 ad=43.9215p pd=95.32999u as=35.511p ps=48.245u w=46.725u l=1u
X6729 BAT GATE DVDD DVDD pfet_06v0 ad=35.511p pd=48.245u as=35.511p ps=48.245u w=46.725u l=1u
X6730 BAT GATE DVDD DVDD pfet_06v0 ad=58.1096p pd=77.98u as=58.1096p ps=77.98u w=76.46u l=1u
X6731 DVDD GATE BAT DVDD pfet_06v0 ad=35.511p pd=48.245u as=35.511p ps=48.245u w=46.725u l=1u
X6732 DVDD GATE BAT DVDD pfet_06v0 ad=71.8771p pd=0.15481m as=58.1134p ps=77.985u w=76.465u l=1u
X6733 DVDD GATE BAT DVDD pfet_06v0 ad=35.511p pd=48.245u as=35.511p ps=48.245u w=46.725u l=1u
X6734 DVDD GATE BAT DVDD pfet_06v0 ad=58.1552p pd=78.04u as=58.1552p ps=78.04u w=76.52u l=1u
X6735 BAT GATE DVDD DVDD pfet_06v0 ad=35.511p pd=48.245u as=43.9215p ps=95.32999u w=46.725u l=1u
X6736 BAT GATE DVDD DVDD pfet_06v0 ad=58.1552p pd=78.04u as=71.92879p ps=0.15492m w=76.52u l=1u
X6737 DVDD GATE BAT DVDD pfet_06v0 ad=49.3848p pd=66.5u as=49.3848p ps=66.5u w=64.98u l=1u
X6738 BAT GATE DVDD DVDD pfet_06v0 ad=58.1134p pd=77.985u as=58.1134p ps=77.985u w=76.465u l=1u
X6739 BAT GATE DVDD DVDD pfet_06v0 ad=35.511p pd=48.245u as=43.9215p ps=95.32999u w=46.725u l=1u
X6740 DVDD GATE BAT DVDD pfet_06v0 ad=43.9215p pd=95.32999u as=35.511p ps=48.245u w=46.725u l=1u
X6741 BAT GATE DVDD DVDD pfet_06v0 ad=58.1134p pd=77.985u as=71.8771p ps=0.15481m w=76.465u l=1u
X6742 BAT GATE DVDD DVDD pfet_06v0 ad=35.511p pd=48.245u as=35.511p ps=48.245u w=46.725u l=1u
X6743 BAT GATE DVDD DVDD pfet_06v0 ad=58.1134p pd=77.985u as=58.1134p ps=77.985u w=76.465u l=1u
X6744 DVDD GATE BAT DVDD pfet_06v0 ad=49.3848p pd=66.5u as=49.3848p ps=66.5u w=64.98u l=1u
X6745 BAT GATE DVDD DVDD pfet_06v0 ad=58.0754p pd=77.935u as=58.0754p ps=77.935u w=76.41499u l=1u
X6746 BAT GATE DVDD DVDD pfet_06v0 ad=47.6862p pd=64.265u as=47.6862p ps=64.265u w=62.745u l=1u
X6747 BAT GATE DVDD DVDD pfet_06v0 ad=35.511p pd=48.245u as=35.511p ps=48.245u w=46.725u l=1u
X6748 DVDD GATE BAT DVDD pfet_06v0 ad=58.9803p pd=0.12737m as=47.6862p ps=64.265u w=62.745u l=1u
X6749 BAT GATE DVDD DVDD pfet_06v0 ad=58.0754p pd=77.935u as=58.0754p ps=77.935u w=76.41499u l=1u
X6750 DVDD GATE BAT DVDD pfet_06v0 ad=35.511p pd=48.245u as=35.511p ps=48.245u w=46.725u l=1u
X6751 DVDD GATE BAT DVDD pfet_06v0 ad=43.9215p pd=95.32999u as=35.511p ps=48.245u w=46.725u l=1u
X6752 DVDD GATE BAT DVDD pfet_06v0 ad=58.1134p pd=77.985u as=58.1134p ps=77.985u w=76.465u l=1u
X6753 BAT GATE DVDD DVDD pfet_06v0 ad=58.1134p pd=77.985u as=58.1134p ps=77.985u w=76.465u l=1u
X6754 DVDD GATE BAT DVDD pfet_06v0 ad=35.511p pd=48.245u as=35.511p ps=48.245u w=46.725u l=1u
X6755 DVDD GATE BAT DVDD pfet_06v0 ad=58.1134p pd=77.985u as=58.1134p ps=77.985u w=76.465u l=1u
X6756 DVDD GATE BAT DVDD pfet_06v0 ad=58.1134p pd=77.985u as=58.1134p ps=77.985u w=76.465u l=1u
X6757 BAT GATE DVDD DVDD pfet_06v0 ad=35.511p pd=48.245u as=35.511p ps=48.245u w=46.725u l=1u
X6758 DVDD GATE BAT DVDD pfet_06v0 ad=35.511p pd=48.245u as=35.511p ps=48.245u w=46.725u l=1u
X6759 BAT GATE DVDD DVDD pfet_06v0 ad=35.511p pd=48.245u as=35.511p ps=48.245u w=46.725u l=1u
X6760 DVDD GATE BAT DVDD pfet_06v0 ad=43.9215p pd=95.32999u as=35.511p ps=48.245u w=46.725u l=1u
X6761 DVDD GATE BAT DVDD pfet_06v0 ad=35.5072p pd=48.24u as=35.5072p ps=48.24u w=46.72u l=1u
X6762 BAT GATE DVDD DVDD pfet_06v0 ad=58.1172p pd=77.99u as=58.1172p ps=77.99u w=76.47u l=1u
X6763 DVDD GATE BAT DVDD pfet_06v0 ad=43.9215p pd=95.32999u as=35.511p ps=48.245u w=46.725u l=1u
X6764 BAT GATE DVDD DVDD pfet_06v0 ad=58.1134p pd=77.985u as=58.1134p ps=77.985u w=76.465u l=1u
X6765 BAT GATE DVDD DVDD pfet_06v0 ad=35.5072p pd=48.24u as=35.5072p ps=48.24u w=46.72u l=1u
X6766 BAT GATE DVDD DVDD pfet_06v0 ad=58.1134p pd=77.985u as=71.8771p ps=0.15481m w=76.465u l=1u
X6767 DVDD GATE BAT DVDD pfet_06v0 ad=47.6862p pd=64.265u as=47.6862p ps=64.265u w=62.745u l=1u
X6768 BAT GATE DVDD DVDD pfet_06v0 ad=35.511p pd=48.245u as=35.511p ps=48.245u w=46.725u l=1u
X6769 BAT GATE DVDD DVDD pfet_06v0 ad=35.511p pd=48.245u as=35.511p ps=48.245u w=46.725u l=1u
X6770 DVDD GATE BAT DVDD pfet_06v0 ad=58.1552p pd=78.04u as=58.1552p ps=78.04u w=76.52u l=1u
X6771 BAT GATE DVDD DVDD pfet_06v0 ad=47.6862p pd=64.265u as=47.6862p ps=64.265u w=62.745u l=1u
X6772 DVDD GATE BAT DVDD pfet_06v0 ad=43.9215p pd=95.32999u as=35.511p ps=48.245u w=46.725u l=1u
X6773 DVDD GATE BAT DVDD pfet_06v0 ad=35.511p pd=48.245u as=35.511p ps=48.245u w=46.725u l=1u
X6774 DVDD GATE BAT DVDD pfet_06v0 ad=35.5072p pd=48.24u as=35.5072p ps=48.24u w=46.72u l=1u
X6775 DVDD GATE BAT DVDD pfet_06v0 ad=35.511p pd=48.245u as=35.511p ps=48.245u w=46.725u l=1u
X6776 DVDD GATE BAT DVDD pfet_06v0 ad=43.9215p pd=95.32999u as=35.511p ps=48.245u w=46.725u l=1u
X6777 DVDD GATE BAT DVDD pfet_06v0 ad=58.1134p pd=77.985u as=58.1134p ps=77.985u w=76.465u l=1u
X6778 DVDD GATE BAT DVDD pfet_06v0 ad=71.8771p pd=0.15481m as=58.1134p ps=77.985u w=76.465u l=1u
X6779 DVDD GATE BAT DVDD pfet_06v0 ad=35.511p pd=48.245u as=35.511p ps=48.245u w=46.725u l=1u
X6780 BAT GATE DVDD DVDD pfet_06v0 ad=35.511p pd=48.245u as=35.511p ps=48.245u w=46.725u l=1u
X6781 DVDD GATE BAT DVDD pfet_06v0 ad=35.5072p pd=48.24u as=35.5072p ps=48.24u w=46.72u l=1u
X6782 BAT GATE DVDD DVDD pfet_06v0 ad=35.511p pd=48.245u as=35.511p ps=48.245u w=46.725u l=1u
X6783 DVDD GATE BAT DVDD pfet_06v0 ad=58.1134p pd=77.985u as=58.1134p ps=77.985u w=76.465u l=1u
X6784 BAT GATE DVDD DVDD pfet_06v0 ad=35.511p pd=48.245u as=35.511p ps=48.245u w=46.725u l=1u
X6785 DVDD GATE BAT DVDD pfet_06v0 ad=58.9803p pd=0.12737m as=47.6862p ps=64.265u w=62.745u l=1u
X6786 BAT GATE DVDD DVDD pfet_06v0 ad=35.511p pd=48.245u as=43.9215p ps=95.32999u w=46.725u l=1u
X6787 DVDD GATE BAT DVDD pfet_06v0 ad=58.1172p pd=77.99u as=58.1172p ps=77.99u w=76.47u l=1u
X6788 BAT GATE DVDD DVDD pfet_06v0 ad=58.1096p pd=77.98u as=71.8724p ps=0.1548m w=76.46u l=1u
X6789 BAT GATE DVDD DVDD pfet_06v0 ad=47.6862p pd=64.265u as=47.6862p ps=64.265u w=62.745u l=1u
X6790 DVDD GATE BAT DVDD pfet_06v0 ad=58.1134p pd=77.985u as=58.1134p ps=77.985u w=76.465u l=1u
X6791 DVDD GATE BAT DVDD pfet_06v0 ad=58.1134p pd=77.985u as=58.1134p ps=77.985u w=76.465u l=1u
X6792 DVDD GATE BAT DVDD pfet_06v0 ad=47.6862p pd=64.265u as=47.6862p ps=64.265u w=62.745u l=1u
X6793 BAT GATE DVDD DVDD pfet_06v0 ad=58.1134p pd=77.985u as=58.1134p ps=77.985u w=76.465u l=1u
X6794 BAT GATE DVDD DVDD pfet_06v0 ad=35.5072p pd=48.24u as=35.5072p ps=48.24u w=46.72u l=1u
X6795 DVDD GATE BAT DVDD pfet_06v0 ad=58.1134p pd=77.985u as=58.1134p ps=77.985u w=76.465u l=1u
X6796 BAT GATE DVDD DVDD pfet_06v0 ad=49.3848p pd=66.5u as=61.0812p ps=0.13184m w=64.98u l=1u
X6797 DVDD GATE BAT DVDD pfet_06v0 ad=58.1134p pd=77.985u as=58.1134p ps=77.985u w=76.465u l=1u
X6798 DVDD GATE BAT DVDD pfet_06v0 ad=35.511p pd=48.245u as=35.511p ps=48.245u w=46.725u l=1u
X6799 DVDD GATE BAT DVDD pfet_06v0 ad=58.1134p pd=77.985u as=58.1134p ps=77.985u w=76.465u l=1u
X6800 BAT GATE DVDD DVDD pfet_06v0 ad=35.511p pd=48.245u as=35.511p ps=48.245u w=46.725u l=1u
X6801 DVDD GATE BAT DVDD pfet_06v0 ad=58.1134p pd=77.985u as=58.1134p ps=77.985u w=76.465u l=1u
X6802 BAT GATE DVDD DVDD pfet_06v0 ad=58.1134p pd=77.985u as=58.1134p ps=77.985u w=76.465u l=1u
X6803 BAT GATE DVDD DVDD pfet_06v0 ad=35.511p pd=48.245u as=43.9215p ps=95.32999u w=46.725u l=1u
X6804 DVDD GATE BAT DVDD pfet_06v0 ad=58.1134p pd=77.985u as=58.1134p ps=77.985u w=76.465u l=1u
X6805 BAT GATE DVDD DVDD pfet_06v0 ad=58.1134p pd=77.985u as=58.1134p ps=77.985u w=76.465u l=1u
X6806 BAT GATE DVDD DVDD pfet_06v0 ad=35.511p pd=48.245u as=35.511p ps=48.245u w=46.725u l=1u
X6807 DVDD GATE BAT DVDD pfet_06v0 ad=58.1134p pd=77.985u as=58.1134p ps=77.985u w=76.465u l=1u
X6808 BAT GATE DVDD DVDD pfet_06v0 ad=35.511p pd=48.245u as=35.511p ps=48.245u w=46.725u l=1u
X6809 BAT GATE DVDD DVDD pfet_06v0 ad=58.0754p pd=77.935u as=58.0754p ps=77.935u w=76.41499u l=1u
X6810 DVDD GATE BAT DVDD pfet_06v0 ad=58.1134p pd=77.985u as=58.1134p ps=77.985u w=76.465u l=1u
X6811 BAT GATE DVDD DVDD pfet_06v0 ad=58.1552p pd=78.04u as=58.1552p ps=78.04u w=76.52u l=1u
X6812 DVDD GATE BAT DVDD pfet_06v0 ad=35.511p pd=48.245u as=35.511p ps=48.245u w=46.725u l=1u
X6813 BAT GATE DVDD DVDD pfet_06v0 ad=35.5072p pd=48.24u as=35.5072p ps=48.24u w=46.72u l=1u
X6814 BAT GATE DVDD DVDD pfet_06v0 ad=58.1134p pd=77.985u as=58.1134p ps=77.985u w=76.465u l=1u
X6815 DVDD GATE BAT DVDD pfet_06v0 ad=35.511p pd=48.245u as=35.511p ps=48.245u w=46.725u l=1u
X6816 BAT GATE DVDD DVDD pfet_06v0 ad=35.511p pd=48.245u as=43.9215p ps=95.32999u w=46.725u l=1u
X6817 DVDD GATE BAT DVDD pfet_06v0 ad=58.1134p pd=77.985u as=58.1134p ps=77.985u w=76.465u l=1u
X6818 DVDD GATE BAT DVDD pfet_06v0 ad=43.9215p pd=95.32999u as=35.511p ps=48.245u w=46.725u l=1u
X6819 DVDD GATE BAT DVDD pfet_06v0 ad=58.0754p pd=77.935u as=58.0754p ps=77.935u w=76.41499u l=1u
X6820 DVDD GATE BAT DVDD pfet_06v0 ad=61.0812p pd=0.13184m as=49.3848p ps=66.5u w=64.98u l=1u
X6821 BAT GATE DVDD DVDD pfet_06v0 ad=58.1134p pd=77.985u as=58.1134p ps=77.985u w=76.465u l=1u
X6822 DVDD GATE BAT DVDD pfet_06v0 ad=35.511p pd=48.245u as=35.511p ps=48.245u w=46.725u l=1u
X6823 BAT GATE DVDD DVDD pfet_06v0 ad=58.1134p pd=77.985u as=58.1134p ps=77.985u w=76.465u l=1u
X6824 BAT GATE DVDD DVDD pfet_06v0 ad=58.1134p pd=77.985u as=71.8771p ps=0.15481m w=76.465u l=1u
X6825 DVDD GATE BAT DVDD pfet_06v0 ad=35.511p pd=48.245u as=35.511p ps=48.245u w=46.725u l=1u
X6826 BAT GATE DVDD DVDD pfet_06v0 ad=35.511p pd=48.245u as=35.511p ps=48.245u w=46.725u l=1u
X6827 BAT GATE DVDD DVDD pfet_06v0 ad=58.1134p pd=77.985u as=58.1134p ps=77.985u w=76.465u l=1u
X6828 DVDD GATE BAT DVDD pfet_06v0 ad=58.1134p pd=77.985u as=58.1134p ps=77.985u w=76.465u l=1u
X6829 BAT GATE DVDD DVDD pfet_06v0 ad=58.1134p pd=77.985u as=58.1134p ps=77.985u w=76.465u l=1u
X6830 DVDD GATE BAT DVDD pfet_06v0 ad=58.1134p pd=77.985u as=58.1134p ps=77.985u w=76.465u l=1u
X6831 DVDD GATE BAT DVDD pfet_06v0 ad=35.511p pd=48.245u as=35.511p ps=48.245u w=46.725u l=1u
X6832 BAT GATE DVDD DVDD pfet_06v0 ad=35.511p pd=48.245u as=35.511p ps=48.245u w=46.725u l=1u
X6833 DVDD GATE BAT DVDD pfet_06v0 ad=58.1134p pd=77.985u as=58.1134p ps=77.985u w=76.465u l=1u
X6834 BAT GATE DVDD DVDD pfet_06v0 ad=35.511p pd=48.245u as=35.511p ps=48.245u w=46.725u l=1u
X6835 BAT GATE DVDD DVDD pfet_06v0 ad=58.1096p pd=77.98u as=58.1096p ps=77.98u w=76.46u l=1u
X6836 BAT GATE DVDD DVDD pfet_06v0 ad=49.3848p pd=66.5u as=61.0812p ps=0.13184m w=64.98u l=1u
X6837 BAT GATE DVDD DVDD pfet_06v0 ad=49.3848p pd=66.5u as=49.3848p ps=66.5u w=64.98u l=1u
X6838 DVDD GATE BAT DVDD pfet_06v0 ad=58.1134p pd=77.985u as=58.1134p ps=77.985u w=76.465u l=1u
X6839 BAT GATE DVDD DVDD pfet_06v0 ad=58.1552p pd=78.04u as=58.1552p ps=78.04u w=76.52u l=1u
X6840 BAT GATE DVDD DVDD pfet_06v0 ad=58.1134p pd=77.985u as=58.1134p ps=77.985u w=76.465u l=1u
X6841 BAT GATE DVDD DVDD pfet_06v0 ad=35.511p pd=48.245u as=35.511p ps=48.245u w=46.725u l=1u
X6842 BAT GATE DVDD DVDD pfet_06v0 ad=35.511p pd=48.245u as=35.511p ps=48.245u w=46.725u l=1u
X6843 DVDD GATE BAT DVDD pfet_06v0 ad=35.511p pd=48.245u as=35.511p ps=48.245u w=46.725u l=1u
X6844 DVDD GATE BAT DVDD pfet_06v0 ad=71.8771p pd=0.15481m as=58.1134p ps=77.985u w=76.465u l=1u
X6845 BAT GATE DVDD DVDD pfet_06v0 ad=49.3848p pd=66.5u as=49.3848p ps=66.5u w=64.98u l=1u
X6846 DVDD GATE BAT DVDD pfet_06v0 ad=58.1134p pd=77.985u as=58.1134p ps=77.985u w=76.465u l=1u
X6847 BAT GATE DVDD DVDD pfet_06v0 ad=58.1134p pd=77.985u as=71.8771p ps=0.15481m w=76.465u l=1u
X6848 BAT GATE DVDD DVDD pfet_06v0 ad=35.511p pd=48.245u as=35.511p ps=48.245u w=46.725u l=1u
X6849 DVDD GATE BAT DVDD pfet_06v0 ad=58.1134p pd=77.985u as=58.1134p ps=77.985u w=76.465u l=1u
X6850 BAT GATE DVDD DVDD pfet_06v0 ad=35.511p pd=48.245u as=35.511p ps=48.245u w=46.725u l=1u
X6851 BAT GATE DVDD DVDD pfet_06v0 ad=35.511p pd=48.245u as=35.511p ps=48.245u w=46.725u l=1u
X6852 DVDD GATE BAT DVDD pfet_06v0 ad=49.3848p pd=66.5u as=49.3848p ps=66.5u w=64.98u l=1u
X6853 DVDD GATE BAT DVDD pfet_06v0 ad=35.511p pd=48.245u as=35.511p ps=48.245u w=46.725u l=1u
X6854 DVDD GATE BAT DVDD pfet_06v0 ad=58.1134p pd=77.985u as=58.1134p ps=77.985u w=76.465u l=1u
X6855 DVDD GATE BAT DVDD pfet_06v0 ad=58.1096p pd=77.98u as=58.1096p ps=77.98u w=76.46u l=1u
X6856 DVDD GATE BAT DVDD pfet_06v0 ad=35.511p pd=48.245u as=35.511p ps=48.245u w=46.725u l=1u
X6857 DVDD GATE BAT DVDD pfet_06v0 ad=58.1134p pd=77.985u as=58.1134p ps=77.985u w=76.465u l=1u
X6858 BAT GATE DVDD DVDD pfet_06v0 ad=58.1134p pd=77.985u as=71.8771p ps=0.15481m w=76.465u l=1u
X6859 DVDD GATE BAT DVDD pfet_06v0 ad=35.511p pd=48.245u as=35.511p ps=48.245u w=46.725u l=1u
X6860 BAT GATE DVDD DVDD pfet_06v0 ad=35.511p pd=48.245u as=35.511p ps=48.245u w=46.725u l=1u
X6861 DVDD GATE BAT DVDD pfet_06v0 ad=43.9215p pd=95.32999u as=35.511p ps=48.245u w=46.725u l=1u
X6862 BAT GATE DVDD DVDD pfet_06v0 ad=58.1134p pd=77.985u as=58.1134p ps=77.985u w=76.465u l=1u
X6863 DVDD GATE BAT DVDD pfet_06v0 ad=35.5072p pd=48.24u as=35.5072p ps=48.24u w=46.72u l=1u
X6864 BAT GATE DVDD DVDD pfet_06v0 ad=35.511p pd=48.245u as=35.511p ps=48.245u w=46.725u l=1u
X6865 DVDD GATE BAT DVDD pfet_06v0 ad=58.1096p pd=77.98u as=58.1096p ps=77.98u w=76.46u l=1u
X6866 BAT GATE DVDD DVDD pfet_06v0 ad=58.1134p pd=77.985u as=58.1134p ps=77.985u w=76.465u l=1u
X6867 BAT GATE DVDD DVDD pfet_06v0 ad=58.1552p pd=78.04u as=71.92879p ps=0.15492m w=76.52u l=1u
X6868 DVDD GATE BAT DVDD pfet_06v0 ad=35.5072p pd=48.24u as=35.5072p ps=48.24u w=46.72u l=1u
X6869 BAT GATE DVDD DVDD pfet_06v0 ad=35.511p pd=48.245u as=43.9215p ps=95.32999u w=46.725u l=1u
X6870 BAT GATE DVDD DVDD pfet_06v0 ad=58.1134p pd=77.985u as=71.8771p ps=0.15481m w=76.465u l=1u
X6871 BAT GATE DVDD DVDD pfet_06v0 ad=58.1096p pd=77.98u as=58.1096p ps=77.98u w=76.46u l=1u
X6872 BAT GATE DVDD DVDD pfet_06v0 ad=58.1134p pd=77.985u as=58.1134p ps=77.985u w=76.465u l=1u
X6873 BAT GATE DVDD DVDD pfet_06v0 ad=58.0754p pd=77.935u as=71.8301p ps=0.15471m w=76.41499u l=1u
X6874 BAT GATE DVDD DVDD pfet_06v0 ad=35.511p pd=48.245u as=35.511p ps=48.245u w=46.725u l=1u
X6875 BAT GATE DVDD DVDD pfet_06v0 ad=35.511p pd=48.245u as=35.511p ps=48.245u w=46.725u l=1u
X6876 BAT GATE DVDD DVDD pfet_06v0 ad=35.5072p pd=48.24u as=35.5072p ps=48.24u w=46.72u l=1u
X6877 DVDD GATE BAT DVDD pfet_06v0 ad=35.511p pd=48.245u as=35.511p ps=48.245u w=46.725u l=1u
X6878 DVDD GATE BAT DVDD pfet_06v0 ad=58.1134p pd=77.985u as=58.1134p ps=77.985u w=76.465u l=1u
X6879 BAT GATE DVDD DVDD pfet_06v0 ad=35.511p pd=48.245u as=43.9215p ps=95.32999u w=46.725u l=1u
X6880 BAT GATE DVDD DVDD pfet_06v0 ad=58.1552p pd=78.04u as=58.1552p ps=78.04u w=76.52u l=1u
X6881 DVDD GATE BAT DVDD pfet_06v0 ad=35.511p pd=48.245u as=35.511p ps=48.245u w=46.725u l=1u
X6882 DVDD GATE BAT DVDD pfet_06v0 ad=58.0754p pd=77.935u as=58.0754p ps=77.935u w=76.41499u l=1u
X6883 DVDD GATE BAT DVDD pfet_06v0 ad=47.6862p pd=64.265u as=47.6862p ps=64.265u w=62.745u l=1u
X6884 DVDD GATE BAT DVDD pfet_06v0 ad=35.511p pd=48.245u as=35.511p ps=48.245u w=46.725u l=1u
X6885 BAT GATE DVDD DVDD pfet_06v0 ad=35.5072p pd=48.24u as=43.9168p ps=95.32u w=46.72u l=1u
X6886 BAT GATE DVDD DVDD pfet_06v0 ad=35.511p pd=48.245u as=35.511p ps=48.245u w=46.725u l=1u
X6887 DVDD GATE BAT DVDD pfet_06v0 ad=58.1134p pd=77.985u as=58.1134p ps=77.985u w=76.465u l=1u
X6888 DVDD GATE BAT DVDD pfet_06v0 ad=58.1134p pd=77.985u as=58.1134p ps=77.985u w=76.465u l=1u
X6889 BAT GATE DVDD DVDD pfet_06v0 ad=35.5072p pd=48.24u as=35.5072p ps=48.24u w=46.72u l=1u
X6890 DVDD GATE BAT DVDD pfet_06v0 ad=35.511p pd=48.245u as=35.511p ps=48.245u w=46.725u l=1u
X6891 BAT GATE DVDD DVDD pfet_06v0 ad=58.1134p pd=77.985u as=58.1134p ps=77.985u w=76.465u l=1u
X6892 BAT GATE DVDD DVDD pfet_06v0 ad=58.1134p pd=77.985u as=58.1134p ps=77.985u w=76.465u l=1u
X6893 DVDD GATE BAT DVDD pfet_06v0 ad=58.1096p pd=77.98u as=58.1096p ps=77.98u w=76.46u l=1u
X6894 BAT GATE DVDD DVDD pfet_06v0 ad=58.1134p pd=77.985u as=58.1134p ps=77.985u w=76.465u l=1u
X6895 BAT GATE DVDD DVDD pfet_06v0 ad=35.511p pd=48.245u as=35.511p ps=48.245u w=46.725u l=1u
X6896 DVDD GATE BAT DVDD pfet_06v0 ad=35.511p pd=48.245u as=35.511p ps=48.245u w=46.725u l=1u
X6897 BAT GATE DVDD DVDD pfet_06v0 ad=58.1134p pd=77.985u as=58.1134p ps=77.985u w=76.465u l=1u
X6898 DVDD GATE BAT DVDD pfet_06v0 ad=35.511p pd=48.245u as=35.511p ps=48.245u w=46.725u l=1u
X6899 BAT GATE DVDD DVDD pfet_06v0 ad=58.1134p pd=77.985u as=58.1134p ps=77.985u w=76.465u l=1u
X6900 DVDD GATE BAT DVDD pfet_06v0 ad=49.3848p pd=66.5u as=49.3848p ps=66.5u w=64.98u l=1u
X6901 BAT GATE DVDD DVDD pfet_06v0 ad=35.511p pd=48.245u as=35.511p ps=48.245u w=46.725u l=1u
X6902 DVDD GATE BAT DVDD pfet_06v0 ad=58.1134p pd=77.985u as=58.1134p ps=77.985u w=76.465u l=1u
X6903 BAT GATE DVDD DVDD pfet_06v0 ad=58.1134p pd=77.985u as=58.1134p ps=77.985u w=76.465u l=1u
X6904 BAT GATE DVDD DVDD pfet_06v0 ad=58.1134p pd=77.985u as=71.8771p ps=0.15481m w=76.465u l=1u
X6905 DVDD GATE BAT DVDD pfet_06v0 ad=58.1096p pd=77.98u as=58.1096p ps=77.98u w=76.46u l=1u
X6906 DVDD GATE BAT DVDD pfet_06v0 ad=49.3848p pd=66.5u as=49.3848p ps=66.5u w=64.98u l=1u
X6907 DVDD GATE BAT DVDD pfet_06v0 ad=58.1134p pd=77.985u as=58.1134p ps=77.985u w=76.465u l=1u
X6908 BAT GATE DVDD DVDD pfet_06v0 ad=58.1096p pd=77.98u as=71.8724p ps=0.1548m w=76.46u l=1u
X6909 DVDD GATE BAT DVDD pfet_06v0 ad=35.511p pd=48.245u as=35.511p ps=48.245u w=46.725u l=1u
X6910 BAT GATE DVDD DVDD pfet_06v0 ad=58.1552p pd=78.04u as=58.1552p ps=78.04u w=76.52u l=1u
X6911 BAT GATE DVDD DVDD pfet_06v0 ad=58.1134p pd=77.985u as=71.8771p ps=0.15481m w=76.465u l=1u
X6912 DVDD GATE BAT DVDD pfet_06v0 ad=35.511p pd=48.245u as=35.511p ps=48.245u w=46.725u l=1u
X6913 BAT GATE DVDD DVDD pfet_06v0 ad=35.511p pd=48.245u as=35.511p ps=48.245u w=46.725u l=1u
X6914 DVDD GATE BAT DVDD pfet_06v0 ad=43.9215p pd=95.32999u as=35.511p ps=48.245u w=46.725u l=1u
X6915 BAT GATE DVDD DVDD pfet_06v0 ad=58.1134p pd=77.985u as=58.1134p ps=77.985u w=76.465u l=1u
X6916 DVDD GATE BAT DVDD pfet_06v0 ad=35.5072p pd=48.24u as=35.5072p ps=48.24u w=46.72u l=1u
X6917 BAT GATE DVDD DVDD pfet_06v0 ad=35.511p pd=48.245u as=35.511p ps=48.245u w=46.725u l=1u
X6918 DVDD GATE BAT DVDD pfet_06v0 ad=58.1134p pd=77.985u as=58.1134p ps=77.985u w=76.465u l=1u
X6919 DVDD GATE BAT DVDD pfet_06v0 ad=58.1134p pd=77.985u as=58.1134p ps=77.985u w=76.465u l=1u
X6920 DVDD GATE BAT DVDD pfet_06v0 ad=58.1172p pd=77.99u as=58.1172p ps=77.99u w=76.47u l=1u
X6921 DVDD GATE BAT DVDD pfet_06v0 ad=58.1134p pd=77.985u as=58.1134p ps=77.985u w=76.465u l=1u
X6922 BAT GATE DVDD DVDD pfet_06v0 ad=35.511p pd=48.245u as=35.511p ps=48.245u w=46.725u l=1u
X6923 BAT GATE DVDD DVDD pfet_06v0 ad=58.1172p pd=77.99u as=71.8818p ps=0.15482m w=76.47u l=1u
X6924 DVDD GATE BAT DVDD pfet_06v0 ad=35.511p pd=48.245u as=35.511p ps=48.245u w=46.725u l=1u
X6925 DVDD GATE BAT DVDD pfet_06v0 ad=71.8771p pd=0.15481m as=58.1134p ps=77.985u w=76.465u l=1u
X6926 BAT GATE DVDD DVDD pfet_06v0 ad=35.511p pd=48.245u as=43.9215p ps=95.32999u w=46.725u l=1u
X6927 DVDD GATE BAT DVDD pfet_06v0 ad=58.1134p pd=77.985u as=58.1134p ps=77.985u w=76.465u l=1u
X6928 BAT GATE DVDD DVDD pfet_06v0 ad=58.1134p pd=77.985u as=58.1134p ps=77.985u w=76.465u l=1u
X6929 DVDD GATE BAT DVDD pfet_06v0 ad=58.1134p pd=77.985u as=58.1134p ps=77.985u w=76.465u l=1u
X6930 DVDD GATE BAT DVDD pfet_06v0 ad=35.511p pd=48.245u as=35.511p ps=48.245u w=46.725u l=1u
X6931 BAT GATE DVDD DVDD pfet_06v0 ad=35.511p pd=48.245u as=35.511p ps=48.245u w=46.725u l=1u
X6932 BAT GATE DVDD DVDD pfet_06v0 ad=58.1134p pd=77.985u as=71.8771p ps=0.15481m w=76.465u l=1u
X6933 DVDD GATE BAT DVDD pfet_06v0 ad=58.9803p pd=0.12737m as=47.6862p ps=64.265u w=62.745u l=1u
X6934 BAT GATE DVDD DVDD pfet_06v0 ad=58.1134p pd=77.985u as=71.8771p ps=0.15481m w=76.465u l=1u
X6935 DVDD GATE BAT DVDD pfet_06v0 ad=58.1552p pd=78.04u as=58.1552p ps=78.04u w=76.52u l=1u
X6936 DVDD GATE BAT DVDD pfet_06v0 ad=49.3848p pd=66.5u as=49.3848p ps=66.5u w=64.98u l=1u
X6937 DVDD GATE BAT DVDD pfet_06v0 ad=35.511p pd=48.245u as=35.511p ps=48.245u w=46.725u l=1u
X6938 BAT GATE DVDD DVDD pfet_06v0 ad=58.1134p pd=77.985u as=71.8771p ps=0.15481m w=76.465u l=1u
X6939 DVDD GATE BAT DVDD pfet_06v0 ad=58.0754p pd=77.935u as=58.0754p ps=77.935u w=76.41499u l=1u
X6940 BAT GATE DVDD DVDD pfet_06v0 ad=58.1172p pd=77.99u as=58.1172p ps=77.99u w=76.47u l=1u
X6941 DVDD GATE BAT DVDD pfet_06v0 ad=35.511p pd=48.245u as=35.511p ps=48.245u w=46.725u l=1u
X6942 DVDD GATE BAT DVDD pfet_06v0 ad=58.1552p pd=78.04u as=58.1552p ps=78.04u w=76.52u l=1u
X6943 BAT GATE DVDD DVDD pfet_06v0 ad=58.1134p pd=77.985u as=58.1134p ps=77.985u w=76.465u l=1u
X6944 BAT GATE DVDD DVDD pfet_06v0 ad=58.1134p pd=77.985u as=58.1134p ps=77.985u w=76.465u l=1u
X6945 BAT GATE DVDD DVDD pfet_06v0 ad=58.1134p pd=77.985u as=58.1134p ps=77.985u w=76.465u l=1u
X6946 DVDD GATE BAT DVDD pfet_06v0 ad=58.1552p pd=78.04u as=58.1552p ps=78.04u w=76.52u l=1u
X6947 DVDD GATE BAT DVDD pfet_06v0 ad=58.1172p pd=77.99u as=58.1172p ps=77.99u w=76.47u l=1u
X6948 DVDD GATE BAT DVDD pfet_06v0 ad=43.9215p pd=95.32999u as=35.511p ps=48.245u w=46.725u l=1u
X6949 BAT GATE DVDD DVDD pfet_06v0 ad=58.1134p pd=77.985u as=58.1134p ps=77.985u w=76.465u l=1u
X6950 BAT GATE DVDD DVDD pfet_06v0 ad=35.511p pd=48.245u as=43.9215p ps=95.32999u w=46.725u l=1u
X6951 BAT GATE DVDD DVDD pfet_06v0 ad=35.511p pd=48.245u as=43.9215p ps=95.32999u w=46.725u l=1u
X6952 BAT GATE DVDD DVDD pfet_06v0 ad=58.1552p pd=78.04u as=58.1552p ps=78.04u w=76.52u l=1u
X6953 BAT GATE DVDD DVDD pfet_06v0 ad=58.1096p pd=77.98u as=58.1096p ps=77.98u w=76.46u l=1u
X6954 DVDD GATE BAT DVDD pfet_06v0 ad=43.9215p pd=95.32999u as=35.511p ps=48.245u w=46.725u l=1u
X6955 BAT GATE DVDD DVDD pfet_06v0 ad=58.1134p pd=77.985u as=58.1134p ps=77.985u w=76.465u l=1u
X6956 DVDD GATE BAT DVDD pfet_06v0 ad=35.511p pd=48.245u as=35.511p ps=48.245u w=46.725u l=1u
X6957 DVDD GATE BAT DVDD pfet_06v0 ad=35.511p pd=48.245u as=35.511p ps=48.245u w=46.725u l=1u
X6958 DVDD GATE BAT DVDD pfet_06v0 ad=58.1134p pd=77.985u as=58.1134p ps=77.985u w=76.465u l=1u
X6959 DVDD GATE BAT DVDD pfet_06v0 ad=58.1134p pd=77.985u as=58.1134p ps=77.985u w=76.465u l=1u
X6960 DVDD GATE BAT DVDD pfet_06v0 ad=71.8771p pd=0.15481m as=58.1134p ps=77.985u w=76.465u l=1u
X6961 DVDD GATE BAT DVDD pfet_06v0 ad=58.1172p pd=77.99u as=58.1172p ps=77.99u w=76.47u l=1u
X6962 DVDD GATE BAT DVDD pfet_06v0 ad=58.1096p pd=77.98u as=58.1096p ps=77.98u w=76.46u l=1u
X6963 BAT GATE DVDD DVDD pfet_06v0 ad=35.5072p pd=48.24u as=35.5072p ps=48.24u w=46.72u l=1u
X6964 BAT GATE DVDD DVDD pfet_06v0 ad=58.1096p pd=77.98u as=58.1096p ps=77.98u w=76.46u l=1u
X6965 DVDD GATE BAT DVDD pfet_06v0 ad=58.1172p pd=77.99u as=58.1172p ps=77.99u w=76.47u l=1u
X6966 DVDD GATE BAT DVDD pfet_06v0 ad=58.1134p pd=77.985u as=58.1134p ps=77.985u w=76.465u l=1u
X6967 BAT GATE DVDD DVDD pfet_06v0 ad=49.3848p pd=66.5u as=49.3848p ps=66.5u w=64.98u l=1u
X6968 DVDD GATE BAT DVDD pfet_06v0 ad=58.1134p pd=77.985u as=58.1134p ps=77.985u w=76.465u l=1u
X6969 DVDD GATE BAT DVDD pfet_06v0 ad=58.1096p pd=77.98u as=58.1096p ps=77.98u w=76.46u l=1u
X6970 DVDD GATE BAT DVDD pfet_06v0 ad=58.1134p pd=77.985u as=58.1134p ps=77.985u w=76.465u l=1u
X6971 BAT GATE DVDD DVDD pfet_06v0 ad=35.511p pd=48.245u as=35.511p ps=48.245u w=46.725u l=1u
X6972 BAT GATE DVDD DVDD pfet_06v0 ad=49.3848p pd=66.5u as=49.3848p ps=66.5u w=64.98u l=1u
X6973 DVDD GATE BAT DVDD pfet_06v0 ad=58.1134p pd=77.985u as=58.1134p ps=77.985u w=76.465u l=1u
X6974 BAT GATE DVDD DVDD pfet_06v0 ad=58.1134p pd=77.985u as=58.1134p ps=77.985u w=76.465u l=1u
X6975 DVDD GATE BAT DVDD pfet_06v0 ad=58.1096p pd=77.98u as=58.1096p ps=77.98u w=76.46u l=1u
X6976 DVDD GATE BAT DVDD pfet_06v0 ad=58.1552p pd=78.04u as=58.1552p ps=78.04u w=76.52u l=1u
X6977 BAT GATE DVDD DVDD pfet_06v0 ad=35.511p pd=48.245u as=35.511p ps=48.245u w=46.725u l=1u
X6978 BAT GATE DVDD DVDD pfet_06v0 ad=35.511p pd=48.245u as=35.511p ps=48.245u w=46.725u l=1u
X6979 BAT GATE DVDD DVDD pfet_06v0 ad=58.0754p pd=77.935u as=58.0754p ps=77.935u w=76.41499u l=1u
X6980 DVDD GATE BAT DVDD pfet_06v0 ad=35.511p pd=48.245u as=35.511p ps=48.245u w=46.725u l=1u
X6981 DVDD GATE BAT DVDD pfet_06v0 ad=71.8771p pd=0.15481m as=58.1134p ps=77.985u w=76.465u l=1u
X6982 DVDD GATE BAT DVDD pfet_06v0 ad=43.9215p pd=95.32999u as=35.511p ps=48.245u w=46.725u l=1u
X6983 DVDD GATE BAT DVDD pfet_06v0 ad=35.511p pd=48.245u as=35.511p ps=48.245u w=46.725u l=1u
X6984 BAT GATE DVDD DVDD pfet_06v0 ad=58.1134p pd=77.985u as=71.8771p ps=0.15481m w=76.465u l=1u
X6985 DVDD GATE BAT DVDD pfet_06v0 ad=35.511p pd=48.245u as=35.511p ps=48.245u w=46.725u l=1u
X6986 BAT GATE DVDD DVDD pfet_06v0 ad=35.511p pd=48.245u as=35.511p ps=48.245u w=46.725u l=1u
X6987 BAT GATE DVDD DVDD pfet_06v0 ad=58.1096p pd=77.98u as=58.1096p ps=77.98u w=76.46u l=1u
X6988 DVDD GATE BAT DVDD pfet_06v0 ad=35.511p pd=48.245u as=35.511p ps=48.245u w=46.725u l=1u
X6989 DVDD GATE BAT DVDD pfet_06v0 ad=58.1134p pd=77.985u as=58.1134p ps=77.985u w=76.465u l=1u
X6990 BAT GATE DVDD DVDD pfet_06v0 ad=35.511p pd=48.245u as=35.511p ps=48.245u w=46.725u l=1u
X6991 DVDD GATE BAT DVDD pfet_06v0 ad=58.1172p pd=77.99u as=58.1172p ps=77.99u w=76.47u l=1u
X6992 DVDD GATE BAT DVDD pfet_06v0 ad=58.9803p pd=0.12737m as=47.6862p ps=64.265u w=62.745u l=1u
X6993 BAT GATE DVDD DVDD pfet_06v0 ad=35.511p pd=48.245u as=35.511p ps=48.245u w=46.725u l=1u
X6994 DVDD GATE BAT DVDD pfet_06v0 ad=35.5072p pd=48.24u as=35.5072p ps=48.24u w=46.72u l=1u
X6995 BAT GATE DVDD DVDD pfet_06v0 ad=47.6862p pd=64.265u as=47.6862p ps=64.265u w=62.745u l=1u
X6996 DVDD GATE BAT DVDD pfet_06v0 ad=71.8771p pd=0.15481m as=58.1134p ps=77.985u w=76.465u l=1u
X6997 DVDD GATE BAT DVDD pfet_06v0 ad=58.1134p pd=77.985u as=58.1134p ps=77.985u w=76.465u l=1u
X6998 BAT GATE DVDD DVDD pfet_06v0 ad=58.1134p pd=77.985u as=58.1134p ps=77.985u w=76.465u l=1u
X6999 DVDD GATE BAT DVDD pfet_06v0 ad=58.1134p pd=77.985u as=58.1134p ps=77.985u w=76.465u l=1u
X7000 BAT GATE DVDD DVDD pfet_06v0 ad=58.1134p pd=77.985u as=71.8771p ps=0.15481m w=76.465u l=1u
X7001 DVDD GATE BAT DVDD pfet_06v0 ad=35.511p pd=48.245u as=35.511p ps=48.245u w=46.725u l=1u
X7002 BAT GATE DVDD DVDD pfet_06v0 ad=58.1096p pd=77.98u as=58.1096p ps=77.98u w=76.46u l=1u
X7003 DVDD GATE BAT DVDD pfet_06v0 ad=35.511p pd=48.245u as=35.511p ps=48.245u w=46.725u l=1u
X7004 BAT GATE DVDD DVDD pfet_06v0 ad=58.0754p pd=77.935u as=58.0754p ps=77.935u w=76.41499u l=1u
X7005 BAT GATE DVDD DVDD pfet_06v0 ad=58.1552p pd=78.04u as=58.1552p ps=78.04u w=76.52u l=1u
X7006 DVDD GATE BAT DVDD pfet_06v0 ad=58.1552p pd=78.04u as=58.1552p ps=78.04u w=76.52u l=1u
X7007 BAT GATE DVDD DVDD pfet_06v0 ad=35.511p pd=48.245u as=43.9215p ps=95.32999u w=46.725u l=1u
X7008 DVDD GATE BAT DVDD pfet_06v0 ad=71.8771p pd=0.15481m as=58.1134p ps=77.985u w=76.465u l=1u
X7009 DVDD GATE BAT DVDD pfet_06v0 ad=47.6862p pd=64.265u as=47.6862p ps=64.265u w=62.745u l=1u
X7010 DVDD GATE BAT DVDD pfet_06v0 ad=58.1134p pd=77.985u as=58.1134p ps=77.985u w=76.465u l=1u
X7011 BAT GATE DVDD DVDD pfet_06v0 ad=35.511p pd=48.245u as=35.511p ps=48.245u w=46.725u l=1u
X7012 DVDD GATE BAT DVDD pfet_06v0 ad=35.511p pd=48.245u as=35.511p ps=48.245u w=46.725u l=1u
X7013 BAT GATE DVDD DVDD pfet_06v0 ad=58.1134p pd=77.985u as=58.1134p ps=77.985u w=76.465u l=1u
X7014 DVDD GATE BAT DVDD pfet_06v0 ad=35.511p pd=48.245u as=35.511p ps=48.245u w=46.725u l=1u
X7015 DVDD GATE BAT DVDD pfet_06v0 ad=71.92879p pd=0.15492m as=58.1552p ps=78.04u w=76.52u l=1u
X7016 DVDD GATE BAT DVDD pfet_06v0 ad=58.1134p pd=77.985u as=58.1134p ps=77.985u w=76.465u l=1u
X7017 DVDD GATE BAT DVDD pfet_06v0 ad=35.5072p pd=48.24u as=35.5072p ps=48.24u w=46.72u l=1u
X7018 DVDD GATE BAT DVDD pfet_06v0 ad=35.511p pd=48.245u as=35.511p ps=48.245u w=46.725u l=1u
X7019 DVDD GATE BAT DVDD pfet_06v0 ad=43.9215p pd=95.32999u as=35.511p ps=48.245u w=46.725u l=1u
X7020 BAT GATE DVDD DVDD pfet_06v0 ad=58.1134p pd=77.985u as=58.1134p ps=77.985u w=76.465u l=1u
X7021 BAT GATE DVDD DVDD pfet_06v0 ad=58.1134p pd=77.985u as=71.8771p ps=0.15481m w=76.465u l=1u
X7022 BAT GATE DVDD DVDD pfet_06v0 ad=35.511p pd=48.245u as=43.9215p ps=95.32999u w=46.725u l=1u
X7023 BAT GATE DVDD DVDD pfet_06v0 ad=58.1134p pd=77.985u as=58.1134p ps=77.985u w=76.465u l=1u
X7024 DVDD GATE BAT DVDD pfet_06v0 ad=35.511p pd=48.245u as=35.511p ps=48.245u w=46.725u l=1u
X7025 BAT GATE DVDD DVDD pfet_06v0 ad=35.511p pd=48.245u as=35.511p ps=48.245u w=46.725u l=1u
X7026 BAT GATE DVDD DVDD pfet_06v0 ad=58.1134p pd=77.985u as=58.1134p ps=77.985u w=76.465u l=1u
X7027 BAT GATE DVDD DVDD pfet_06v0 ad=58.1134p pd=77.985u as=58.1134p ps=77.985u w=76.465u l=1u
X7028 DVDD GATE BAT DVDD pfet_06v0 ad=35.511p pd=48.245u as=35.511p ps=48.245u w=46.725u l=1u
X7029 BAT GATE DVDD DVDD pfet_06v0 ad=58.1552p pd=78.04u as=71.92879p ps=0.15492m w=76.52u l=1u
X7030 BAT GATE DVDD DVDD pfet_06v0 ad=58.1134p pd=77.985u as=58.1134p ps=77.985u w=76.465u l=1u
X7031 DVDD GATE BAT DVDD pfet_06v0 ad=58.1552p pd=78.04u as=58.1552p ps=78.04u w=76.52u l=1u
X7032 DVDD GATE BAT DVDD pfet_06v0 ad=35.5072p pd=48.24u as=35.5072p ps=48.24u w=46.72u l=1u
X7033 DVDD GATE BAT DVDD pfet_06v0 ad=71.8771p pd=0.15481m as=58.1134p ps=77.985u w=76.465u l=1u
X7034 BAT GATE DVDD DVDD pfet_06v0 ad=49.3848p pd=66.5u as=61.0812p ps=0.13184m w=64.98u l=1u
X7035 BAT GATE DVDD DVDD pfet_06v0 ad=35.511p pd=48.245u as=43.9215p ps=95.32999u w=46.725u l=1u
X7036 DVDD GATE BAT DVDD pfet_06v0 ad=35.5072p pd=48.24u as=35.5072p ps=48.24u w=46.72u l=1u
X7037 BAT GATE DVDD DVDD pfet_06v0 ad=58.0754p pd=77.935u as=58.0754p ps=77.935u w=76.41499u l=1u
X7038 BAT GATE DVDD DVDD pfet_06v0 ad=58.1134p pd=77.985u as=58.1134p ps=77.985u w=76.465u l=1u
X7039 BAT GATE DVDD DVDD pfet_06v0 ad=58.0754p pd=77.935u as=58.0754p ps=77.935u w=76.41499u l=1u
X7040 BAT GATE DVDD DVDD pfet_06v0 ad=58.1096p pd=77.98u as=58.1096p ps=77.98u w=76.46u l=1u
X7041 BAT GATE DVDD DVDD pfet_06v0 ad=49.3848p pd=66.5u as=49.3848p ps=66.5u w=64.98u l=1u
X7042 DVDD GATE BAT DVDD pfet_06v0 ad=58.1134p pd=77.985u as=58.1134p ps=77.985u w=76.465u l=1u
X7043 DVDD GATE BAT DVDD pfet_06v0 ad=61.0812p pd=0.13184m as=49.3848p ps=66.5u w=64.98u l=1u
X7044 BAT GATE DVDD DVDD pfet_06v0 ad=58.0754p pd=77.935u as=58.0754p ps=77.935u w=76.41499u l=1u
X7045 BAT GATE DVDD DVDD pfet_06v0 ad=58.1552p pd=78.04u as=71.92879p ps=0.15492m w=76.52u l=1u
X7046 BAT GATE DVDD DVDD pfet_06v0 ad=35.511p pd=48.245u as=35.511p ps=48.245u w=46.725u l=1u
X7047 BAT GATE DVDD DVDD pfet_06v0 ad=58.1172p pd=77.99u as=71.8818p ps=0.15482m w=76.47u l=1u
X7048 BAT GATE DVDD DVDD pfet_06v0 ad=58.1552p pd=78.04u as=58.1552p ps=78.04u w=76.52u l=1u
X7049 BAT GATE DVDD DVDD pfet_06v0 ad=35.511p pd=48.245u as=35.511p ps=48.245u w=46.725u l=1u
X7050 DVDD GATE BAT DVDD pfet_06v0 ad=35.511p pd=48.245u as=35.511p ps=48.245u w=46.725u l=1u
X7051 DVDD GATE BAT DVDD pfet_06v0 ad=58.1552p pd=78.04u as=58.1552p ps=78.04u w=76.52u l=1u
X7052 DVDD GATE BAT DVDD pfet_06v0 ad=58.1134p pd=77.985u as=58.1134p ps=77.985u w=76.465u l=1u
X7053 BAT GATE DVDD DVDD pfet_06v0 ad=35.5072p pd=48.24u as=35.5072p ps=48.24u w=46.72u l=1u
X7054 BAT GATE DVDD DVDD pfet_06v0 ad=58.1134p pd=77.985u as=71.8771p ps=0.15481m w=76.465u l=1u
X7055 BAT GATE DVDD DVDD pfet_06v0 ad=58.1134p pd=77.985u as=71.8771p ps=0.15481m w=76.465u l=1u
X7056 DVDD GATE BAT DVDD pfet_06v0 ad=58.1134p pd=77.985u as=58.1134p ps=77.985u w=76.465u l=1u
X7057 DVDD GATE BAT DVDD pfet_06v0 ad=58.1134p pd=77.985u as=58.1134p ps=77.985u w=76.465u l=1u
X7058 DVDD GATE BAT DVDD pfet_06v0 ad=35.511p pd=48.245u as=35.511p ps=48.245u w=46.725u l=1u
X7059 BAT GATE DVDD DVDD pfet_06v0 ad=58.1134p pd=77.985u as=71.8771p ps=0.15481m w=76.465u l=1u
X7060 DVDD GATE BAT DVDD pfet_06v0 ad=71.8771p pd=0.15481m as=58.1134p ps=77.985u w=76.465u l=1u
X7061 DVDD GATE BAT DVDD pfet_06v0 ad=58.1096p pd=77.98u as=58.1096p ps=77.98u w=76.46u l=1u
X7062 BAT GATE DVDD DVDD pfet_06v0 ad=35.511p pd=48.245u as=43.9215p ps=95.32999u w=46.725u l=1u
X7063 DVDD GATE BAT DVDD pfet_06v0 ad=43.9215p pd=95.32999u as=35.511p ps=48.245u w=46.725u l=1u
X7064 DVDD GATE BAT DVDD pfet_06v0 ad=35.511p pd=48.245u as=35.511p ps=48.245u w=46.725u l=1u
X7065 DVDD GATE BAT DVDD pfet_06v0 ad=35.511p pd=48.245u as=35.511p ps=48.245u w=46.725u l=1u
X7066 BAT GATE DVDD DVDD pfet_06v0 ad=58.1134p pd=77.985u as=58.1134p ps=77.985u w=76.465u l=1u
X7067 BAT GATE DVDD DVDD pfet_06v0 ad=58.1134p pd=77.985u as=58.1134p ps=77.985u w=76.465u l=1u
X7068 BAT GATE DVDD DVDD pfet_06v0 ad=35.511p pd=48.245u as=35.511p ps=48.245u w=46.725u l=1u
X7069 BAT GATE DVDD DVDD pfet_06v0 ad=58.1096p pd=77.98u as=58.1096p ps=77.98u w=76.46u l=1u
X7070 DVDD GATE BAT DVDD pfet_06v0 ad=35.511p pd=48.245u as=35.511p ps=48.245u w=46.725u l=1u
X7071 DVDD GATE BAT DVDD pfet_06v0 ad=58.1134p pd=77.985u as=58.1134p ps=77.985u w=76.465u l=1u
X7072 DVDD GATE BAT DVDD pfet_06v0 ad=58.1134p pd=77.985u as=58.1134p ps=77.985u w=76.465u l=1u
X7073 DVDD GATE BAT DVDD pfet_06v0 ad=35.511p pd=48.245u as=35.511p ps=48.245u w=46.725u l=1u
X7074 BAT GATE DVDD DVDD pfet_06v0 ad=58.1172p pd=77.99u as=58.1172p ps=77.99u w=76.47u l=1u
X7075 DVDD GATE BAT DVDD pfet_06v0 ad=43.9215p pd=95.32999u as=35.511p ps=48.245u w=46.725u l=1u
X7076 DVDD GATE BAT DVDD pfet_06v0 ad=49.3848p pd=66.5u as=49.3848p ps=66.5u w=64.98u l=1u
X7077 BAT GATE DVDD DVDD pfet_06v0 ad=35.511p pd=48.245u as=35.511p ps=48.245u w=46.725u l=1u
X7078 DVDD GATE BAT DVDD pfet_06v0 ad=49.3848p pd=66.5u as=49.3848p ps=66.5u w=64.98u l=1u
X7079 BAT GATE DVDD DVDD pfet_06v0 ad=58.1134p pd=77.985u as=58.1134p ps=77.985u w=76.465u l=1u
X7080 BAT GATE DVDD DVDD pfet_06v0 ad=58.0754p pd=77.935u as=71.8301p ps=0.15471m w=76.41499u l=1u
X7081 BAT GATE DVDD DVDD pfet_06v0 ad=47.6862p pd=64.265u as=47.6862p ps=64.265u w=62.745u l=1u
X7082 DVDD GATE BAT DVDD pfet_06v0 ad=43.9215p pd=95.32999u as=35.511p ps=48.245u w=46.725u l=1u
X7083 BAT GATE DVDD DVDD pfet_06v0 ad=58.1096p pd=77.98u as=58.1096p ps=77.98u w=76.46u l=1u
X7084 BAT GATE DVDD DVDD pfet_06v0 ad=35.511p pd=48.245u as=35.511p ps=48.245u w=46.725u l=1u
X7085 BAT GATE DVDD DVDD pfet_06v0 ad=35.511p pd=48.245u as=35.511p ps=48.245u w=46.725u l=1u
X7086 BAT GATE DVDD DVDD pfet_06v0 ad=58.0754p pd=77.935u as=58.0754p ps=77.935u w=76.41499u l=1u
X7087 BAT GATE DVDD DVDD pfet_06v0 ad=58.1552p pd=78.04u as=58.1552p ps=78.04u w=76.52u l=1u
X7088 DVDD GATE BAT DVDD pfet_06v0 ad=35.511p pd=48.245u as=35.511p ps=48.245u w=46.725u l=1u
X7089 DVDD GATE BAT DVDD pfet_06v0 ad=35.511p pd=48.245u as=35.511p ps=48.245u w=46.725u l=1u
X7090 BAT GATE DVDD DVDD pfet_06v0 ad=58.1134p pd=77.985u as=58.1134p ps=77.985u w=76.465u l=1u
X7091 DVDD GATE BAT DVDD pfet_06v0 ad=35.511p pd=48.245u as=35.511p ps=48.245u w=46.725u l=1u
X7092 DVDD GATE BAT DVDD pfet_06v0 ad=35.511p pd=48.245u as=35.511p ps=48.245u w=46.725u l=1u
X7093 BAT GATE DVDD DVDD pfet_06v0 ad=58.1134p pd=77.985u as=58.1134p ps=77.985u w=76.465u l=1u
X7094 DVDD GATE BAT DVDD pfet_06v0 ad=71.8771p pd=0.15481m as=58.1134p ps=77.985u w=76.465u l=1u
X7095 DVDD GATE BAT DVDD pfet_06v0 ad=58.9803p pd=0.12737m as=47.6862p ps=64.265u w=62.745u l=1u
X7096 BAT GATE DVDD DVDD pfet_06v0 ad=35.5072p pd=48.24u as=35.5072p ps=48.24u w=46.72u l=1u
X7097 BAT GATE DVDD DVDD pfet_06v0 ad=35.511p pd=48.245u as=43.9215p ps=95.32999u w=46.725u l=1u
X7098 DVDD GATE BAT DVDD pfet_06v0 ad=58.1134p pd=77.985u as=58.1134p ps=77.985u w=76.465u l=1u
X7099 BAT GATE DVDD DVDD pfet_06v0 ad=35.511p pd=48.245u as=35.511p ps=48.245u w=46.725u l=1u
X7100 DVDD GATE BAT DVDD pfet_06v0 ad=35.511p pd=48.245u as=35.511p ps=48.245u w=46.725u l=1u
X7101 BAT GATE DVDD DVDD pfet_06v0 ad=58.1134p pd=77.985u as=58.1134p ps=77.985u w=76.465u l=1u
X7102 DVDD GATE BAT DVDD pfet_06v0 ad=35.511p pd=48.245u as=35.511p ps=48.245u w=46.725u l=1u
X7103 BAT GATE DVDD DVDD pfet_06v0 ad=58.1172p pd=77.99u as=58.1172p ps=77.99u w=76.47u l=1u
X7104 DVDD GATE BAT DVDD pfet_06v0 ad=35.511p pd=48.245u as=35.511p ps=48.245u w=46.725u l=1u
X7105 BAT GATE DVDD DVDD pfet_06v0 ad=35.511p pd=48.245u as=35.511p ps=48.245u w=46.725u l=1u
X7106 DVDD GATE BAT DVDD pfet_06v0 ad=71.8771p pd=0.15481m as=58.1134p ps=77.985u w=76.465u l=1u
X7107 DVDD GATE BAT DVDD pfet_06v0 ad=58.1134p pd=77.985u as=58.1134p ps=77.985u w=76.465u l=1u
X7108 DVDD GATE BAT DVDD pfet_06v0 ad=47.6862p pd=64.265u as=47.6862p ps=64.265u w=62.745u l=1u
X7109 BAT GATE DVDD DVDD pfet_06v0 ad=35.5072p pd=48.24u as=35.5072p ps=48.24u w=46.72u l=1u
X7110 BAT GATE DVDD DVDD pfet_06v0 ad=58.1134p pd=77.985u as=58.1134p ps=77.985u w=76.465u l=1u
X7111 DVDD GATE BAT DVDD pfet_06v0 ad=58.1552p pd=78.04u as=58.1552p ps=78.04u w=76.52u l=1u
X7112 DVDD GATE BAT DVDD pfet_06v0 ad=58.0754p pd=77.935u as=58.0754p ps=77.935u w=76.41499u l=1u
X7113 BAT GATE DVDD DVDD pfet_06v0 ad=35.511p pd=48.245u as=35.511p ps=48.245u w=46.725u l=1u
X7114 DVDD GATE BAT DVDD pfet_06v0 ad=35.511p pd=48.245u as=35.511p ps=48.245u w=46.725u l=1u
X7115 DVDD GATE BAT DVDD pfet_06v0 ad=58.1096p pd=77.98u as=58.1096p ps=77.98u w=76.46u l=1u
X7116 DVDD GATE BAT DVDD pfet_06v0 ad=35.511p pd=48.245u as=35.511p ps=48.245u w=46.725u l=1u
X7117 DVDD GATE BAT DVDD pfet_06v0 ad=35.511p pd=48.245u as=35.511p ps=48.245u w=46.725u l=1u
X7118 DVDD GATE BAT DVDD pfet_06v0 ad=35.511p pd=48.245u as=35.511p ps=48.245u w=46.725u l=1u
X7119 BAT GATE DVDD DVDD pfet_06v0 ad=35.511p pd=48.245u as=35.511p ps=48.245u w=46.725u l=1u
X7120 DVDD GATE BAT DVDD pfet_06v0 ad=35.5072p pd=48.24u as=35.5072p ps=48.24u w=46.72u l=1u
X7121 DVDD GATE BAT DVDD pfet_06v0 ad=58.1134p pd=77.985u as=58.1134p ps=77.985u w=76.465u l=1u
X7122 DVDD GATE BAT DVDD pfet_06v0 ad=58.1134p pd=77.985u as=58.1134p ps=77.985u w=76.465u l=1u
X7123 DVDD GATE BAT DVDD pfet_06v0 ad=49.3848p pd=66.5u as=49.3848p ps=66.5u w=64.98u l=1u
X7124 BAT GATE DVDD DVDD pfet_06v0 ad=35.511p pd=48.245u as=35.511p ps=48.245u w=46.725u l=1u
X7125 BAT GATE DVDD DVDD pfet_06v0 ad=35.511p pd=48.245u as=35.511p ps=48.245u w=46.725u l=1u
X7126 DVDD GATE BAT DVDD pfet_06v0 ad=47.6862p pd=64.265u as=47.6862p ps=64.265u w=62.745u l=1u
X7127 BAT GATE DVDD DVDD pfet_06v0 ad=58.1134p pd=77.985u as=58.1134p ps=77.985u w=76.465u l=1u
X7128 BAT GATE DVDD DVDD pfet_06v0 ad=35.511p pd=48.245u as=43.9215p ps=95.32999u w=46.725u l=1u
X7129 BAT GATE DVDD DVDD pfet_06v0 ad=47.6862p pd=64.265u as=58.9803p ps=0.12737m w=62.745u l=1u
X7130 DVDD GATE BAT DVDD pfet_06v0 ad=58.1172p pd=77.99u as=58.1172p ps=77.99u w=76.47u l=1u
X7131 DVDD GATE BAT DVDD pfet_06v0 ad=58.1134p pd=77.985u as=58.1134p ps=77.985u w=76.465u l=1u
X7132 BAT GATE DVDD DVDD pfet_06v0 ad=35.511p pd=48.245u as=35.511p ps=48.245u w=46.725u l=1u
X7133 BAT GATE DVDD DVDD pfet_06v0 ad=58.1552p pd=78.04u as=58.1552p ps=78.04u w=76.52u l=1u
X7134 DVDD GATE BAT DVDD pfet_06v0 ad=58.1134p pd=77.985u as=58.1134p ps=77.985u w=76.465u l=1u
X7135 BAT GATE DVDD DVDD pfet_06v0 ad=35.5072p pd=48.24u as=43.9168p ps=95.32u w=46.72u l=1u
X7136 BAT GATE DVDD DVDD pfet_06v0 ad=35.511p pd=48.245u as=35.511p ps=48.245u w=46.725u l=1u
X7137 DVDD GATE BAT DVDD pfet_06v0 ad=58.1134p pd=77.985u as=58.1134p ps=77.985u w=76.465u l=1u
X7138 BAT GATE DVDD DVDD pfet_06v0 ad=49.3848p pd=66.5u as=49.3848p ps=66.5u w=64.98u l=1u
X7139 BAT GATE DVDD DVDD pfet_06v0 ad=35.511p pd=48.245u as=43.9215p ps=95.32999u w=46.725u l=1u
X7140 BAT GATE DVDD DVDD pfet_06v0 ad=58.1134p pd=77.985u as=58.1134p ps=77.985u w=76.465u l=1u
X7141 BAT GATE DVDD DVDD pfet_06v0 ad=58.1134p pd=77.985u as=58.1134p ps=77.985u w=76.465u l=1u
X7142 DVDD GATE BAT DVDD pfet_06v0 ad=47.6862p pd=64.265u as=47.6862p ps=64.265u w=62.745u l=1u
X7143 BAT GATE DVDD DVDD pfet_06v0 ad=35.511p pd=48.245u as=43.9215p ps=95.32999u w=46.725u l=1u
X7144 BAT GATE DVDD DVDD pfet_06v0 ad=35.511p pd=48.245u as=43.9215p ps=95.32999u w=46.725u l=1u
X7145 DVDD GATE BAT DVDD pfet_06v0 ad=35.511p pd=48.245u as=35.511p ps=48.245u w=46.725u l=1u
X7146 BAT GATE DVDD DVDD pfet_06v0 ad=58.1552p pd=78.04u as=58.1552p ps=78.04u w=76.52u l=1u
X7147 BAT GATE DVDD DVDD pfet_06v0 ad=58.0754p pd=77.935u as=71.8301p ps=0.15471m w=76.41499u l=1u
X7148 DVDD GATE BAT DVDD pfet_06v0 ad=35.511p pd=48.245u as=35.511p ps=48.245u w=46.725u l=1u
X7149 BAT GATE DVDD DVDD pfet_06v0 ad=58.1134p pd=77.985u as=71.8771p ps=0.15481m w=76.465u l=1u
X7150 DVDD GATE BAT DVDD pfet_06v0 ad=71.8771p pd=0.15481m as=58.1134p ps=77.985u w=76.465u l=1u
X7151 DVDD GATE BAT DVDD pfet_06v0 ad=58.1134p pd=77.985u as=58.1134p ps=77.985u w=76.465u l=1u
X7152 BAT GATE DVDD DVDD pfet_06v0 ad=49.3848p pd=66.5u as=49.3848p ps=66.5u w=64.98u l=1u
X7153 DVDD GATE BAT DVDD pfet_06v0 ad=71.8771p pd=0.15481m as=58.1134p ps=77.985u w=76.465u l=1u
X7154 DVDD GATE BAT DVDD pfet_06v0 ad=58.0754p pd=77.935u as=58.0754p ps=77.935u w=76.41499u l=1u
X7155 DVDD GATE BAT DVDD pfet_06v0 ad=71.8771p pd=0.15481m as=58.1134p ps=77.985u w=76.465u l=1u
X7156 DVDD GATE BAT DVDD pfet_06v0 ad=49.3848p pd=66.5u as=49.3848p ps=66.5u w=64.98u l=1u
X7157 DVDD GATE BAT DVDD pfet_06v0 ad=35.511p pd=48.245u as=35.511p ps=48.245u w=46.725u l=1u
X7158 BAT GATE DVDD DVDD pfet_06v0 ad=58.1134p pd=77.985u as=58.1134p ps=77.985u w=76.465u l=1u
X7159 BAT GATE DVDD DVDD pfet_06v0 ad=58.1134p pd=77.985u as=58.1134p ps=77.985u w=76.465u l=1u
X7160 BAT GATE DVDD DVDD pfet_06v0 ad=35.511p pd=48.245u as=43.9215p ps=95.32999u w=46.725u l=1u
X7161 BAT GATE DVDD DVDD pfet_06v0 ad=58.1134p pd=77.985u as=58.1134p ps=77.985u w=76.465u l=1u
X7162 DVDD GATE BAT DVDD pfet_06v0 ad=43.9215p pd=95.32999u as=35.511p ps=48.245u w=46.725u l=1u
X7163 BAT GATE DVDD DVDD pfet_06v0 ad=58.1552p pd=78.04u as=58.1552p ps=78.04u w=76.52u l=1u
X7164 DVDD GATE BAT DVDD pfet_06v0 ad=58.1134p pd=77.985u as=58.1134p ps=77.985u w=76.465u l=1u
X7165 DVDD GATE BAT DVDD pfet_06v0 ad=35.511p pd=48.245u as=35.511p ps=48.245u w=46.725u l=1u
X7166 BAT GATE DVDD DVDD pfet_06v0 ad=35.511p pd=48.245u as=35.511p ps=48.245u w=46.725u l=1u
X7167 BAT GATE DVDD DVDD pfet_06v0 ad=35.511p pd=48.245u as=35.511p ps=48.245u w=46.725u l=1u
X7168 BAT GATE DVDD DVDD pfet_06v0 ad=58.1134p pd=77.985u as=58.1134p ps=77.985u w=76.465u l=1u
X7169 DVDD GATE BAT DVDD pfet_06v0 ad=35.511p pd=48.245u as=35.511p ps=48.245u w=46.725u l=1u
X7170 DVDD GATE BAT DVDD pfet_06v0 ad=35.511p pd=48.245u as=35.511p ps=48.245u w=46.725u l=1u
X7171 DVDD GATE BAT DVDD pfet_06v0 ad=71.8818p pd=0.15482m as=58.1172p ps=77.99u w=76.47u l=1u
X7172 BAT GATE DVDD DVDD pfet_06v0 ad=58.1134p pd=77.985u as=58.1134p ps=77.985u w=76.465u l=1u
X7173 DVDD GATE BAT DVDD pfet_06v0 ad=58.1134p pd=77.985u as=58.1134p ps=77.985u w=76.465u l=1u
X7174 BAT GATE DVDD DVDD pfet_06v0 ad=49.3848p pd=66.5u as=49.3848p ps=66.5u w=64.98u l=1u
X7175 DVDD GATE BAT DVDD pfet_06v0 ad=35.511p pd=48.245u as=35.511p ps=48.245u w=46.725u l=1u
X7176 BAT GATE DVDD DVDD pfet_06v0 ad=35.511p pd=48.245u as=43.9215p ps=95.32999u w=46.725u l=1u
X7177 BAT GATE DVDD DVDD pfet_06v0 ad=58.1172p pd=77.99u as=58.1172p ps=77.99u w=76.47u l=1u
X7178 DVDD GATE BAT DVDD pfet_06v0 ad=58.1134p pd=77.985u as=58.1134p ps=77.985u w=76.465u l=1u
X7179 DVDD GATE BAT DVDD pfet_06v0 ad=47.6862p pd=64.265u as=47.6862p ps=64.265u w=62.745u l=1u
X7180 DVDD GATE BAT DVDD pfet_06v0 ad=58.1134p pd=77.985u as=58.1134p ps=77.985u w=76.465u l=1u
X7181 BAT GATE DVDD DVDD pfet_06v0 ad=35.511p pd=48.245u as=43.9215p ps=95.32999u w=46.725u l=1u
X7182 BAT GATE DVDD DVDD pfet_06v0 ad=35.511p pd=48.245u as=35.511p ps=48.245u w=46.725u l=1u
X7183 DVDD GATE BAT DVDD pfet_06v0 ad=58.1134p pd=77.985u as=58.1134p ps=77.985u w=76.465u l=1u
X7184 BAT GATE DVDD DVDD pfet_06v0 ad=35.511p pd=48.245u as=35.511p ps=48.245u w=46.725u l=1u
X7185 DVDD GATE BAT DVDD pfet_06v0 ad=35.511p pd=48.245u as=35.511p ps=48.245u w=46.725u l=1u
X7186 BAT GATE DVDD DVDD pfet_06v0 ad=35.511p pd=48.245u as=35.511p ps=48.245u w=46.725u l=1u
X7187 DVDD GATE BAT DVDD pfet_06v0 ad=58.1096p pd=77.98u as=58.1096p ps=77.98u w=76.46u l=1u
X7188 DVDD GATE BAT DVDD pfet_06v0 ad=71.8771p pd=0.15481m as=58.1134p ps=77.985u w=76.465u l=1u
X7189 DVDD GATE BAT DVDD pfet_06v0 ad=58.1134p pd=77.985u as=58.1134p ps=77.985u w=76.465u l=1u
X7190 BAT GATE DVDD DVDD pfet_06v0 ad=35.5072p pd=48.24u as=35.5072p ps=48.24u w=46.72u l=1u
X7191 BAT GATE DVDD DVDD pfet_06v0 ad=35.511p pd=48.245u as=35.511p ps=48.245u w=46.725u l=1u
X7192 DVDD GATE BAT DVDD pfet_06v0 ad=35.511p pd=48.245u as=35.511p ps=48.245u w=46.725u l=1u
X7193 BAT GATE DVDD DVDD pfet_06v0 ad=58.1134p pd=77.985u as=58.1134p ps=77.985u w=76.465u l=1u
X7194 BAT GATE DVDD DVDD pfet_06v0 ad=58.1172p pd=77.99u as=71.8818p ps=0.15482m w=76.47u l=1u
X7195 DVDD GATE BAT DVDD pfet_06v0 ad=35.511p pd=48.245u as=35.511p ps=48.245u w=46.725u l=1u
X7196 BAT GATE DVDD DVDD pfet_06v0 ad=35.511p pd=48.245u as=43.9215p ps=95.32999u w=46.725u l=1u
X7197 DVDD GATE BAT DVDD pfet_06v0 ad=35.5072p pd=48.24u as=35.5072p ps=48.24u w=46.72u l=1u
X7198 BAT GATE DVDD DVDD pfet_06v0 ad=35.511p pd=48.245u as=43.9215p ps=95.32999u w=46.725u l=1u
X7199 DVDD GATE BAT DVDD pfet_06v0 ad=58.1096p pd=77.98u as=58.1096p ps=77.98u w=76.46u l=1u
X7200 BAT GATE DVDD DVDD pfet_06v0 ad=58.1134p pd=77.985u as=58.1134p ps=77.985u w=76.465u l=1u
X7201 BAT GATE DVDD DVDD pfet_06v0 ad=47.6862p pd=64.265u as=47.6862p ps=64.265u w=62.745u l=1u
X7202 BAT GATE DVDD DVDD pfet_06v0 ad=58.1134p pd=77.985u as=58.1134p ps=77.985u w=76.465u l=1u
X7203 BAT GATE DVDD DVDD pfet_06v0 ad=58.1134p pd=77.985u as=58.1134p ps=77.985u w=76.465u l=1u
X7204 BAT GATE DVDD DVDD pfet_06v0 ad=35.511p pd=48.245u as=35.511p ps=48.245u w=46.725u l=1u
X7205 DVDD GATE BAT DVDD pfet_06v0 ad=35.511p pd=48.245u as=35.511p ps=48.245u w=46.725u l=1u
X7206 BAT GATE DVDD DVDD pfet_06v0 ad=35.511p pd=48.245u as=35.511p ps=48.245u w=46.725u l=1u
X7207 BAT GATE DVDD DVDD pfet_06v0 ad=58.1134p pd=77.985u as=58.1134p ps=77.985u w=76.465u l=1u
X7208 DVDD GATE BAT DVDD pfet_06v0 ad=35.511p pd=48.245u as=35.511p ps=48.245u w=46.725u l=1u
X7209 DVDD GATE BAT DVDD pfet_06v0 ad=43.9215p pd=95.32999u as=35.511p ps=48.245u w=46.725u l=1u
X7210 DVDD GATE BAT DVDD pfet_06v0 ad=35.511p pd=48.245u as=35.511p ps=48.245u w=46.725u l=1u
X7211 BAT GATE DVDD DVDD pfet_06v0 ad=58.1552p pd=78.04u as=71.92879p ps=0.15492m w=76.52u l=1u
X7212 BAT GATE DVDD DVDD pfet_06v0 ad=47.6862p pd=64.265u as=47.6862p ps=64.265u w=62.745u l=1u
X7213 DVDD GATE BAT DVDD pfet_06v0 ad=35.511p pd=48.245u as=35.511p ps=48.245u w=46.725u l=1u
X7214 DVDD GATE BAT DVDD pfet_06v0 ad=71.92879p pd=0.15492m as=58.1552p ps=78.04u w=76.52u l=1u
X7215 DVDD GATE BAT DVDD pfet_06v0 ad=58.0754p pd=77.935u as=58.0754p ps=77.935u w=76.41499u l=1u
X7216 DVDD GATE BAT DVDD pfet_06v0 ad=35.511p pd=48.245u as=35.511p ps=48.245u w=46.725u l=1u
X7217 BAT GATE DVDD DVDD pfet_06v0 ad=35.511p pd=48.245u as=35.511p ps=48.245u w=46.725u l=1u
X7218 BAT GATE DVDD DVDD pfet_06v0 ad=35.511p pd=48.245u as=43.9215p ps=95.32999u w=46.725u l=1u
X7219 DVDD GATE BAT DVDD pfet_06v0 ad=43.9168p pd=95.32u as=35.5072p ps=48.24u w=46.72u l=1u
X7220 DVDD GATE BAT DVDD pfet_06v0 ad=58.1134p pd=77.985u as=58.1134p ps=77.985u w=76.465u l=1u
X7221 DVDD GATE BAT DVDD pfet_06v0 ad=71.8771p pd=0.15481m as=58.1134p ps=77.985u w=76.465u l=1u
X7222 DVDD GATE BAT DVDD pfet_06v0 ad=35.511p pd=48.245u as=35.511p ps=48.245u w=46.725u l=1u
X7223 BAT GATE DVDD DVDD pfet_06v0 ad=58.1134p pd=77.985u as=58.1134p ps=77.985u w=76.465u l=1u
X7224 DVDD GATE BAT DVDD pfet_06v0 ad=58.1096p pd=77.98u as=58.1096p ps=77.98u w=76.46u l=1u
X7225 DVDD GATE BAT DVDD pfet_06v0 ad=35.511p pd=48.245u as=35.511p ps=48.245u w=46.725u l=1u
X7226 DVDD GATE BAT DVDD pfet_06v0 ad=58.1134p pd=77.985u as=58.1134p ps=77.985u w=76.465u l=1u
X7227 BAT GATE DVDD DVDD pfet_06v0 ad=35.511p pd=48.245u as=35.511p ps=48.245u w=46.725u l=1u
X7228 BAT GATE DVDD DVDD pfet_06v0 ad=35.511p pd=48.245u as=35.511p ps=48.245u w=46.725u l=1u
X7229 DVDD GATE BAT DVDD pfet_06v0 ad=43.9215p pd=95.32999u as=35.511p ps=48.245u w=46.725u l=1u
X7230 BAT GATE DVDD DVDD pfet_06v0 ad=58.1134p pd=77.985u as=58.1134p ps=77.985u w=76.465u l=1u
X7231 DVDD GATE BAT DVDD pfet_06v0 ad=35.511p pd=48.245u as=35.511p ps=48.245u w=46.725u l=1u
X7232 DVDD GATE BAT DVDD pfet_06v0 ad=35.511p pd=48.245u as=35.511p ps=48.245u w=46.725u l=1u
X7233 BAT GATE DVDD DVDD pfet_06v0 ad=47.6862p pd=64.265u as=47.6862p ps=64.265u w=62.745u l=1u
X7234 BAT GATE DVDD DVDD pfet_06v0 ad=58.1134p pd=77.985u as=58.1134p ps=77.985u w=76.465u l=1u
X7235 BAT GATE DVDD DVDD pfet_06v0 ad=58.1134p pd=77.985u as=58.1134p ps=77.985u w=76.465u l=1u
X7236 DVDD GATE BAT DVDD pfet_06v0 ad=58.1096p pd=77.98u as=58.1096p ps=77.98u w=76.46u l=1u
X7237 DVDD GATE BAT DVDD pfet_06v0 ad=43.9215p pd=95.32999u as=35.511p ps=48.245u w=46.725u l=1u
X7238 BAT GATE DVDD DVDD pfet_06v0 ad=35.511p pd=48.245u as=35.511p ps=48.245u w=46.725u l=1u
X7239 DVDD GATE BAT DVDD pfet_06v0 ad=49.3848p pd=66.5u as=49.3848p ps=66.5u w=64.98u l=1u
X7240 DVDD GATE BAT DVDD pfet_06v0 ad=71.8771p pd=0.15481m as=58.1134p ps=77.985u w=76.465u l=1u
X7241 DVDD GATE BAT DVDD pfet_06v0 ad=61.0812p pd=0.13184m as=49.3848p ps=66.5u w=64.98u l=1u
X7242 DVDD GATE BAT DVDD pfet_06v0 ad=58.1096p pd=77.98u as=58.1096p ps=77.98u w=76.46u l=1u
X7243 DVDD GATE BAT DVDD pfet_06v0 ad=58.1552p pd=78.04u as=58.1552p ps=78.04u w=76.52u l=1u
X7244 DVDD GATE BAT DVDD pfet_06v0 ad=58.1134p pd=77.985u as=58.1134p ps=77.985u w=76.465u l=1u
X7245 BAT GATE DVDD DVDD pfet_06v0 ad=58.1552p pd=78.04u as=71.92879p ps=0.15492m w=76.52u l=1u
X7246 DVDD GATE BAT DVDD pfet_06v0 ad=43.9215p pd=95.32999u as=35.511p ps=48.245u w=46.725u l=1u
X7247 DVDD GATE BAT DVDD pfet_06v0 ad=58.1134p pd=77.985u as=58.1134p ps=77.985u w=76.465u l=1u
X7248 DVDD GATE BAT DVDD pfet_06v0 ad=35.511p pd=48.245u as=35.511p ps=48.245u w=46.725u l=1u
X7249 DVDD GATE BAT DVDD pfet_06v0 ad=35.511p pd=48.245u as=35.511p ps=48.245u w=46.725u l=1u
X7250 BAT GATE DVDD DVDD pfet_06v0 ad=58.1134p pd=77.985u as=58.1134p ps=77.985u w=76.465u l=1u
X7251 DVDD GATE BAT DVDD pfet_06v0 ad=35.5072p pd=48.24u as=35.5072p ps=48.24u w=46.72u l=1u
X7252 BAT GATE DVDD DVDD pfet_06v0 ad=35.511p pd=48.245u as=35.511p ps=48.245u w=46.725u l=1u
X7253 BAT GATE DVDD DVDD pfet_06v0 ad=35.511p pd=48.245u as=35.511p ps=48.245u w=46.725u l=1u
X7254 DVDD GATE BAT DVDD pfet_06v0 ad=43.9168p pd=95.32u as=35.5072p ps=48.24u w=46.72u l=1u
X7255 DVDD GATE BAT DVDD pfet_06v0 ad=58.1172p pd=77.99u as=58.1172p ps=77.99u w=76.47u l=1u
X7256 DVDD GATE BAT DVDD pfet_06v0 ad=58.1134p pd=77.985u as=58.1134p ps=77.985u w=76.465u l=1u
X7257 DVDD GATE BAT DVDD pfet_06v0 ad=58.1552p pd=78.04u as=58.1552p ps=78.04u w=76.52u l=1u
X7258 BAT GATE DVDD DVDD pfet_06v0 ad=58.1134p pd=77.985u as=58.1134p ps=77.985u w=76.465u l=1u
X7259 DVDD GATE BAT DVDD pfet_06v0 ad=58.1134p pd=77.985u as=58.1134p ps=77.985u w=76.465u l=1u
X7260 BAT GATE DVDD DVDD pfet_06v0 ad=35.511p pd=48.245u as=35.511p ps=48.245u w=46.725u l=1u
X7261 DVDD GATE BAT DVDD pfet_06v0 ad=43.9215p pd=95.32999u as=35.511p ps=48.245u w=46.725u l=1u
X7262 DVDD GATE BAT DVDD pfet_06v0 ad=35.511p pd=48.245u as=35.511p ps=48.245u w=46.725u l=1u
X7263 BAT GATE DVDD DVDD pfet_06v0 ad=58.1134p pd=77.985u as=58.1134p ps=77.985u w=76.465u l=1u
X7264 DVDD GATE BAT DVDD pfet_06v0 ad=58.1134p pd=77.985u as=58.1134p ps=77.985u w=76.465u l=1u
X7265 DVDD GATE BAT DVDD pfet_06v0 ad=58.1134p pd=77.985u as=58.1134p ps=77.985u w=76.465u l=1u
X7266 BAT GATE DVDD DVDD pfet_06v0 ad=58.1134p pd=77.985u as=58.1134p ps=77.985u w=76.465u l=1u
X7267 DVDD GATE BAT DVDD pfet_06v0 ad=58.1134p pd=77.985u as=58.1134p ps=77.985u w=76.465u l=1u
X7268 DVDD GATE BAT DVDD pfet_06v0 ad=35.511p pd=48.245u as=35.511p ps=48.245u w=46.725u l=1u
X7269 BAT GATE DVDD DVDD pfet_06v0 ad=35.511p pd=48.245u as=35.511p ps=48.245u w=46.725u l=1u
X7270 BAT GATE DVDD DVDD pfet_06v0 ad=35.511p pd=48.245u as=35.511p ps=48.245u w=46.725u l=1u
X7271 DVDD GATE BAT DVDD pfet_06v0 ad=71.8771p pd=0.15481m as=58.1134p ps=77.985u w=76.465u l=1u
X7272 DVDD GATE BAT DVDD pfet_06v0 ad=71.8771p pd=0.15481m as=58.1134p ps=77.985u w=76.465u l=1u
X7273 DVDD GATE BAT DVDD pfet_06v0 ad=47.6862p pd=64.265u as=47.6862p ps=64.265u w=62.745u l=1u
X7274 DVDD GATE BAT DVDD pfet_06v0 ad=58.1134p pd=77.985u as=58.1134p ps=77.985u w=76.465u l=1u
X7275 DVDD GATE BAT DVDD pfet_06v0 ad=58.0754p pd=77.935u as=58.0754p ps=77.935u w=76.41499u l=1u
X7276 DVDD GATE BAT DVDD pfet_06v0 ad=58.1134p pd=77.985u as=58.1134p ps=77.985u w=76.465u l=1u
X7277 BAT GATE DVDD DVDD pfet_06v0 ad=35.511p pd=48.245u as=43.9215p ps=95.32999u w=46.725u l=1u
X7278 DVDD GATE BAT DVDD pfet_06v0 ad=43.9215p pd=95.32999u as=35.511p ps=48.245u w=46.725u l=1u
X7279 DVDD GATE BAT DVDD pfet_06v0 ad=58.1096p pd=77.98u as=58.1096p ps=77.98u w=76.46u l=1u
X7280 BAT GATE DVDD DVDD pfet_06v0 ad=58.1172p pd=77.99u as=58.1172p ps=77.99u w=76.47u l=1u
X7281 BAT GATE DVDD DVDD pfet_06v0 ad=58.1134p pd=77.985u as=58.1134p ps=77.985u w=76.465u l=1u
X7282 BAT GATE DVDD DVDD pfet_06v0 ad=58.1134p pd=77.985u as=58.1134p ps=77.985u w=76.465u l=1u
X7283 BAT GATE DVDD DVDD pfet_06v0 ad=47.6862p pd=64.265u as=58.9803p ps=0.12737m w=62.745u l=1u
X7284 BAT GATE DVDD DVDD pfet_06v0 ad=58.1134p pd=77.985u as=58.1134p ps=77.985u w=76.465u l=1u
X7285 DVDD GATE BAT DVDD pfet_06v0 ad=58.1552p pd=78.04u as=58.1552p ps=78.04u w=76.52u l=1u
X7286 DVDD GATE BAT DVDD pfet_06v0 ad=35.511p pd=48.245u as=35.511p ps=48.245u w=46.725u l=1u
X7287 BAT GATE DVDD DVDD pfet_06v0 ad=58.1134p pd=77.985u as=71.8771p ps=0.15481m w=76.465u l=1u
X7288 DVDD GATE BAT DVDD pfet_06v0 ad=58.0754p pd=77.935u as=58.0754p ps=77.935u w=76.41499u l=1u
X7289 BAT GATE DVDD DVDD pfet_06v0 ad=35.511p pd=48.245u as=35.511p ps=48.245u w=46.725u l=1u
X7290 BAT GATE DVDD DVDD pfet_06v0 ad=35.511p pd=48.245u as=43.9215p ps=95.32999u w=46.725u l=1u
X7291 BAT GATE DVDD DVDD pfet_06v0 ad=35.511p pd=48.245u as=35.511p ps=48.245u w=46.725u l=1u
X7292 BAT GATE DVDD DVDD pfet_06v0 ad=35.511p pd=48.245u as=35.511p ps=48.245u w=46.725u l=1u
X7293 DVDD GATE BAT DVDD pfet_06v0 ad=35.5072p pd=48.24u as=35.5072p ps=48.24u w=46.72u l=1u
X7294 BAT GATE DVDD DVDD pfet_06v0 ad=58.1134p pd=77.985u as=58.1134p ps=77.985u w=76.465u l=1u
X7295 BAT GATE DVDD DVDD pfet_06v0 ad=47.6862p pd=64.265u as=47.6862p ps=64.265u w=62.745u l=1u
X7296 DVDD GATE BAT DVDD pfet_06v0 ad=35.5072p pd=48.24u as=35.5072p ps=48.24u w=46.72u l=1u
X7297 BAT GATE DVDD DVDD pfet_06v0 ad=35.511p pd=48.245u as=35.511p ps=48.245u w=46.725u l=1u
X7298 DVDD GATE BAT DVDD pfet_06v0 ad=71.8771p pd=0.15481m as=58.1134p ps=77.985u w=76.465u l=1u
X7299 BAT GATE DVDD DVDD pfet_06v0 ad=58.1096p pd=77.98u as=58.1096p ps=77.98u w=76.46u l=1u
X7300 DVDD GATE BAT DVDD pfet_06v0 ad=58.1134p pd=77.985u as=58.1134p ps=77.985u w=76.465u l=1u
X7301 DVDD GATE BAT DVDD pfet_06v0 ad=58.1134p pd=77.985u as=58.1134p ps=77.985u w=76.465u l=1u
X7302 DVDD GATE BAT DVDD pfet_06v0 ad=35.511p pd=48.245u as=35.511p ps=48.245u w=46.725u l=1u
X7303 DVDD GATE BAT DVDD pfet_06v0 ad=43.9215p pd=95.32999u as=35.511p ps=48.245u w=46.725u l=1u
X7304 BAT GATE DVDD DVDD pfet_06v0 ad=58.1134p pd=77.985u as=58.1134p ps=77.985u w=76.465u l=1u
X7305 BAT GATE DVDD DVDD pfet_06v0 ad=58.1134p pd=77.985u as=58.1134p ps=77.985u w=76.465u l=1u
X7306 BAT GATE DVDD DVDD pfet_06v0 ad=58.1096p pd=77.98u as=58.1096p ps=77.98u w=76.46u l=1u
X7307 BAT GATE DVDD DVDD pfet_06v0 ad=35.511p pd=48.245u as=35.511p ps=48.245u w=46.725u l=1u
X7308 DVDD GATE BAT DVDD pfet_06v0 ad=58.1172p pd=77.99u as=58.1172p ps=77.99u w=76.47u l=1u
X7309 BAT GATE DVDD DVDD pfet_06v0 ad=35.511p pd=48.245u as=43.9215p ps=95.32999u w=46.725u l=1u
X7310 DVDD GATE BAT DVDD pfet_06v0 ad=71.8771p pd=0.15481m as=58.1134p ps=77.985u w=76.465u l=1u
X7311 BAT GATE DVDD DVDD pfet_06v0 ad=35.511p pd=48.245u as=35.511p ps=48.245u w=46.725u l=1u
X7312 DVDD GATE BAT DVDD pfet_06v0 ad=71.8771p pd=0.15481m as=58.1134p ps=77.985u w=76.465u l=1u
X7313 DVDD GATE BAT DVDD pfet_06v0 ad=43.9215p pd=95.32999u as=35.511p ps=48.245u w=46.725u l=1u
X7314 BAT GATE DVDD DVDD pfet_06v0 ad=49.3848p pd=66.5u as=49.3848p ps=66.5u w=64.98u l=1u
X7315 DVDD GATE BAT DVDD pfet_06v0 ad=58.1134p pd=77.985u as=58.1134p ps=77.985u w=76.465u l=1u
X7316 BAT GATE DVDD DVDD pfet_06v0 ad=35.5072p pd=48.24u as=35.5072p ps=48.24u w=46.72u l=1u
X7317 DVDD GATE BAT DVDD pfet_06v0 ad=71.8771p pd=0.15481m as=58.1134p ps=77.985u w=76.465u l=1u
X7318 DVDD GATE BAT DVDD pfet_06v0 ad=58.1134p pd=77.985u as=58.1134p ps=77.985u w=76.465u l=1u
X7319 BAT GATE DVDD DVDD pfet_06v0 ad=35.511p pd=48.245u as=43.9215p ps=95.32999u w=46.725u l=1u
X7320 BAT GATE DVDD DVDD pfet_06v0 ad=49.3848p pd=66.5u as=49.3848p ps=66.5u w=64.98u l=1u
X7321 BAT GATE DVDD DVDD pfet_06v0 ad=35.511p pd=48.245u as=35.511p ps=48.245u w=46.725u l=1u
X7322 DVDD GATE BAT DVDD pfet_06v0 ad=47.6862p pd=64.265u as=47.6862p ps=64.265u w=62.745u l=1u
X7323 BAT GATE DVDD DVDD pfet_06v0 ad=58.1134p pd=77.985u as=58.1134p ps=77.985u w=76.465u l=1u
X7324 BAT GATE DVDD DVDD pfet_06v0 ad=35.511p pd=48.245u as=35.511p ps=48.245u w=46.725u l=1u
X7325 DVDD GATE BAT DVDD pfet_06v0 ad=58.1096p pd=77.98u as=58.1096p ps=77.98u w=76.46u l=1u
X7326 DVDD GATE BAT DVDD pfet_06v0 ad=35.511p pd=48.245u as=35.511p ps=48.245u w=46.725u l=1u
X7327 BAT GATE DVDD DVDD pfet_06v0 ad=35.511p pd=48.245u as=35.511p ps=48.245u w=46.725u l=1u
X7328 DVDD GATE BAT DVDD pfet_06v0 ad=58.1552p pd=78.04u as=58.1552p ps=78.04u w=76.52u l=1u
X7329 BAT GATE DVDD DVDD pfet_06v0 ad=35.511p pd=48.245u as=43.9215p ps=95.32999u w=46.725u l=1u
X7330 DVDD GATE BAT DVDD pfet_06v0 ad=35.511p pd=48.245u as=35.511p ps=48.245u w=46.725u l=1u
X7331 DVDD GATE BAT DVDD pfet_06v0 ad=43.9215p pd=95.32999u as=35.511p ps=48.245u w=46.725u l=1u
X7332 BAT GATE DVDD DVDD pfet_06v0 ad=58.0754p pd=77.935u as=58.0754p ps=77.935u w=76.41499u l=1u
X7333 DVDD GATE BAT DVDD pfet_06v0 ad=35.511p pd=48.245u as=35.511p ps=48.245u w=46.725u l=1u
X7334 DVDD GATE BAT DVDD pfet_06v0 ad=35.511p pd=48.245u as=35.511p ps=48.245u w=46.725u l=1u
X7335 BAT GATE DVDD DVDD pfet_06v0 ad=58.1134p pd=77.985u as=58.1134p ps=77.985u w=76.465u l=1u
X7336 BAT GATE DVDD DVDD pfet_06v0 ad=35.511p pd=48.245u as=43.9215p ps=95.32999u w=46.725u l=1u
X7337 DVDD GATE BAT DVDD pfet_06v0 ad=35.511p pd=48.245u as=35.511p ps=48.245u w=46.725u l=1u
X7338 BAT GATE DVDD DVDD pfet_06v0 ad=58.1134p pd=77.985u as=58.1134p ps=77.985u w=76.465u l=1u
X7339 BAT GATE DVDD DVDD pfet_06v0 ad=58.1134p pd=77.985u as=58.1134p ps=77.985u w=76.465u l=1u
X7340 BAT GATE DVDD DVDD pfet_06v0 ad=58.1096p pd=77.98u as=71.8724p ps=0.1548m w=76.46u l=1u
X7341 DVDD GATE BAT DVDD pfet_06v0 ad=58.1134p pd=77.985u as=58.1134p ps=77.985u w=76.465u l=1u
X7342 DVDD GATE BAT DVDD pfet_06v0 ad=47.6862p pd=64.265u as=47.6862p ps=64.265u w=62.745u l=1u
X7343 DVDD GATE BAT DVDD pfet_06v0 ad=58.1172p pd=77.99u as=58.1172p ps=77.99u w=76.47u l=1u
X7344 DVDD GATE BAT DVDD pfet_06v0 ad=35.511p pd=48.245u as=35.511p ps=48.245u w=46.725u l=1u
X7345 BAT GATE DVDD DVDD pfet_06v0 ad=35.511p pd=48.245u as=35.511p ps=48.245u w=46.725u l=1u
X7346 DVDD GATE BAT DVDD pfet_06v0 ad=35.5072p pd=48.24u as=35.5072p ps=48.24u w=46.72u l=1u
X7347 BAT GATE DVDD DVDD pfet_06v0 ad=58.1134p pd=77.985u as=58.1134p ps=77.985u w=76.465u l=1u
X7348 BAT GATE DVDD DVDD pfet_06v0 ad=47.6862p pd=64.265u as=47.6862p ps=64.265u w=62.745u l=1u
X7349 DVDD GATE BAT DVDD pfet_06v0 ad=58.1134p pd=77.985u as=58.1134p ps=77.985u w=76.465u l=1u
X7350 DVDD GATE BAT DVDD pfet_06v0 ad=58.1134p pd=77.985u as=58.1134p ps=77.985u w=76.465u l=1u
X7351 DVDD GATE BAT DVDD pfet_06v0 ad=35.511p pd=48.245u as=35.511p ps=48.245u w=46.725u l=1u
X7352 DVDD GATE BAT DVDD pfet_06v0 ad=43.9215p pd=95.32999u as=35.511p ps=48.245u w=46.725u l=1u
X7353 DVDD GATE BAT DVDD pfet_06v0 ad=58.1134p pd=77.985u as=58.1134p ps=77.985u w=76.465u l=1u
X7354 DVDD GATE BAT DVDD pfet_06v0 ad=35.511p pd=48.245u as=35.511p ps=48.245u w=46.725u l=1u
X7355 DVDD GATE BAT DVDD pfet_06v0 ad=35.511p pd=48.245u as=35.511p ps=48.245u w=46.725u l=1u
X7356 BAT GATE DVDD DVDD pfet_06v0 ad=58.1552p pd=78.04u as=58.1552p ps=78.04u w=76.52u l=1u
X7357 BAT GATE DVDD DVDD pfet_06v0 ad=49.3848p pd=66.5u as=49.3848p ps=66.5u w=64.98u l=1u
X7358 DVDD GATE BAT DVDD pfet_06v0 ad=71.8818p pd=0.15482m as=58.1172p ps=77.99u w=76.47u l=1u
X7359 BAT GATE DVDD DVDD pfet_06v0 ad=49.3848p pd=66.5u as=49.3848p ps=66.5u w=64.98u l=1u
X7360 BAT GATE DVDD DVDD pfet_06v0 ad=35.511p pd=48.245u as=35.511p ps=48.245u w=46.725u l=1u
X7361 BAT GATE DVDD DVDD pfet_06v0 ad=58.1134p pd=77.985u as=58.1134p ps=77.985u w=76.465u l=1u
X7362 BAT GATE DVDD DVDD pfet_06v0 ad=35.511p pd=48.245u as=35.511p ps=48.245u w=46.725u l=1u
X7363 BAT GATE DVDD DVDD pfet_06v0 ad=58.1552p pd=78.04u as=58.1552p ps=78.04u w=76.52u l=1u
X7364 DVDD GATE BAT DVDD pfet_06v0 ad=58.1134p pd=77.985u as=58.1134p ps=77.985u w=76.465u l=1u
X7365 DVDD GATE BAT DVDD pfet_06v0 ad=58.1134p pd=77.985u as=58.1134p ps=77.985u w=76.465u l=1u
X7366 DVDD GATE BAT DVDD pfet_06v0 ad=35.511p pd=48.245u as=35.511p ps=48.245u w=46.725u l=1u
X7367 DVDD GATE BAT DVDD pfet_06v0 ad=35.511p pd=48.245u as=35.511p ps=48.245u w=46.725u l=1u
X7368 DVDD GATE BAT DVDD pfet_06v0 ad=58.1552p pd=78.04u as=58.1552p ps=78.04u w=76.52u l=1u
X7369 DVDD GATE BAT DVDD pfet_06v0 ad=71.8771p pd=0.15481m as=58.1134p ps=77.985u w=76.465u l=1u
X7370 DVDD GATE BAT DVDD pfet_06v0 ad=35.511p pd=48.245u as=35.511p ps=48.245u w=46.725u l=1u
X7371 BAT GATE DVDD DVDD pfet_06v0 ad=58.1134p pd=77.985u as=58.1134p ps=77.985u w=76.465u l=1u
X7372 DVDD GATE BAT DVDD pfet_06v0 ad=58.1096p pd=77.98u as=58.1096p ps=77.98u w=76.46u l=1u
X7373 DVDD GATE BAT DVDD pfet_06v0 ad=58.0754p pd=77.935u as=58.0754p ps=77.935u w=76.41499u l=1u
X7374 DVDD GATE BAT DVDD pfet_06v0 ad=43.9215p pd=95.32999u as=35.511p ps=48.245u w=46.725u l=1u
X7375 BAT GATE DVDD DVDD pfet_06v0 ad=35.511p pd=48.245u as=35.511p ps=48.245u w=46.725u l=1u
X7376 BAT GATE DVDD DVDD pfet_06v0 ad=35.511p pd=48.245u as=35.511p ps=48.245u w=46.725u l=1u
X7377 BAT GATE DVDD DVDD pfet_06v0 ad=58.1134p pd=77.985u as=58.1134p ps=77.985u w=76.465u l=1u
X7378 DVDD GATE BAT DVDD pfet_06v0 ad=58.1134p pd=77.985u as=58.1134p ps=77.985u w=76.465u l=1u
X7379 BAT GATE DVDD DVDD pfet_06v0 ad=58.1172p pd=77.99u as=58.1172p ps=77.99u w=76.47u l=1u
X7380 BAT GATE DVDD DVDD pfet_06v0 ad=58.1134p pd=77.985u as=71.8771p ps=0.15481m w=76.465u l=1u
X7381 BAT GATE DVDD DVDD pfet_06v0 ad=58.1134p pd=77.985u as=71.8771p ps=0.15481m w=76.465u l=1u
X7382 DVDD GATE BAT DVDD pfet_06v0 ad=49.3848p pd=66.5u as=49.3848p ps=66.5u w=64.98u l=1u
X7383 BAT GATE DVDD DVDD pfet_06v0 ad=58.1134p pd=77.985u as=71.8771p ps=0.15481m w=76.465u l=1u
X7384 DVDD GATE BAT DVDD pfet_06v0 ad=35.5072p pd=48.24u as=35.5072p ps=48.24u w=46.72u l=1u
X7385 BAT GATE DVDD DVDD pfet_06v0 ad=58.1134p pd=77.985u as=58.1134p ps=77.985u w=76.465u l=1u
X7386 BAT GATE DVDD DVDD pfet_06v0 ad=58.0754p pd=77.935u as=58.0754p ps=77.935u w=76.41499u l=1u
X7387 BAT GATE DVDD DVDD pfet_06v0 ad=58.1134p pd=77.985u as=58.1134p ps=77.985u w=76.465u l=1u
X7388 DVDD GATE BAT DVDD pfet_06v0 ad=61.0812p pd=0.13184m as=49.3848p ps=66.5u w=64.98u l=1u
X7389 BAT GATE DVDD DVDD pfet_06v0 ad=58.1134p pd=77.985u as=71.8771p ps=0.15481m w=76.465u l=1u
X7390 BAT GATE DVDD DVDD pfet_06v0 ad=58.1134p pd=77.985u as=58.1134p ps=77.985u w=76.465u l=1u
X7391 BAT GATE DVDD DVDD pfet_06v0 ad=58.0754p pd=77.935u as=58.0754p ps=77.935u w=76.41499u l=1u
X7392 BAT GATE DVDD DVDD pfet_06v0 ad=58.1096p pd=77.98u as=58.1096p ps=77.98u w=76.46u l=1u
X7393 BAT GATE DVDD DVDD pfet_06v0 ad=35.511p pd=48.245u as=35.511p ps=48.245u w=46.725u l=1u
X7394 DVDD GATE BAT DVDD pfet_06v0 ad=49.3848p pd=66.5u as=49.3848p ps=66.5u w=64.98u l=1u
X7395 BAT GATE DVDD DVDD pfet_06v0 ad=58.1134p pd=77.985u as=58.1134p ps=77.985u w=76.465u l=1u
X7396 BAT GATE DVDD DVDD pfet_06v0 ad=58.0754p pd=77.935u as=58.0754p ps=77.935u w=76.41499u l=1u
X7397 BAT GATE DVDD DVDD pfet_06v0 ad=49.3848p pd=66.5u as=49.3848p ps=66.5u w=64.98u l=1u
X7398 BAT GATE DVDD DVDD pfet_06v0 ad=58.1096p pd=77.98u as=58.1096p ps=77.98u w=76.46u l=1u
X7399 BAT GATE DVDD DVDD pfet_06v0 ad=35.511p pd=48.245u as=43.9215p ps=95.32999u w=46.725u l=1u
X7400 BAT GATE DVDD DVDD pfet_06v0 ad=58.1552p pd=78.04u as=58.1552p ps=78.04u w=76.52u l=1u
X7401 DVDD GATE BAT DVDD pfet_06v0 ad=43.9215p pd=95.32999u as=35.511p ps=48.245u w=46.725u l=1u
X7402 BAT GATE DVDD DVDD pfet_06v0 ad=35.511p pd=48.245u as=35.511p ps=48.245u w=46.725u l=1u
X7403 BAT GATE DVDD DVDD pfet_06v0 ad=35.5072p pd=48.24u as=35.5072p ps=48.24u w=46.72u l=1u
X7404 DVDD GATE BAT DVDD pfet_06v0 ad=58.1134p pd=77.985u as=58.1134p ps=77.985u w=76.465u l=1u
X7405 BAT GATE DVDD DVDD pfet_06v0 ad=35.511p pd=48.245u as=35.511p ps=48.245u w=46.725u l=1u
X7406 DVDD GATE BAT DVDD pfet_06v0 ad=47.6862p pd=64.265u as=47.6862p ps=64.265u w=62.745u l=1u
X7407 DVDD GATE BAT DVDD pfet_06v0 ad=35.511p pd=48.245u as=35.511p ps=48.245u w=46.725u l=1u
X7408 DVDD GATE BAT DVDD pfet_06v0 ad=35.511p pd=48.245u as=35.511p ps=48.245u w=46.725u l=1u
X7409 BAT GATE DVDD DVDD pfet_06v0 ad=58.1172p pd=77.99u as=58.1172p ps=77.99u w=76.47u l=1u
X7410 BAT GATE DVDD DVDD pfet_06v0 ad=35.511p pd=48.245u as=35.511p ps=48.245u w=46.725u l=1u
X7411 DVDD GATE BAT DVDD pfet_06v0 ad=58.9803p pd=0.12737m as=47.6862p ps=64.265u w=62.745u l=1u
X7412 DVDD GATE BAT DVDD pfet_06v0 ad=58.1134p pd=77.985u as=58.1134p ps=77.985u w=76.465u l=1u
X7413 BAT GATE DVDD DVDD pfet_06v0 ad=58.1134p pd=77.985u as=58.1134p ps=77.985u w=76.465u l=1u
X7414 DVDD GATE BAT DVDD pfet_06v0 ad=71.8771p pd=0.15481m as=58.1134p ps=77.985u w=76.465u l=1u
X7415 BAT GATE DVDD DVDD pfet_06v0 ad=58.1134p pd=77.985u as=58.1134p ps=77.985u w=76.465u l=1u
X7416 DVDD GATE BAT DVDD pfet_06v0 ad=49.3848p pd=66.5u as=49.3848p ps=66.5u w=64.98u l=1u
X7417 BAT GATE DVDD DVDD pfet_06v0 ad=58.1134p pd=77.985u as=58.1134p ps=77.985u w=76.465u l=1u
X7418 BAT GATE DVDD DVDD pfet_06v0 ad=35.511p pd=48.245u as=35.511p ps=48.245u w=46.725u l=1u
X7419 BAT GATE DVDD DVDD pfet_06v0 ad=35.511p pd=48.245u as=35.511p ps=48.245u w=46.725u l=1u
X7420 DVDD GATE BAT DVDD pfet_06v0 ad=71.8724p pd=0.1548m as=58.1096p ps=77.98u w=76.46u l=1u
X7421 BAT GATE DVDD DVDD pfet_06v0 ad=35.511p pd=48.245u as=35.511p ps=48.245u w=46.725u l=1u
X7422 DVDD GATE BAT DVDD pfet_06v0 ad=43.9215p pd=95.32999u as=35.511p ps=48.245u w=46.725u l=1u
X7423 BAT GATE DVDD DVDD pfet_06v0 ad=58.1134p pd=77.985u as=58.1134p ps=77.985u w=76.465u l=1u
X7424 BAT GATE DVDD DVDD pfet_06v0 ad=47.6862p pd=64.265u as=58.9803p ps=0.12737m w=62.745u l=1u
X7425 DVDD GATE BAT DVDD pfet_06v0 ad=35.511p pd=48.245u as=35.511p ps=48.245u w=46.725u l=1u
X7426 BAT GATE DVDD DVDD pfet_06v0 ad=35.511p pd=48.245u as=35.511p ps=48.245u w=46.725u l=1u
X7427 BAT GATE DVDD DVDD pfet_06v0 ad=58.0754p pd=77.935u as=71.8301p ps=0.15471m w=76.41499u l=1u
X7428 BAT GATE DVDD DVDD pfet_06v0 ad=58.1552p pd=78.04u as=58.1552p ps=78.04u w=76.52u l=1u
X7429 BAT GATE DVDD DVDD pfet_06v0 ad=47.6862p pd=64.265u as=47.6862p ps=64.265u w=62.745u l=1u
X7430 BAT GATE DVDD DVDD pfet_06v0 ad=35.511p pd=48.245u as=35.511p ps=48.245u w=46.725u l=1u
X7431 BAT GATE DVDD DVDD pfet_06v0 ad=35.511p pd=48.245u as=35.511p ps=48.245u w=46.725u l=1u
X7432 DVDD GATE BAT DVDD pfet_06v0 ad=43.9168p pd=95.32u as=35.5072p ps=48.24u w=46.72u l=1u
X7433 BAT GATE DVDD DVDD pfet_06v0 ad=35.511p pd=48.245u as=35.511p ps=48.245u w=46.725u l=1u
X7434 BAT GATE DVDD DVDD pfet_06v0 ad=58.1134p pd=77.985u as=58.1134p ps=77.985u w=76.465u l=1u
X7435 BAT GATE DVDD DVDD pfet_06v0 ad=35.511p pd=48.245u as=35.511p ps=48.245u w=46.725u l=1u
X7436 BAT GATE DVDD DVDD pfet_06v0 ad=35.511p pd=48.245u as=35.511p ps=48.245u w=46.725u l=1u
X7437 BAT GATE DVDD DVDD pfet_06v0 ad=35.511p pd=48.245u as=35.511p ps=48.245u w=46.725u l=1u
X7438 DVDD GATE BAT DVDD pfet_06v0 ad=71.8771p pd=0.15481m as=58.1134p ps=77.985u w=76.465u l=1u
X7439 BAT GATE DVDD DVDD pfet_06v0 ad=35.511p pd=48.245u as=35.511p ps=48.245u w=46.725u l=1u
X7440 BAT GATE DVDD DVDD pfet_06v0 ad=35.5072p pd=48.24u as=35.5072p ps=48.24u w=46.72u l=1u
X7441 DVDD GATE BAT DVDD pfet_06v0 ad=58.1134p pd=77.985u as=58.1134p ps=77.985u w=76.465u l=1u
X7442 DVDD GATE BAT DVDD pfet_06v0 ad=58.1134p pd=77.985u as=58.1134p ps=77.985u w=76.465u l=1u
X7443 DVDD GATE BAT DVDD pfet_06v0 ad=35.511p pd=48.245u as=35.511p ps=48.245u w=46.725u l=1u
X7444 DVDD GATE BAT DVDD pfet_06v0 ad=35.511p pd=48.245u as=35.511p ps=48.245u w=46.725u l=1u
X7445 BAT GATE DVDD DVDD pfet_06v0 ad=58.1134p pd=77.985u as=71.8771p ps=0.15481m w=76.465u l=1u
X7446 BAT GATE DVDD DVDD pfet_06v0 ad=58.1172p pd=77.99u as=58.1172p ps=77.99u w=76.47u l=1u
X7447 BAT GATE DVDD DVDD pfet_06v0 ad=35.511p pd=48.245u as=35.511p ps=48.245u w=46.725u l=1u
X7448 DVDD GATE BAT DVDD pfet_06v0 ad=35.511p pd=48.245u as=35.511p ps=48.245u w=46.725u l=1u
X7449 DVDD GATE BAT DVDD pfet_06v0 ad=58.1134p pd=77.985u as=58.1134p ps=77.985u w=76.465u l=1u
X7450 BAT GATE DVDD DVDD pfet_06v0 ad=35.5072p pd=48.24u as=43.9168p ps=95.32u w=46.72u l=1u
X7451 DVDD GATE BAT DVDD pfet_06v0 ad=58.9803p pd=0.12737m as=47.6862p ps=64.265u w=62.745u l=1u
X7452 DVDD GATE BAT DVDD pfet_06v0 ad=58.1552p pd=78.04u as=58.1552p ps=78.04u w=76.52u l=1u
X7453 DVDD GATE BAT DVDD pfet_06v0 ad=35.511p pd=48.245u as=35.511p ps=48.245u w=46.725u l=1u
X7454 BAT GATE DVDD DVDD pfet_06v0 ad=58.1134p pd=77.985u as=58.1134p ps=77.985u w=76.465u l=1u
X7455 BAT GATE DVDD DVDD pfet_06v0 ad=35.511p pd=48.245u as=35.511p ps=48.245u w=46.725u l=1u
X7456 BAT GATE DVDD DVDD pfet_06v0 ad=35.5072p pd=48.24u as=35.5072p ps=48.24u w=46.72u l=1u
X7457 DVDD GATE BAT DVDD pfet_06v0 ad=35.511p pd=48.245u as=35.511p ps=48.245u w=46.725u l=1u
X7458 BAT GATE DVDD DVDD pfet_06v0 ad=35.5072p pd=48.24u as=35.5072p ps=48.24u w=46.72u l=1u
X7459 DVDD GATE BAT DVDD pfet_06v0 ad=58.1096p pd=77.98u as=58.1096p ps=77.98u w=76.46u l=1u
X7460 DVDD GATE BAT DVDD pfet_06v0 ad=49.3848p pd=66.5u as=49.3848p ps=66.5u w=64.98u l=1u
X7461 DVDD GATE BAT DVDD pfet_06v0 ad=35.511p pd=48.245u as=35.511p ps=48.245u w=46.725u l=1u
X7462 DVDD GATE BAT DVDD pfet_06v0 ad=71.8724p pd=0.1548m as=58.1096p ps=77.98u w=76.46u l=1u
X7463 BAT GATE DVDD DVDD pfet_06v0 ad=35.511p pd=48.245u as=43.9215p ps=95.32999u w=46.725u l=1u
X7464 DVDD GATE BAT DVDD pfet_06v0 ad=58.1134p pd=77.985u as=58.1134p ps=77.985u w=76.465u l=1u
X7465 DVDD GATE BAT DVDD pfet_06v0 ad=71.8724p pd=0.1548m as=58.1096p ps=77.98u w=76.46u l=1u
X7466 BAT GATE DVDD DVDD pfet_06v0 ad=35.511p pd=48.245u as=43.9215p ps=95.32999u w=46.725u l=1u
X7467 BAT GATE DVDD DVDD pfet_06v0 ad=35.511p pd=48.245u as=35.511p ps=48.245u w=46.725u l=1u
X7468 BAT GATE DVDD DVDD pfet_06v0 ad=58.1134p pd=77.985u as=58.1134p ps=77.985u w=76.465u l=1u
X7469 DVDD GATE BAT DVDD pfet_06v0 ad=71.8301p pd=0.15471m as=58.0754p ps=77.935u w=76.41499u l=1u
X7470 DVDD GATE BAT DVDD pfet_06v0 ad=47.6862p pd=64.265u as=47.6862p ps=64.265u w=62.745u l=1u
X7471 DVDD GATE BAT DVDD pfet_06v0 ad=43.9215p pd=95.32999u as=35.511p ps=48.245u w=46.725u l=1u
X7472 DVDD GATE BAT DVDD pfet_06v0 ad=58.1552p pd=78.04u as=58.1552p ps=78.04u w=76.52u l=1u
X7473 BAT GATE DVDD DVDD pfet_06v0 ad=58.1134p pd=77.985u as=71.8771p ps=0.15481m w=76.465u l=1u
X7474 BAT GATE DVDD DVDD pfet_06v0 ad=35.511p pd=48.245u as=35.511p ps=48.245u w=46.725u l=1u
X7475 DVDD GATE BAT DVDD pfet_06v0 ad=58.1172p pd=77.99u as=58.1172p ps=77.99u w=76.47u l=1u
X7476 BAT GATE DVDD DVDD pfet_06v0 ad=35.511p pd=48.245u as=35.511p ps=48.245u w=46.725u l=1u
X7477 BAT GATE DVDD DVDD pfet_06v0 ad=58.1172p pd=77.99u as=58.1172p ps=77.99u w=76.47u l=1u
X7478 BAT GATE DVDD DVDD pfet_06v0 ad=58.1552p pd=78.04u as=58.1552p ps=78.04u w=76.52u l=1u
X7479 DVDD GATE BAT DVDD pfet_06v0 ad=58.1134p pd=77.985u as=58.1134p ps=77.985u w=76.465u l=1u
X7480 DVDD GATE BAT DVDD pfet_06v0 ad=43.9168p pd=95.32u as=35.5072p ps=48.24u w=46.72u l=1u
X7481 BAT GATE DVDD DVDD pfet_06v0 ad=58.1134p pd=77.985u as=58.1134p ps=77.985u w=76.465u l=1u
X7482 DVDD GATE BAT DVDD pfet_06v0 ad=58.1134p pd=77.985u as=58.1134p ps=77.985u w=76.465u l=1u
X7483 BAT GATE DVDD DVDD pfet_06v0 ad=35.511p pd=48.245u as=35.511p ps=48.245u w=46.725u l=1u
X7484 BAT GATE DVDD DVDD pfet_06v0 ad=49.3848p pd=66.5u as=49.3848p ps=66.5u w=64.98u l=1u
X7485 BAT GATE DVDD DVDD pfet_06v0 ad=58.1134p pd=77.985u as=71.8771p ps=0.15481m w=76.465u l=1u
X7486 DVDD GATE BAT DVDD pfet_06v0 ad=43.9215p pd=95.32999u as=35.511p ps=48.245u w=46.725u l=1u
X7487 DVDD GATE BAT DVDD pfet_06v0 ad=35.511p pd=48.245u as=35.511p ps=48.245u w=46.725u l=1u
X7488 BAT GATE DVDD DVDD pfet_06v0 ad=35.5072p pd=48.24u as=35.5072p ps=48.24u w=46.72u l=1u
X7489 DVDD GATE BAT DVDD pfet_06v0 ad=71.8818p pd=0.15482m as=58.1172p ps=77.99u w=76.47u l=1u
X7490 DVDD GATE BAT DVDD pfet_06v0 ad=35.511p pd=48.245u as=35.511p ps=48.245u w=46.725u l=1u
X7491 BAT GATE DVDD DVDD pfet_06v0 ad=49.3848p pd=66.5u as=49.3848p ps=66.5u w=64.98u l=1u
X7492 DVDD GATE BAT DVDD pfet_06v0 ad=58.1134p pd=77.985u as=58.1134p ps=77.985u w=76.465u l=1u
X7493 DVDD GATE BAT DVDD pfet_06v0 ad=58.1134p pd=77.985u as=58.1134p ps=77.985u w=76.465u l=1u
X7494 DVDD GATE BAT DVDD pfet_06v0 ad=49.3848p pd=66.5u as=49.3848p ps=66.5u w=64.98u l=1u
X7495 BAT GATE DVDD DVDD pfet_06v0 ad=49.3848p pd=66.5u as=49.3848p ps=66.5u w=64.98u l=1u
X7496 DVDD GATE BAT DVDD pfet_06v0 ad=58.0754p pd=77.935u as=58.0754p ps=77.935u w=76.41499u l=1u
X7497 DVDD GATE BAT DVDD pfet_06v0 ad=58.1134p pd=77.985u as=58.1134p ps=77.985u w=76.465u l=1u
X7498 DVDD GATE BAT DVDD pfet_06v0 ad=58.1096p pd=77.98u as=58.1096p ps=77.98u w=76.46u l=1u
X7499 BAT GATE DVDD DVDD pfet_06v0 ad=35.511p pd=48.245u as=35.511p ps=48.245u w=46.725u l=1u
X7500 DVDD GATE BAT DVDD pfet_06v0 ad=58.1134p pd=77.985u as=58.1134p ps=77.985u w=76.465u l=1u
X7501 DVDD GATE BAT DVDD pfet_06v0 ad=71.92879p pd=0.15492m as=58.1552p ps=78.04u w=76.52u l=1u
X7502 BAT GATE DVDD DVDD pfet_06v0 ad=35.511p pd=48.245u as=35.511p ps=48.245u w=46.725u l=1u
X7503 DVDD GATE BAT DVDD pfet_06v0 ad=35.511p pd=48.245u as=35.511p ps=48.245u w=46.725u l=1u
X7504 BAT GATE DVDD DVDD pfet_06v0 ad=58.1552p pd=78.04u as=58.1552p ps=78.04u w=76.52u l=1u
X7505 DVDD GATE BAT DVDD pfet_06v0 ad=58.1134p pd=77.985u as=58.1134p ps=77.985u w=76.465u l=1u
X7506 BAT GATE DVDD DVDD pfet_06v0 ad=58.1134p pd=77.985u as=58.1134p ps=77.985u w=76.465u l=1u
X7507 BAT GATE DVDD DVDD pfet_06v0 ad=58.1134p pd=77.985u as=58.1134p ps=77.985u w=76.465u l=1u
X7508 BAT GATE DVDD DVDD pfet_06v0 ad=58.1134p pd=77.985u as=58.1134p ps=77.985u w=76.465u l=1u
X7509 DVDD GATE BAT DVDD pfet_06v0 ad=35.511p pd=48.245u as=35.511p ps=48.245u w=46.725u l=1u
X7510 DVDD GATE BAT DVDD pfet_06v0 ad=43.9215p pd=95.32999u as=35.511p ps=48.245u w=46.725u l=1u
X7511 BAT GATE DVDD DVDD pfet_06v0 ad=58.1134p pd=77.985u as=58.1134p ps=77.985u w=76.465u l=1u
X7512 BAT GATE DVDD DVDD pfet_06v0 ad=49.3848p pd=66.5u as=61.0812p ps=0.13184m w=64.98u l=1u
X7513 DVDD GATE BAT DVDD pfet_06v0 ad=58.1172p pd=77.99u as=58.1172p ps=77.99u w=76.47u l=1u
X7514 DVDD GATE BAT DVDD pfet_06v0 ad=35.511p pd=48.245u as=35.511p ps=48.245u w=46.725u l=1u
X7515 DVDD GATE BAT DVDD pfet_06v0 ad=58.1134p pd=77.985u as=58.1134p ps=77.985u w=76.465u l=1u
X7516 BAT GATE DVDD DVDD pfet_06v0 ad=47.6862p pd=64.265u as=47.6862p ps=64.265u w=62.745u l=1u
X7517 BAT GATE DVDD DVDD pfet_06v0 ad=58.0754p pd=77.935u as=58.0754p ps=77.935u w=76.41499u l=1u
X7518 DVDD GATE BAT DVDD pfet_06v0 ad=71.92879p pd=0.15492m as=58.1552p ps=78.04u w=76.52u l=1u
X7519 DVDD GATE BAT DVDD pfet_06v0 ad=35.511p pd=48.245u as=35.511p ps=48.245u w=46.725u l=1u
X7520 DVDD GATE BAT DVDD pfet_06v0 ad=35.511p pd=48.245u as=35.511p ps=48.245u w=46.725u l=1u
X7521 DVDD GATE BAT DVDD pfet_06v0 ad=35.511p pd=48.245u as=35.511p ps=48.245u w=46.725u l=1u
X7522 DVDD GATE BAT DVDD pfet_06v0 ad=58.1134p pd=77.985u as=58.1134p ps=77.985u w=76.465u l=1u
X7523 DVDD GATE BAT DVDD pfet_06v0 ad=58.1134p pd=77.985u as=58.1134p ps=77.985u w=76.465u l=1u
X7524 DVDD GATE BAT DVDD pfet_06v0 ad=58.1134p pd=77.985u as=58.1134p ps=77.985u w=76.465u l=1u
X7525 DVDD GATE BAT DVDD pfet_06v0 ad=35.511p pd=48.245u as=35.511p ps=48.245u w=46.725u l=1u
X7526 BAT GATE DVDD DVDD pfet_06v0 ad=35.5072p pd=48.24u as=35.5072p ps=48.24u w=46.72u l=1u
X7527 BAT GATE DVDD DVDD pfet_06v0 ad=35.511p pd=48.245u as=35.511p ps=48.245u w=46.725u l=1u
X7528 BAT GATE DVDD DVDD pfet_06v0 ad=49.3848p pd=66.5u as=49.3848p ps=66.5u w=64.98u l=1u
X7529 BAT GATE DVDD DVDD pfet_06v0 ad=35.511p pd=48.245u as=43.9215p ps=95.32999u w=46.725u l=1u
X7530 DVDD GATE BAT DVDD pfet_06v0 ad=58.1134p pd=77.985u as=58.1134p ps=77.985u w=76.465u l=1u
X7531 DVDD GATE BAT DVDD pfet_06v0 ad=35.511p pd=48.245u as=35.511p ps=48.245u w=46.725u l=1u
X7532 DVDD GATE BAT DVDD pfet_06v0 ad=58.1134p pd=77.985u as=58.1134p ps=77.985u w=76.465u l=1u
X7533 DVDD GATE BAT DVDD pfet_06v0 ad=58.1096p pd=77.98u as=58.1096p ps=77.98u w=76.46u l=1u
X7534 DVDD GATE BAT DVDD pfet_06v0 ad=35.511p pd=48.245u as=35.511p ps=48.245u w=46.725u l=1u
X7535 DVDD GATE BAT DVDD pfet_06v0 ad=35.511p pd=48.245u as=35.511p ps=48.245u w=46.725u l=1u
X7536 BAT GATE DVDD DVDD pfet_06v0 ad=58.1134p pd=77.985u as=58.1134p ps=77.985u w=76.465u l=1u
X7537 DVDD GATE BAT DVDD pfet_06v0 ad=35.511p pd=48.245u as=35.511p ps=48.245u w=46.725u l=1u
X7538 BAT GATE DVDD DVDD pfet_06v0 ad=58.1134p pd=77.985u as=58.1134p ps=77.985u w=76.465u l=1u
X7539 DVDD GATE BAT DVDD pfet_06v0 ad=49.3848p pd=66.5u as=49.3848p ps=66.5u w=64.98u l=1u
X7540 BAT GATE DVDD DVDD pfet_06v0 ad=35.511p pd=48.245u as=43.9215p ps=95.32999u w=46.725u l=1u
X7541 BAT GATE DVDD DVDD pfet_06v0 ad=35.511p pd=48.245u as=35.511p ps=48.245u w=46.725u l=1u
X7542 BAT GATE DVDD DVDD pfet_06v0 ad=58.1134p pd=77.985u as=58.1134p ps=77.985u w=76.465u l=1u
X7543 BAT GATE DVDD DVDD pfet_06v0 ad=58.1134p pd=77.985u as=58.1134p ps=77.985u w=76.465u l=1u
X7544 BAT GATE DVDD DVDD pfet_06v0 ad=58.1134p pd=77.985u as=58.1134p ps=77.985u w=76.465u l=1u
X7545 BAT GATE DVDD DVDD pfet_06v0 ad=35.511p pd=48.245u as=35.511p ps=48.245u w=46.725u l=1u
X7546 BAT GATE DVDD DVDD pfet_06v0 ad=35.511p pd=48.245u as=43.9215p ps=95.32999u w=46.725u l=1u
X7547 DVDD GATE BAT DVDD pfet_06v0 ad=35.511p pd=48.245u as=35.511p ps=48.245u w=46.725u l=1u
X7548 BAT GATE DVDD DVDD pfet_06v0 ad=47.6862p pd=64.265u as=47.6862p ps=64.265u w=62.745u l=1u
X7549 BAT GATE DVDD DVDD pfet_06v0 ad=35.511p pd=48.245u as=35.511p ps=48.245u w=46.725u l=1u
X7550 BAT GATE DVDD DVDD pfet_06v0 ad=47.6862p pd=64.265u as=47.6862p ps=64.265u w=62.745u l=1u
X7551 DVDD GATE BAT DVDD pfet_06v0 ad=35.511p pd=48.245u as=35.511p ps=48.245u w=46.725u l=1u
X7552 DVDD GATE BAT DVDD pfet_06v0 ad=58.0754p pd=77.935u as=58.0754p ps=77.935u w=76.41499u l=1u
X7553 DVDD GATE BAT DVDD pfet_06v0 ad=58.1552p pd=78.04u as=58.1552p ps=78.04u w=76.52u l=1u
X7554 BAT GATE DVDD DVDD pfet_06v0 ad=35.511p pd=48.245u as=35.511p ps=48.245u w=46.725u l=1u
X7555 BAT GATE DVDD DVDD pfet_06v0 ad=35.511p pd=48.245u as=35.511p ps=48.245u w=46.725u l=1u
X7556 BAT GATE DVDD DVDD pfet_06v0 ad=58.1552p pd=78.04u as=71.92879p ps=0.15492m w=76.52u l=1u
X7557 DVDD GATE BAT DVDD pfet_06v0 ad=58.1134p pd=77.985u as=58.1134p ps=77.985u w=76.465u l=1u
X7558 DVDD GATE BAT DVDD pfet_06v0 ad=35.511p pd=48.245u as=35.511p ps=48.245u w=46.725u l=1u
X7559 BAT GATE DVDD DVDD pfet_06v0 ad=35.511p pd=48.245u as=35.511p ps=48.245u w=46.725u l=1u
X7560 BAT GATE DVDD DVDD pfet_06v0 ad=58.1134p pd=77.985u as=58.1134p ps=77.985u w=76.465u l=1u
X7561 BAT GATE DVDD DVDD pfet_06v0 ad=58.0754p pd=77.935u as=58.0754p ps=77.935u w=76.41499u l=1u
X7562 BAT GATE DVDD DVDD pfet_06v0 ad=35.511p pd=48.245u as=35.511p ps=48.245u w=46.725u l=1u
X7563 DVDD GATE BAT DVDD pfet_06v0 ad=71.8771p pd=0.15481m as=58.1134p ps=77.985u w=76.465u l=1u
X7564 DVDD GATE BAT DVDD pfet_06v0 ad=71.8771p pd=0.15481m as=58.1134p ps=77.985u w=76.465u l=1u
X7565 DVDD GATE BAT DVDD pfet_06v0 ad=35.511p pd=48.245u as=35.511p ps=48.245u w=46.725u l=1u
X7566 DVDD GATE BAT DVDD pfet_06v0 ad=35.511p pd=48.245u as=35.511p ps=48.245u w=46.725u l=1u
X7567 BAT GATE DVDD DVDD pfet_06v0 ad=58.1134p pd=77.985u as=58.1134p ps=77.985u w=76.465u l=1u
X7568 DVDD GATE BAT DVDD pfet_06v0 ad=71.8724p pd=0.1548m as=58.1096p ps=77.98u w=76.46u l=1u
X7569 DVDD GATE BAT DVDD pfet_06v0 ad=35.511p pd=48.245u as=35.511p ps=48.245u w=46.725u l=1u
X7570 BAT GATE DVDD DVDD pfet_06v0 ad=47.6862p pd=64.265u as=47.6862p ps=64.265u w=62.745u l=1u
X7571 BAT GATE DVDD DVDD pfet_06v0 ad=58.1134p pd=77.985u as=58.1134p ps=77.985u w=76.465u l=1u
X7572 BAT GATE DVDD DVDD pfet_06v0 ad=58.1134p pd=77.985u as=58.1134p ps=77.985u w=76.465u l=1u
X7573 BAT GATE DVDD DVDD pfet_06v0 ad=35.511p pd=48.245u as=35.511p ps=48.245u w=46.725u l=1u
X7574 BAT GATE DVDD DVDD pfet_06v0 ad=35.511p pd=48.245u as=35.511p ps=48.245u w=46.725u l=1u
X7575 BAT GATE DVDD DVDD pfet_06v0 ad=58.1172p pd=77.99u as=58.1172p ps=77.99u w=76.47u l=1u
X7576 DVDD GATE BAT DVDD pfet_06v0 ad=71.8771p pd=0.15481m as=58.1134p ps=77.985u w=76.465u l=1u
X7577 BAT GATE DVDD DVDD pfet_06v0 ad=47.6862p pd=64.265u as=47.6862p ps=64.265u w=62.745u l=1u
X7578 DVDD GATE BAT DVDD pfet_06v0 ad=58.1134p pd=77.985u as=58.1134p ps=77.985u w=76.465u l=1u
X7579 DVDD GATE BAT DVDD pfet_06v0 ad=43.9168p pd=95.32u as=35.5072p ps=48.24u w=46.72u l=1u
X7580 BAT GATE DVDD DVDD pfet_06v0 ad=58.1134p pd=77.985u as=58.1134p ps=77.985u w=76.465u l=1u
X7581 DVDD GATE BAT DVDD pfet_06v0 ad=35.5072p pd=48.24u as=35.5072p ps=48.24u w=46.72u l=1u
X7582 DVDD GATE BAT DVDD pfet_06v0 ad=35.511p pd=48.245u as=35.511p ps=48.245u w=46.725u l=1u
X7583 BAT GATE DVDD DVDD pfet_06v0 ad=35.511p pd=48.245u as=43.9215p ps=95.32999u w=46.725u l=1u
X7584 DVDD GATE BAT DVDD pfet_06v0 ad=35.511p pd=48.245u as=35.511p ps=48.245u w=46.725u l=1u
X7585 BAT GATE DVDD DVDD pfet_06v0 ad=35.511p pd=48.245u as=35.511p ps=48.245u w=46.725u l=1u
X7586 BAT GATE DVDD DVDD pfet_06v0 ad=35.511p pd=48.245u as=35.511p ps=48.245u w=46.725u l=1u
X7587 DVDD GATE BAT DVDD pfet_06v0 ad=35.5072p pd=48.24u as=35.5072p ps=48.24u w=46.72u l=1u
X7588 BAT GATE DVDD DVDD pfet_06v0 ad=58.1134p pd=77.985u as=58.1134p ps=77.985u w=76.465u l=1u
X7589 DVDD GATE BAT DVDD pfet_06v0 ad=35.511p pd=48.245u as=35.511p ps=48.245u w=46.725u l=1u
X7590 DVDD GATE BAT DVDD pfet_06v0 ad=58.1552p pd=78.04u as=58.1552p ps=78.04u w=76.52u l=1u
X7591 BAT GATE DVDD DVDD pfet_06v0 ad=58.1134p pd=77.985u as=58.1134p ps=77.985u w=76.465u l=1u
X7592 DVDD GATE BAT DVDD pfet_06v0 ad=35.511p pd=48.245u as=35.511p ps=48.245u w=46.725u l=1u
X7593 DVDD GATE BAT DVDD pfet_06v0 ad=35.511p pd=48.245u as=35.511p ps=48.245u w=46.725u l=1u
X7594 DVDD GATE BAT DVDD pfet_06v0 ad=58.1134p pd=77.985u as=58.1134p ps=77.985u w=76.465u l=1u
X7595 DVDD GATE BAT DVDD pfet_06v0 ad=58.1172p pd=77.99u as=58.1172p ps=77.99u w=76.47u l=1u
X7596 BAT GATE DVDD DVDD pfet_06v0 ad=58.1134p pd=77.985u as=71.8771p ps=0.15481m w=76.465u l=1u
X7597 BAT GATE DVDD DVDD pfet_06v0 ad=49.3848p pd=66.5u as=49.3848p ps=66.5u w=64.98u l=1u
X7598 DVDD GATE BAT DVDD pfet_06v0 ad=35.511p pd=48.245u as=35.511p ps=48.245u w=46.725u l=1u
X7599 BAT GATE DVDD DVDD pfet_06v0 ad=35.511p pd=48.245u as=35.511p ps=48.245u w=46.725u l=1u
X7600 DVDD GATE BAT DVDD pfet_06v0 ad=43.9215p pd=95.32999u as=35.511p ps=48.245u w=46.725u l=1u
X7601 BAT GATE DVDD DVDD pfet_06v0 ad=35.511p pd=48.245u as=35.511p ps=48.245u w=46.725u l=1u
X7602 DVDD GATE BAT DVDD pfet_06v0 ad=58.1134p pd=77.985u as=58.1134p ps=77.985u w=76.465u l=1u
X7603 DVDD GATE BAT DVDD pfet_06v0 ad=58.1134p pd=77.985u as=58.1134p ps=77.985u w=76.465u l=1u
X7604 DVDD GATE BAT DVDD pfet_06v0 ad=47.6862p pd=64.265u as=47.6862p ps=64.265u w=62.745u l=1u
X7605 BAT GATE DVDD DVDD pfet_06v0 ad=35.511p pd=48.245u as=43.9215p ps=95.32999u w=46.725u l=1u
X7606 DVDD GATE BAT DVDD pfet_06v0 ad=58.1134p pd=77.985u as=58.1134p ps=77.985u w=76.465u l=1u
X7607 DVDD GATE BAT DVDD pfet_06v0 ad=43.9215p pd=95.32999u as=35.511p ps=48.245u w=46.725u l=1u
X7608 DVDD GATE BAT DVDD pfet_06v0 ad=58.1134p pd=77.985u as=58.1134p ps=77.985u w=76.465u l=1u
X7609 DVDD GATE BAT DVDD pfet_06v0 ad=58.0754p pd=77.935u as=58.0754p ps=77.935u w=76.41499u l=1u
X7610 DVDD GATE BAT DVDD pfet_06v0 ad=35.511p pd=48.245u as=35.511p ps=48.245u w=46.725u l=1u
X7611 DVDD GATE BAT DVDD pfet_06v0 ad=58.1096p pd=77.98u as=58.1096p ps=77.98u w=76.46u l=1u
X7612 DVDD GATE BAT DVDD pfet_06v0 ad=58.1134p pd=77.985u as=58.1134p ps=77.985u w=76.465u l=1u
X7613 BAT GATE DVDD DVDD pfet_06v0 ad=35.511p pd=48.245u as=35.511p ps=48.245u w=46.725u l=1u
X7614 BAT GATE DVDD DVDD pfet_06v0 ad=35.511p pd=48.245u as=35.511p ps=48.245u w=46.725u l=1u
X7615 BAT GATE DVDD DVDD pfet_06v0 ad=58.1134p pd=77.985u as=71.8771p ps=0.15481m w=76.465u l=1u
X7616 BAT GATE DVDD DVDD pfet_06v0 ad=58.0754p pd=77.935u as=58.0754p ps=77.935u w=76.41499u l=1u
X7617 DVDD GATE BAT DVDD pfet_06v0 ad=58.1552p pd=78.04u as=58.1552p ps=78.04u w=76.52u l=1u
X7618 DVDD GATE BAT DVDD pfet_06v0 ad=35.511p pd=48.245u as=35.511p ps=48.245u w=46.725u l=1u
X7619 BAT GATE DVDD DVDD pfet_06v0 ad=35.511p pd=48.245u as=35.511p ps=48.245u w=46.725u l=1u
X7620 DVDD GATE BAT DVDD pfet_06v0 ad=58.0754p pd=77.935u as=58.0754p ps=77.935u w=76.41499u l=1u
X7621 BAT GATE DVDD DVDD pfet_06v0 ad=35.511p pd=48.245u as=43.9215p ps=95.32999u w=46.725u l=1u
X7622 BAT GATE DVDD DVDD pfet_06v0 ad=58.1134p pd=77.985u as=58.1134p ps=77.985u w=76.465u l=1u
X7623 BAT GATE DVDD DVDD pfet_06v0 ad=35.511p pd=48.245u as=35.511p ps=48.245u w=46.725u l=1u
X7624 DVDD GATE BAT DVDD pfet_06v0 ad=35.5072p pd=48.24u as=35.5072p ps=48.24u w=46.72u l=1u
X7625 BAT GATE DVDD DVDD pfet_06v0 ad=35.511p pd=48.245u as=35.511p ps=48.245u w=46.725u l=1u
X7626 DVDD GATE BAT DVDD pfet_06v0 ad=71.8724p pd=0.1548m as=58.1096p ps=77.98u w=76.46u l=1u
X7627 BAT GATE DVDD DVDD pfet_06v0 ad=58.1134p pd=77.985u as=58.1134p ps=77.985u w=76.465u l=1u
X7628 DVDD GATE BAT DVDD pfet_06v0 ad=58.0754p pd=77.935u as=58.0754p ps=77.935u w=76.41499u l=1u
X7629 BAT GATE DVDD DVDD pfet_06v0 ad=58.1134p pd=77.985u as=58.1134p ps=77.985u w=76.465u l=1u
X7630 BAT GATE DVDD DVDD pfet_06v0 ad=35.511p pd=48.245u as=35.511p ps=48.245u w=46.725u l=1u
X7631 BAT GATE DVDD DVDD pfet_06v0 ad=35.511p pd=48.245u as=35.511p ps=48.245u w=46.725u l=1u
X7632 BAT GATE DVDD DVDD pfet_06v0 ad=47.6862p pd=64.265u as=58.9803p ps=0.12737m w=62.745u l=1u
X7633 DVDD GATE BAT DVDD pfet_06v0 ad=58.1134p pd=77.985u as=58.1134p ps=77.985u w=76.465u l=1u
X7634 BAT GATE DVDD DVDD pfet_06v0 ad=58.1096p pd=77.98u as=58.1096p ps=77.98u w=76.46u l=1u
X7635 DVDD GATE BAT DVDD pfet_06v0 ad=58.1134p pd=77.985u as=58.1134p ps=77.985u w=76.465u l=1u
X7636 DVDD GATE BAT DVDD pfet_06v0 ad=43.9215p pd=95.32999u as=35.511p ps=48.245u w=46.725u l=1u
X7637 DVDD GATE BAT DVDD pfet_06v0 ad=35.511p pd=48.245u as=35.511p ps=48.245u w=46.725u l=1u
X7638 BAT GATE DVDD DVDD pfet_06v0 ad=58.1134p pd=77.985u as=71.8771p ps=0.15481m w=76.465u l=1u
X7639 DVDD GATE BAT DVDD pfet_06v0 ad=58.9803p pd=0.12737m as=47.6862p ps=64.265u w=62.745u l=1u
X7640 DVDD GATE BAT DVDD pfet_06v0 ad=35.511p pd=48.245u as=35.511p ps=48.245u w=46.725u l=1u
X7641 BAT GATE DVDD DVDD pfet_06v0 ad=58.1096p pd=77.98u as=71.8724p ps=0.1548m w=76.46u l=1u
X7642 BAT GATE DVDD DVDD pfet_06v0 ad=35.511p pd=48.245u as=43.9215p ps=95.32999u w=46.725u l=1u
X7643 DVDD GATE BAT DVDD pfet_06v0 ad=58.1134p pd=77.985u as=58.1134p ps=77.985u w=76.465u l=1u
X7644 DVDD GATE BAT DVDD pfet_06v0 ad=58.1172p pd=77.99u as=58.1172p ps=77.99u w=76.47u l=1u
X7645 BAT GATE DVDD DVDD pfet_06v0 ad=35.511p pd=48.245u as=35.511p ps=48.245u w=46.725u l=1u
X7646 DVDD GATE BAT DVDD pfet_06v0 ad=71.8818p pd=0.15482m as=58.1172p ps=77.99u w=76.47u l=1u
X7647 BAT GATE DVDD DVDD pfet_06v0 ad=49.3848p pd=66.5u as=49.3848p ps=66.5u w=64.98u l=1u
X7648 BAT GATE DVDD DVDD pfet_06v0 ad=35.5072p pd=48.24u as=43.9168p ps=95.32u w=46.72u l=1u
X7649 DVDD GATE BAT DVDD pfet_06v0 ad=58.1134p pd=77.985u as=58.1134p ps=77.985u w=76.465u l=1u
X7650 BAT GATE DVDD DVDD pfet_06v0 ad=58.1096p pd=77.98u as=58.1096p ps=77.98u w=76.46u l=1u
X7651 DVDD GATE BAT DVDD pfet_06v0 ad=43.9215p pd=95.32999u as=35.511p ps=48.245u w=46.725u l=1u
X7652 DVDD GATE BAT DVDD pfet_06v0 ad=58.1134p pd=77.985u as=58.1134p ps=77.985u w=76.465u l=1u
X7653 BAT GATE DVDD DVDD pfet_06v0 ad=58.1096p pd=77.98u as=58.1096p ps=77.98u w=76.46u l=1u
X7654 BAT GATE DVDD DVDD pfet_06v0 ad=58.1134p pd=77.985u as=58.1134p ps=77.985u w=76.465u l=1u
X7655 BAT GATE DVDD DVDD pfet_06v0 ad=49.3848p pd=66.5u as=61.0812p ps=0.13184m w=64.98u l=1u
X7656 BAT GATE DVDD DVDD pfet_06v0 ad=35.511p pd=48.245u as=35.511p ps=48.245u w=46.725u l=1u
X7657 DVDD GATE BAT DVDD pfet_06v0 ad=58.1552p pd=78.04u as=58.1552p ps=78.04u w=76.52u l=1u
X7658 BAT GATE DVDD DVDD pfet_06v0 ad=58.1134p pd=77.985u as=58.1134p ps=77.985u w=76.465u l=1u
X7659 DVDD GATE BAT DVDD pfet_06v0 ad=71.8771p pd=0.15481m as=58.1134p ps=77.985u w=76.465u l=1u
X7660 BAT GATE DVDD DVDD pfet_06v0 ad=58.0754p pd=77.935u as=58.0754p ps=77.935u w=76.41499u l=1u
X7661 BAT GATE DVDD DVDD pfet_06v0 ad=35.5072p pd=48.24u as=35.5072p ps=48.24u w=46.72u l=1u
X7662 BAT GATE DVDD DVDD pfet_06v0 ad=58.1134p pd=77.985u as=58.1134p ps=77.985u w=76.465u l=1u
X7663 DVDD GATE BAT DVDD pfet_06v0 ad=35.511p pd=48.245u as=35.511p ps=48.245u w=46.725u l=1u
X7664 BAT GATE DVDD DVDD pfet_06v0 ad=58.1134p pd=77.985u as=58.1134p ps=77.985u w=76.465u l=1u
X7665 BAT GATE DVDD DVDD pfet_06v0 ad=58.1134p pd=77.985u as=58.1134p ps=77.985u w=76.465u l=1u
X7666 DVDD GATE BAT DVDD pfet_06v0 ad=35.511p pd=48.245u as=35.511p ps=48.245u w=46.725u l=1u
X7667 BAT GATE DVDD DVDD pfet_06v0 ad=35.511p pd=48.245u as=35.511p ps=48.245u w=46.725u l=1u
X7668 DVDD GATE BAT DVDD pfet_06v0 ad=47.6862p pd=64.265u as=47.6862p ps=64.265u w=62.745u l=1u
X7669 DVDD GATE BAT DVDD pfet_06v0 ad=35.511p pd=48.245u as=35.511p ps=48.245u w=46.725u l=1u
X7670 BAT GATE DVDD DVDD pfet_06v0 ad=35.511p pd=48.245u as=35.511p ps=48.245u w=46.725u l=1u
X7671 BAT GATE DVDD DVDD pfet_06v0 ad=58.1134p pd=77.985u as=58.1134p ps=77.985u w=76.465u l=1u
X7672 BAT GATE DVDD DVDD pfet_06v0 ad=47.6862p pd=64.265u as=47.6862p ps=64.265u w=62.745u l=1u
X7673 DVDD GATE BAT DVDD pfet_06v0 ad=58.1134p pd=77.985u as=58.1134p ps=77.985u w=76.465u l=1u
X7674 DVDD GATE BAT DVDD pfet_06v0 ad=58.1134p pd=77.985u as=58.1134p ps=77.985u w=76.465u l=1u
X7675 BAT GATE DVDD DVDD pfet_06v0 ad=35.511p pd=48.245u as=35.511p ps=48.245u w=46.725u l=1u
X7676 DVDD GATE BAT DVDD pfet_06v0 ad=58.1134p pd=77.985u as=58.1134p ps=77.985u w=76.465u l=1u
X7677 DVDD GATE BAT DVDD pfet_06v0 ad=35.511p pd=48.245u as=35.511p ps=48.245u w=46.725u l=1u
X7678 BAT GATE DVDD DVDD pfet_06v0 ad=49.3848p pd=66.5u as=49.3848p ps=66.5u w=64.98u l=1u
X7679 DVDD GATE BAT DVDD pfet_06v0 ad=35.511p pd=48.245u as=35.511p ps=48.245u w=46.725u l=1u
X7680 BAT GATE DVDD DVDD pfet_06v0 ad=35.511p pd=48.245u as=35.511p ps=48.245u w=46.725u l=1u
X7681 DVDD GATE BAT DVDD pfet_06v0 ad=58.1134p pd=77.985u as=58.1134p ps=77.985u w=76.465u l=1u
X7682 DVDD GATE BAT DVDD pfet_06v0 ad=35.511p pd=48.245u as=35.511p ps=48.245u w=46.725u l=1u
X7683 BAT GATE DVDD DVDD pfet_06v0 ad=58.1096p pd=77.98u as=58.1096p ps=77.98u w=76.46u l=1u
X7684 BAT GATE DVDD DVDD pfet_06v0 ad=58.1134p pd=77.985u as=58.1134p ps=77.985u w=76.465u l=1u
X7685 DVDD GATE BAT DVDD pfet_06v0 ad=35.511p pd=48.245u as=35.511p ps=48.245u w=46.725u l=1u
X7686 BAT GATE DVDD DVDD pfet_06v0 ad=58.1096p pd=77.98u as=58.1096p ps=77.98u w=76.46u l=1u
X7687 BAT GATE DVDD DVDD pfet_06v0 ad=49.3848p pd=66.5u as=61.0812p ps=0.13184m w=64.98u l=1u
X7688 DVDD GATE BAT DVDD pfet_06v0 ad=58.1172p pd=77.99u as=58.1172p ps=77.99u w=76.47u l=1u
X7689 BAT GATE DVDD DVDD pfet_06v0 ad=58.1552p pd=78.04u as=58.1552p ps=78.04u w=76.52u l=1u
X7690 BAT GATE DVDD DVDD pfet_06v0 ad=35.511p pd=48.245u as=35.511p ps=48.245u w=46.725u l=1u
X7691 DVDD GATE BAT DVDD pfet_06v0 ad=71.8771p pd=0.15481m as=58.1134p ps=77.985u w=76.465u l=1u
X7692 DVDD GATE BAT DVDD pfet_06v0 ad=47.6862p pd=64.265u as=47.6862p ps=64.265u w=62.745u l=1u
X7693 DVDD GATE BAT DVDD pfet_06v0 ad=58.1134p pd=77.985u as=58.1134p ps=77.985u w=76.465u l=1u
X7694 BAT GATE DVDD DVDD pfet_06v0 ad=58.1552p pd=78.04u as=58.1552p ps=78.04u w=76.52u l=1u
X7695 DVDD GATE BAT DVDD pfet_06v0 ad=35.511p pd=48.245u as=35.511p ps=48.245u w=46.725u l=1u
X7696 BAT GATE DVDD DVDD pfet_06v0 ad=58.0754p pd=77.935u as=58.0754p ps=77.935u w=76.41499u l=1u
X7697 DVDD GATE BAT DVDD pfet_06v0 ad=58.1134p pd=77.985u as=58.1134p ps=77.985u w=76.465u l=1u
X7698 BAT GATE DVDD DVDD pfet_06v0 ad=35.5072p pd=48.24u as=35.5072p ps=48.24u w=46.72u l=1u
X7699 BAT GATE DVDD DVDD pfet_06v0 ad=58.0754p pd=77.935u as=58.0754p ps=77.935u w=76.41499u l=1u
X7700 DVDD GATE BAT DVDD pfet_06v0 ad=35.511p pd=48.245u as=35.511p ps=48.245u w=46.725u l=1u
X7701 DVDD GATE BAT DVDD pfet_06v0 ad=35.511p pd=48.245u as=35.511p ps=48.245u w=46.725u l=1u
X7702 DVDD GATE BAT DVDD pfet_06v0 ad=35.511p pd=48.245u as=35.511p ps=48.245u w=46.725u l=1u
X7703 DVDD GATE BAT DVDD pfet_06v0 ad=58.1134p pd=77.985u as=58.1134p ps=77.985u w=76.465u l=1u
X7704 BAT GATE DVDD DVDD pfet_06v0 ad=35.5072p pd=48.24u as=35.5072p ps=48.24u w=46.72u l=1u
X7705 DVDD GATE BAT DVDD pfet_06v0 ad=58.1134p pd=77.985u as=58.1134p ps=77.985u w=76.465u l=1u
X7706 DVDD GATE BAT DVDD pfet_06v0 ad=47.6862p pd=64.265u as=47.6862p ps=64.265u w=62.745u l=1u
X7707 BAT GATE DVDD DVDD pfet_06v0 ad=35.511p pd=48.245u as=35.511p ps=48.245u w=46.725u l=1u
X7708 DVDD GATE BAT DVDD pfet_06v0 ad=58.9803p pd=0.12737m as=47.6862p ps=64.265u w=62.745u l=1u
X7709 DVDD GATE BAT DVDD pfet_06v0 ad=71.8301p pd=0.15471m as=58.0754p ps=77.935u w=76.41499u l=1u
X7710 BAT GATE DVDD DVDD pfet_06v0 ad=35.511p pd=48.245u as=35.511p ps=48.245u w=46.725u l=1u
X7711 DVDD GATE BAT DVDD pfet_06v0 ad=58.1134p pd=77.985u as=58.1134p ps=77.985u w=76.465u l=1u
X7712 BAT GATE DVDD DVDD pfet_06v0 ad=35.511p pd=48.245u as=35.511p ps=48.245u w=46.725u l=1u
X7713 DVDD GATE BAT DVDD pfet_06v0 ad=71.8771p pd=0.15481m as=58.1134p ps=77.985u w=76.465u l=1u
X7714 DVDD GATE BAT DVDD pfet_06v0 ad=58.0754p pd=77.935u as=58.0754p ps=77.935u w=76.41499u l=1u
X7715 DVDD GATE BAT DVDD pfet_06v0 ad=49.3848p pd=66.5u as=49.3848p ps=66.5u w=64.98u l=1u
X7716 BAT GATE DVDD DVDD pfet_06v0 ad=58.1172p pd=77.99u as=58.1172p ps=77.99u w=76.47u l=1u
X7717 DVDD GATE BAT DVDD pfet_06v0 ad=35.511p pd=48.245u as=35.511p ps=48.245u w=46.725u l=1u
X7718 DVDD GATE BAT DVDD pfet_06v0 ad=49.3848p pd=66.5u as=49.3848p ps=66.5u w=64.98u l=1u
X7719 DVDD GATE BAT DVDD pfet_06v0 ad=49.3848p pd=66.5u as=49.3848p ps=66.5u w=64.98u l=1u
X7720 BAT GATE DVDD DVDD pfet_06v0 ad=58.0754p pd=77.935u as=71.8301p ps=0.15471m w=76.41499u l=1u
X7721 BAT GATE DVDD DVDD pfet_06v0 ad=58.1096p pd=77.98u as=58.1096p ps=77.98u w=76.46u l=1u
X7722 BAT GATE DVDD DVDD pfet_06v0 ad=58.1096p pd=77.98u as=58.1096p ps=77.98u w=76.46u l=1u
X7723 DVDD GATE BAT DVDD pfet_06v0 ad=49.3848p pd=66.5u as=49.3848p ps=66.5u w=64.98u l=1u
X7724 BAT GATE DVDD DVDD pfet_06v0 ad=58.1134p pd=77.985u as=58.1134p ps=77.985u w=76.465u l=1u
X7725 BAT GATE DVDD DVDD pfet_06v0 ad=58.0754p pd=77.935u as=58.0754p ps=77.935u w=76.41499u l=1u
X7726 BAT GATE DVDD DVDD pfet_06v0 ad=49.3848p pd=66.5u as=49.3848p ps=66.5u w=64.98u l=1u
X7727 DVDD GATE BAT DVDD pfet_06v0 ad=35.511p pd=48.245u as=35.511p ps=48.245u w=46.725u l=1u
X7728 BAT GATE DVDD DVDD pfet_06v0 ad=58.1096p pd=77.98u as=58.1096p ps=77.98u w=76.46u l=1u
X7729 DVDD GATE BAT DVDD pfet_06v0 ad=43.9168p pd=95.32u as=35.5072p ps=48.24u w=46.72u l=1u
X7730 DVDD GATE BAT DVDD pfet_06v0 ad=35.511p pd=48.245u as=35.511p ps=48.245u w=46.725u l=1u
X7731 BAT GATE DVDD DVDD pfet_06v0 ad=58.1552p pd=78.04u as=58.1552p ps=78.04u w=76.52u l=1u
X7732 BAT GATE DVDD DVDD pfet_06v0 ad=58.1552p pd=78.04u as=58.1552p ps=78.04u w=76.52u l=1u
X7733 DVDD GATE BAT DVDD pfet_06v0 ad=35.511p pd=48.245u as=35.511p ps=48.245u w=46.725u l=1u
X7734 BAT GATE DVDD DVDD pfet_06v0 ad=35.511p pd=48.245u as=35.511p ps=48.245u w=46.725u l=1u
X7735 DVDD GATE BAT DVDD pfet_06v0 ad=58.1134p pd=77.985u as=58.1134p ps=77.985u w=76.465u l=1u
X7736 BAT GATE DVDD DVDD pfet_06v0 ad=35.5072p pd=48.24u as=35.5072p ps=48.24u w=46.72u l=1u
X7737 DVDD GATE BAT DVDD pfet_06v0 ad=35.511p pd=48.245u as=35.511p ps=48.245u w=46.725u l=1u
X7738 BAT GATE DVDD DVDD pfet_06v0 ad=58.0754p pd=77.935u as=71.8301p ps=0.15471m w=76.41499u l=1u
X7739 BAT GATE DVDD DVDD pfet_06v0 ad=35.511p pd=48.245u as=35.511p ps=48.245u w=46.725u l=1u
X7740 DVDD GATE BAT DVDD pfet_06v0 ad=35.511p pd=48.245u as=35.511p ps=48.245u w=46.725u l=1u
X7741 DVDD GATE BAT DVDD pfet_06v0 ad=58.1134p pd=77.985u as=58.1134p ps=77.985u w=76.465u l=1u
X7742 DVDD GATE BAT DVDD pfet_06v0 ad=35.511p pd=48.245u as=35.511p ps=48.245u w=46.725u l=1u
X7743 BAT GATE DVDD DVDD pfet_06v0 ad=58.1134p pd=77.985u as=58.1134p ps=77.985u w=76.465u l=1u
X7744 BAT GATE DVDD DVDD pfet_06v0 ad=35.511p pd=48.245u as=35.511p ps=48.245u w=46.725u l=1u
X7745 DVDD GATE BAT DVDD pfet_06v0 ad=43.9215p pd=95.32999u as=35.511p ps=48.245u w=46.725u l=1u
X7746 BAT GATE DVDD DVDD pfet_06v0 ad=58.1172p pd=77.99u as=58.1172p ps=77.99u w=76.47u l=1u
X7747 BAT GATE DVDD DVDD pfet_06v0 ad=35.511p pd=48.245u as=35.511p ps=48.245u w=46.725u l=1u
X7748 DVDD GATE BAT DVDD pfet_06v0 ad=71.8771p pd=0.15481m as=58.1134p ps=77.985u w=76.465u l=1u
X7749 DVDD GATE BAT DVDD pfet_06v0 ad=47.6862p pd=64.265u as=47.6862p ps=64.265u w=62.745u l=1u
X7750 DVDD GATE BAT DVDD pfet_06v0 ad=58.1134p pd=77.985u as=58.1134p ps=77.985u w=76.465u l=1u
X7751 DVDD GATE BAT DVDD pfet_06v0 ad=35.511p pd=48.245u as=35.511p ps=48.245u w=46.725u l=1u
X7752 BAT GATE DVDD DVDD pfet_06v0 ad=58.1134p pd=77.985u as=58.1134p ps=77.985u w=76.465u l=1u
X7753 BAT GATE DVDD DVDD pfet_06v0 ad=35.511p pd=48.245u as=35.511p ps=48.245u w=46.725u l=1u
X7754 DVDD GATE BAT DVDD pfet_06v0 ad=49.3848p pd=66.5u as=49.3848p ps=66.5u w=64.98u l=1u
X7755 BAT GATE DVDD DVDD pfet_06v0 ad=58.1134p pd=77.985u as=58.1134p ps=77.985u w=76.465u l=1u
X7756 BAT GATE DVDD DVDD pfet_06v0 ad=58.1134p pd=77.985u as=58.1134p ps=77.985u w=76.465u l=1u
X7757 BAT GATE DVDD DVDD pfet_06v0 ad=35.511p pd=48.245u as=35.511p ps=48.245u w=46.725u l=1u
X7758 DVDD GATE BAT DVDD pfet_06v0 ad=35.511p pd=48.245u as=35.511p ps=48.245u w=46.725u l=1u
X7759 DVDD GATE BAT DVDD pfet_06v0 ad=49.3848p pd=66.5u as=49.3848p ps=66.5u w=64.98u l=1u
X7760 BAT GATE DVDD DVDD pfet_06v0 ad=35.511p pd=48.245u as=35.511p ps=48.245u w=46.725u l=1u
X7761 DVDD GATE BAT DVDD pfet_06v0 ad=35.511p pd=48.245u as=35.511p ps=48.245u w=46.725u l=1u
X7762 BAT GATE DVDD DVDD pfet_06v0 ad=58.1134p pd=77.985u as=71.8771p ps=0.15481m w=76.465u l=1u
X7763 DVDD GATE BAT DVDD pfet_06v0 ad=35.511p pd=48.245u as=35.511p ps=48.245u w=46.725u l=1u
X7764 DVDD GATE BAT DVDD pfet_06v0 ad=35.511p pd=48.245u as=35.511p ps=48.245u w=46.725u l=1u
X7765 BAT GATE DVDD DVDD pfet_06v0 ad=35.511p pd=48.245u as=35.511p ps=48.245u w=46.725u l=1u
X7766 BAT GATE DVDD DVDD pfet_06v0 ad=58.1552p pd=78.04u as=58.1552p ps=78.04u w=76.52u l=1u
X7767 DVDD GATE BAT DVDD pfet_06v0 ad=58.1134p pd=77.985u as=58.1134p ps=77.985u w=76.465u l=1u
X7768 DVDD GATE BAT DVDD pfet_06v0 ad=58.1552p pd=78.04u as=58.1552p ps=78.04u w=76.52u l=1u
X7769 DVDD GATE BAT DVDD pfet_06v0 ad=58.0754p pd=77.935u as=58.0754p ps=77.935u w=76.41499u l=1u
X7770 BAT GATE DVDD DVDD pfet_06v0 ad=35.511p pd=48.245u as=35.511p ps=48.245u w=46.725u l=1u
X7771 DVDD GATE BAT DVDD pfet_06v0 ad=58.1134p pd=77.985u as=58.1134p ps=77.985u w=76.465u l=1u
X7772 BAT GATE DVDD DVDD pfet_06v0 ad=47.6862p pd=64.265u as=47.6862p ps=64.265u w=62.745u l=1u
X7773 BAT GATE DVDD DVDD pfet_06v0 ad=35.511p pd=48.245u as=35.511p ps=48.245u w=46.725u l=1u
X7774 DVDD GATE BAT DVDD pfet_06v0 ad=35.5072p pd=48.24u as=35.5072p ps=48.24u w=46.72u l=1u
X7775 BAT GATE DVDD DVDD pfet_06v0 ad=35.511p pd=48.245u as=35.511p ps=48.245u w=46.725u l=1u
X7776 BAT GATE DVDD DVDD pfet_06v0 ad=35.511p pd=48.245u as=43.9215p ps=95.32999u w=46.725u l=1u
X7777 BAT GATE DVDD DVDD pfet_06v0 ad=35.511p pd=48.245u as=35.511p ps=48.245u w=46.725u l=1u
X7778 DVDD GATE BAT DVDD pfet_06v0 ad=58.1134p pd=77.985u as=58.1134p ps=77.985u w=76.465u l=1u
X7779 BAT GATE DVDD DVDD pfet_06v0 ad=35.511p pd=48.245u as=35.511p ps=48.245u w=46.725u l=1u
X7780 BAT GATE DVDD DVDD pfet_06v0 ad=35.511p pd=48.245u as=35.511p ps=48.245u w=46.725u l=1u
X7781 DVDD GATE BAT DVDD pfet_06v0 ad=58.1134p pd=77.985u as=58.1134p ps=77.985u w=76.465u l=1u
X7782 BAT GATE DVDD DVDD pfet_06v0 ad=35.511p pd=48.245u as=35.511p ps=48.245u w=46.725u l=1u
X7783 DVDD GATE BAT DVDD pfet_06v0 ad=35.511p pd=48.245u as=35.511p ps=48.245u w=46.725u l=1u
X7784 DVDD GATE BAT DVDD pfet_06v0 ad=35.511p pd=48.245u as=35.511p ps=48.245u w=46.725u l=1u
X7785 DVDD GATE BAT DVDD pfet_06v0 ad=35.511p pd=48.245u as=35.511p ps=48.245u w=46.725u l=1u
X7786 DVDD GATE BAT DVDD pfet_06v0 ad=58.1134p pd=77.985u as=58.1134p ps=77.985u w=76.465u l=1u
X7787 BAT GATE DVDD DVDD pfet_06v0 ad=35.511p pd=48.245u as=43.9215p ps=95.32999u w=46.725u l=1u
X7788 DVDD GATE BAT DVDD pfet_06v0 ad=47.6862p pd=64.265u as=47.6862p ps=64.265u w=62.745u l=1u
X7789 DVDD GATE BAT DVDD pfet_06v0 ad=58.1134p pd=77.985u as=58.1134p ps=77.985u w=76.465u l=1u
X7790 BAT GATE DVDD DVDD pfet_06v0 ad=49.3848p pd=66.5u as=49.3848p ps=66.5u w=64.98u l=1u
X7791 DVDD GATE BAT DVDD pfet_06v0 ad=35.511p pd=48.245u as=35.511p ps=48.245u w=46.725u l=1u
X7792 BAT GATE DVDD DVDD pfet_06v0 ad=58.1134p pd=77.985u as=58.1134p ps=77.985u w=76.465u l=1u
X7793 BAT GATE DVDD DVDD pfet_06v0 ad=35.511p pd=48.245u as=35.511p ps=48.245u w=46.725u l=1u
X7794 DVDD GATE BAT DVDD pfet_06v0 ad=58.1096p pd=77.98u as=58.1096p ps=77.98u w=76.46u l=1u
X7795 DVDD GATE BAT DVDD pfet_06v0 ad=49.3848p pd=66.5u as=49.3848p ps=66.5u w=64.98u l=1u
X7796 DVDD GATE BAT DVDD pfet_06v0 ad=58.1134p pd=77.985u as=58.1134p ps=77.985u w=76.465u l=1u
X7797 DVDD GATE BAT DVDD pfet_06v0 ad=35.511p pd=48.245u as=35.511p ps=48.245u w=46.725u l=1u
X7798 DVDD GATE BAT DVDD pfet_06v0 ad=35.511p pd=48.245u as=35.511p ps=48.245u w=46.725u l=1u
X7799 DVDD GATE BAT DVDD pfet_06v0 ad=35.511p pd=48.245u as=35.511p ps=48.245u w=46.725u l=1u
X7800 DVDD GATE BAT DVDD pfet_06v0 ad=58.1096p pd=77.98u as=58.1096p ps=77.98u w=76.46u l=1u
X7801 DVDD GATE BAT DVDD pfet_06v0 ad=58.1134p pd=77.985u as=58.1134p ps=77.985u w=76.465u l=1u
X7802 DVDD GATE BAT DVDD pfet_06v0 ad=58.1096p pd=77.98u as=58.1096p ps=77.98u w=76.46u l=1u
X7803 DVDD GATE BAT DVDD pfet_06v0 ad=35.511p pd=48.245u as=35.511p ps=48.245u w=46.725u l=1u
X7804 BAT GATE DVDD DVDD pfet_06v0 ad=35.511p pd=48.245u as=35.511p ps=48.245u w=46.725u l=1u
X7805 DVDD GATE BAT DVDD pfet_06v0 ad=61.0812p pd=0.13184m as=49.3848p ps=66.5u w=64.98u l=1u
X7806 DVDD GATE BAT DVDD pfet_06v0 ad=43.9215p pd=95.32999u as=35.511p ps=48.245u w=46.725u l=1u
X7807 DVDD GATE BAT DVDD pfet_06v0 ad=58.0754p pd=77.935u as=58.0754p ps=77.935u w=76.41499u l=1u
X7808 DVDD GATE BAT DVDD pfet_06v0 ad=47.6862p pd=64.265u as=47.6862p ps=64.265u w=62.745u l=1u
X7809 DVDD GATE BAT DVDD pfet_06v0 ad=35.511p pd=48.245u as=35.511p ps=48.245u w=46.725u l=1u
X7810 DVDD GATE BAT DVDD pfet_06v0 ad=58.1552p pd=78.04u as=58.1552p ps=78.04u w=76.52u l=1u
X7811 DVDD GATE BAT DVDD pfet_06v0 ad=35.5072p pd=48.24u as=35.5072p ps=48.24u w=46.72u l=1u
X7812 DVDD GATE BAT DVDD pfet_06v0 ad=35.511p pd=48.245u as=35.511p ps=48.245u w=46.725u l=1u
X7813 DVDD GATE BAT DVDD pfet_06v0 ad=58.1134p pd=77.985u as=58.1134p ps=77.985u w=76.465u l=1u
X7814 BAT GATE DVDD DVDD pfet_06v0 ad=35.511p pd=48.245u as=35.511p ps=48.245u w=46.725u l=1u
X7815 BAT GATE DVDD DVDD pfet_06v0 ad=58.1172p pd=77.99u as=58.1172p ps=77.99u w=76.47u l=1u
X7816 DVDD GATE BAT DVDD pfet_06v0 ad=35.5072p pd=48.24u as=35.5072p ps=48.24u w=46.72u l=1u
X7817 BAT GATE DVDD DVDD pfet_06v0 ad=58.1134p pd=77.985u as=58.1134p ps=77.985u w=76.465u l=1u
X7818 DVDD GATE BAT DVDD pfet_06v0 ad=58.1134p pd=77.985u as=58.1134p ps=77.985u w=76.465u l=1u
X7819 BAT GATE DVDD DVDD pfet_06v0 ad=49.3848p pd=66.5u as=61.0812p ps=0.13184m w=64.98u l=1u
X7820 BAT GATE DVDD DVDD pfet_06v0 ad=58.1134p pd=77.985u as=71.8771p ps=0.15481m w=76.465u l=1u
X7821 DVDD GATE BAT DVDD pfet_06v0 ad=35.511p pd=48.245u as=35.511p ps=48.245u w=46.725u l=1u
X7822 BAT GATE DVDD DVDD pfet_06v0 ad=47.6862p pd=64.265u as=47.6862p ps=64.265u w=62.745u l=1u
X7823 BAT GATE DVDD DVDD pfet_06v0 ad=47.6862p pd=64.265u as=47.6862p ps=64.265u w=62.745u l=1u
X7824 BAT GATE DVDD DVDD pfet_06v0 ad=35.511p pd=48.245u as=35.511p ps=48.245u w=46.725u l=1u
X7825 DVDD GATE BAT DVDD pfet_06v0 ad=35.511p pd=48.245u as=35.511p ps=48.245u w=46.725u l=1u
X7826 BAT GATE DVDD DVDD pfet_06v0 ad=58.1134p pd=77.985u as=58.1134p ps=77.985u w=76.465u l=1u
X7827 DVDD GATE BAT DVDD pfet_06v0 ad=47.6862p pd=64.265u as=47.6862p ps=64.265u w=62.745u l=1u
X7828 BAT GATE DVDD DVDD pfet_06v0 ad=35.5072p pd=48.24u as=35.5072p ps=48.24u w=46.72u l=1u
X7829 BAT GATE DVDD DVDD pfet_06v0 ad=49.3848p pd=66.5u as=61.0812p ps=0.13184m w=64.98u l=1u
X7830 BAT GATE DVDD DVDD pfet_06v0 ad=49.3848p pd=66.5u as=49.3848p ps=66.5u w=64.98u l=1u
X7831 BAT GATE DVDD DVDD pfet_06v0 ad=35.511p pd=48.245u as=43.9215p ps=95.32999u w=46.725u l=1u
X7832 DVDD GATE BAT DVDD pfet_06v0 ad=49.3848p pd=66.5u as=49.3848p ps=66.5u w=64.98u l=1u
X7833 DVDD GATE BAT DVDD pfet_06v0 ad=43.9215p pd=95.32999u as=35.511p ps=48.245u w=46.725u l=1u
X7834 DVDD GATE BAT DVDD pfet_06v0 ad=58.1134p pd=77.985u as=58.1134p ps=77.985u w=76.465u l=1u
X7835 DVDD GATE BAT DVDD pfet_06v0 ad=58.0754p pd=77.935u as=58.0754p ps=77.935u w=76.41499u l=1u
X7836 DVDD GATE BAT DVDD pfet_06v0 ad=58.1134p pd=77.985u as=58.1134p ps=77.985u w=76.465u l=1u
X7837 DVDD GATE BAT DVDD pfet_06v0 ad=43.9215p pd=95.32999u as=35.511p ps=48.245u w=46.725u l=1u
X7838 DVDD GATE BAT DVDD pfet_06v0 ad=58.1552p pd=78.04u as=58.1552p ps=78.04u w=76.52u l=1u
X7839 BAT GATE DVDD DVDD pfet_06v0 ad=35.511p pd=48.245u as=43.9215p ps=95.32999u w=46.725u l=1u
X7840 BAT GATE DVDD DVDD pfet_06v0 ad=35.511p pd=48.245u as=35.511p ps=48.245u w=46.725u l=1u
X7841 DVDD GATE BAT DVDD pfet_06v0 ad=35.511p pd=48.245u as=35.511p ps=48.245u w=46.725u l=1u
X7842 DVDD GATE BAT DVDD pfet_06v0 ad=35.511p pd=48.245u as=35.511p ps=48.245u w=46.725u l=1u
X7843 BAT GATE DVDD DVDD pfet_06v0 ad=58.1134p pd=77.985u as=58.1134p ps=77.985u w=76.465u l=1u
X7844 BAT GATE DVDD DVDD pfet_06v0 ad=58.1552p pd=78.04u as=71.92879p ps=0.15492m w=76.52u l=1u
X7845 DVDD GATE BAT DVDD pfet_06v0 ad=35.511p pd=48.245u as=35.511p ps=48.245u w=46.725u l=1u
X7846 DVDD GATE BAT DVDD pfet_06v0 ad=58.1134p pd=77.985u as=58.1134p ps=77.985u w=76.465u l=1u
X7847 BAT GATE DVDD DVDD pfet_06v0 ad=35.511p pd=48.245u as=35.511p ps=48.245u w=46.725u l=1u
X7848 BAT GATE DVDD DVDD pfet_06v0 ad=35.511p pd=48.245u as=43.9215p ps=95.32999u w=46.725u l=1u
X7849 BAT GATE DVDD DVDD pfet_06v0 ad=58.1134p pd=77.985u as=71.8771p ps=0.15481m w=76.465u l=1u
X7850 BAT GATE DVDD DVDD pfet_06v0 ad=58.1134p pd=77.985u as=58.1134p ps=77.985u w=76.465u l=1u
X7851 BAT GATE DVDD DVDD pfet_06v0 ad=35.511p pd=48.245u as=35.511p ps=48.245u w=46.725u l=1u
X7852 BAT GATE DVDD DVDD pfet_06v0 ad=35.511p pd=48.245u as=35.511p ps=48.245u w=46.725u l=1u
X7853 BAT GATE DVDD DVDD pfet_06v0 ad=58.1134p pd=77.985u as=58.1134p ps=77.985u w=76.465u l=1u
X7854 DVDD GATE BAT DVDD pfet_06v0 ad=58.1172p pd=77.99u as=58.1172p ps=77.99u w=76.47u l=1u
X7855 BAT GATE DVDD DVDD pfet_06v0 ad=35.511p pd=48.245u as=35.511p ps=48.245u w=46.725u l=1u
X7856 BAT GATE DVDD DVDD pfet_06v0 ad=58.1134p pd=77.985u as=58.1134p ps=77.985u w=76.465u l=1u
X7857 BAT GATE DVDD DVDD pfet_06v0 ad=35.511p pd=48.245u as=35.511p ps=48.245u w=46.725u l=1u
X7858 DVDD GATE BAT DVDD pfet_06v0 ad=58.1172p pd=77.99u as=58.1172p ps=77.99u w=76.47u l=1u
X7859 BAT GATE DVDD DVDD pfet_06v0 ad=35.511p pd=48.245u as=35.511p ps=48.245u w=46.725u l=1u
X7860 DVDD GATE BAT DVDD pfet_06v0 ad=58.1552p pd=78.04u as=58.1552p ps=78.04u w=76.52u l=1u
X7861 DVDD GATE BAT DVDD pfet_06v0 ad=71.8771p pd=0.15481m as=58.1134p ps=77.985u w=76.465u l=1u
X7862 DVDD GATE BAT DVDD pfet_06v0 ad=35.511p pd=48.245u as=35.511p ps=48.245u w=46.725u l=1u
X7863 BAT GATE DVDD DVDD pfet_06v0 ad=49.3848p pd=66.5u as=49.3848p ps=66.5u w=64.98u l=1u
X7864 BAT GATE DVDD DVDD pfet_06v0 ad=58.1096p pd=77.98u as=58.1096p ps=77.98u w=76.46u l=1u
X7865 BAT GATE DVDD DVDD pfet_06v0 ad=58.1134p pd=77.985u as=58.1134p ps=77.985u w=76.465u l=1u
X7866 DVDD GATE BAT DVDD pfet_06v0 ad=35.511p pd=48.245u as=35.511p ps=48.245u w=46.725u l=1u
X7867 BAT GATE DVDD DVDD pfet_06v0 ad=35.511p pd=48.245u as=43.9215p ps=95.32999u w=46.725u l=1u
X7868 BAT GATE DVDD DVDD pfet_06v0 ad=58.1134p pd=77.985u as=58.1134p ps=77.985u w=76.465u l=1u
X7869 DVDD GATE BAT DVDD pfet_06v0 ad=35.511p pd=48.245u as=35.511p ps=48.245u w=46.725u l=1u
X7870 BAT GATE DVDD DVDD pfet_06v0 ad=58.1134p pd=77.985u as=58.1134p ps=77.985u w=76.465u l=1u
X7871 DVDD GATE BAT DVDD pfet_06v0 ad=35.511p pd=48.245u as=35.511p ps=48.245u w=46.725u l=1u
X7872 DVDD GATE BAT DVDD pfet_06v0 ad=35.511p pd=48.245u as=35.511p ps=48.245u w=46.725u l=1u
X7873 BAT GATE DVDD DVDD pfet_06v0 ad=35.511p pd=48.245u as=35.511p ps=48.245u w=46.725u l=1u
X7874 DVDD GATE BAT DVDD pfet_06v0 ad=35.511p pd=48.245u as=35.511p ps=48.245u w=46.725u l=1u
X7875 DVDD GATE BAT DVDD pfet_06v0 ad=35.511p pd=48.245u as=35.511p ps=48.245u w=46.725u l=1u
X7876 DVDD GATE BAT DVDD pfet_06v0 ad=35.511p pd=48.245u as=35.511p ps=48.245u w=46.725u l=1u
X7877 DVDD GATE BAT DVDD pfet_06v0 ad=71.92879p pd=0.15492m as=58.1552p ps=78.04u w=76.52u l=1u
X7878 BAT GATE DVDD DVDD pfet_06v0 ad=58.1134p pd=77.985u as=58.1134p ps=77.985u w=76.465u l=1u
X7879 BAT GATE DVDD DVDD pfet_06v0 ad=35.5072p pd=48.24u as=43.9168p ps=95.32u w=46.72u l=1u
X7880 BAT GATE DVDD DVDD pfet_06v0 ad=58.1134p pd=77.985u as=58.1134p ps=77.985u w=76.465u l=1u
X7881 DVDD GATE BAT DVDD pfet_06v0 ad=49.3848p pd=66.5u as=49.3848p ps=66.5u w=64.98u l=1u
X7882 BAT GATE DVDD DVDD pfet_06v0 ad=35.511p pd=48.245u as=43.9215p ps=95.32999u w=46.725u l=1u
X7883 DVDD GATE BAT DVDD pfet_06v0 ad=35.511p pd=48.245u as=35.511p ps=48.245u w=46.725u l=1u
X7884 BAT GATE DVDD DVDD pfet_06v0 ad=58.1134p pd=77.985u as=58.1134p ps=77.985u w=76.465u l=1u
X7885 BAT GATE DVDD DVDD pfet_06v0 ad=35.511p pd=48.245u as=35.511p ps=48.245u w=46.725u l=1u
X7886 DVDD GATE BAT DVDD pfet_06v0 ad=58.0754p pd=77.935u as=58.0754p ps=77.935u w=76.41499u l=1u
X7887 BAT GATE DVDD DVDD pfet_06v0 ad=35.511p pd=48.245u as=43.9215p ps=95.32999u w=46.725u l=1u
X7888 BAT GATE DVDD DVDD pfet_06v0 ad=35.511p pd=48.245u as=43.9215p ps=95.32999u w=46.725u l=1u
X7889 BAT GATE DVDD DVDD pfet_06v0 ad=35.511p pd=48.245u as=35.511p ps=48.245u w=46.725u l=1u
X7890 BAT GATE DVDD DVDD pfet_06v0 ad=58.1096p pd=77.98u as=58.1096p ps=77.98u w=76.46u l=1u
X7891 DVDD GATE BAT DVDD pfet_06v0 ad=58.1134p pd=77.985u as=58.1134p ps=77.985u w=76.465u l=1u
X7892 BAT GATE DVDD DVDD pfet_06v0 ad=35.511p pd=48.245u as=43.9215p ps=95.32999u w=46.725u l=1u
X7893 BAT GATE DVDD DVDD pfet_06v0 ad=58.1134p pd=77.985u as=58.1134p ps=77.985u w=76.465u l=1u
X7894 DVDD GATE BAT DVDD pfet_06v0 ad=61.0812p pd=0.13184m as=49.3848p ps=66.5u w=64.98u l=1u
X7895 BAT GATE DVDD DVDD pfet_06v0 ad=58.0754p pd=77.935u as=58.0754p ps=77.935u w=76.41499u l=1u
X7896 BAT GATE DVDD DVDD pfet_06v0 ad=49.3848p pd=66.5u as=49.3848p ps=66.5u w=64.98u l=1u
X7897 BAT GATE DVDD DVDD pfet_06v0 ad=35.511p pd=48.245u as=35.511p ps=48.245u w=46.725u l=1u
X7898 BAT GATE DVDD DVDD pfet_06v0 ad=35.511p pd=48.245u as=35.511p ps=48.245u w=46.725u l=1u
X7899 BAT GATE DVDD DVDD pfet_06v0 ad=58.1134p pd=77.985u as=58.1134p ps=77.985u w=76.465u l=1u
X7900 DVDD GATE BAT DVDD pfet_06v0 ad=35.511p pd=48.245u as=35.511p ps=48.245u w=46.725u l=1u
X7901 BAT GATE DVDD DVDD pfet_06v0 ad=35.511p pd=48.245u as=35.511p ps=48.245u w=46.725u l=1u
X7902 DVDD GATE BAT DVDD pfet_06v0 ad=35.511p pd=48.245u as=35.511p ps=48.245u w=46.725u l=1u
X7903 BAT GATE DVDD DVDD pfet_06v0 ad=58.1134p pd=77.985u as=71.8771p ps=0.15481m w=76.465u l=1u
X7904 DVDD GATE BAT DVDD pfet_06v0 ad=58.1096p pd=77.98u as=58.1096p ps=77.98u w=76.46u l=1u
X7905 BAT GATE DVDD DVDD pfet_06v0 ad=47.6862p pd=64.265u as=47.6862p ps=64.265u w=62.745u l=1u
X7906 BAT GATE DVDD DVDD pfet_06v0 ad=58.1134p pd=77.985u as=71.8771p ps=0.15481m w=76.465u l=1u
X7907 BAT GATE DVDD DVDD pfet_06v0 ad=35.511p pd=48.245u as=35.511p ps=48.245u w=46.725u l=1u
X7908 DVDD GATE BAT DVDD pfet_06v0 ad=58.9803p pd=0.12737m as=47.6862p ps=64.265u w=62.745u l=1u
X7909 BAT GATE DVDD DVDD pfet_06v0 ad=35.511p pd=48.245u as=35.511p ps=48.245u w=46.725u l=1u
X7910 BAT GATE DVDD DVDD pfet_06v0 ad=58.1134p pd=77.985u as=71.8771p ps=0.15481m w=76.465u l=1u
X7911 DVDD GATE BAT DVDD pfet_06v0 ad=71.8771p pd=0.15481m as=58.1134p ps=77.985u w=76.465u l=1u
X7912 BAT GATE DVDD DVDD pfet_06v0 ad=58.1172p pd=77.99u as=58.1172p ps=77.99u w=76.47u l=1u
X7913 DVDD GATE BAT DVDD pfet_06v0 ad=58.1134p pd=77.985u as=58.1134p ps=77.985u w=76.465u l=1u
X7914 BAT GATE DVDD DVDD pfet_06v0 ad=47.6862p pd=64.265u as=47.6862p ps=64.265u w=62.745u l=1u
X7915 DVDD GATE BAT DVDD pfet_06v0 ad=35.5072p pd=48.24u as=35.5072p ps=48.24u w=46.72u l=1u
X7916 DVDD GATE BAT DVDD pfet_06v0 ad=71.8724p pd=0.1548m as=58.1096p ps=77.98u w=76.46u l=1u
X7917 BAT GATE DVDD DVDD pfet_06v0 ad=58.1134p pd=77.985u as=58.1134p ps=77.985u w=76.465u l=1u
X7918 DVDD GATE BAT DVDD pfet_06v0 ad=58.0754p pd=77.935u as=58.0754p ps=77.935u w=76.41499u l=1u
X7919 BAT GATE DVDD DVDD pfet_06v0 ad=35.511p pd=48.245u as=35.511p ps=48.245u w=46.725u l=1u
X7920 DVDD GATE BAT DVDD pfet_06v0 ad=58.0754p pd=77.935u as=58.0754p ps=77.935u w=76.41499u l=1u
X7921 BAT GATE DVDD DVDD pfet_06v0 ad=35.511p pd=48.245u as=35.511p ps=48.245u w=46.725u l=1u
X7922 BAT GATE DVDD DVDD pfet_06v0 ad=58.1134p pd=77.985u as=58.1134p ps=77.985u w=76.465u l=1u
X7923 BAT GATE DVDD DVDD pfet_06v0 ad=35.511p pd=48.245u as=43.9215p ps=95.32999u w=46.725u l=1u
X7924 DVDD GATE BAT DVDD pfet_06v0 ad=58.1552p pd=78.04u as=58.1552p ps=78.04u w=76.52u l=1u
X7925 DVDD GATE BAT DVDD pfet_06v0 ad=35.511p pd=48.245u as=35.511p ps=48.245u w=46.725u l=1u
X7926 DVDD GATE BAT DVDD pfet_06v0 ad=61.0812p pd=0.13184m as=49.3848p ps=66.5u w=64.98u l=1u
X7927 DVDD GATE BAT DVDD pfet_06v0 ad=35.511p pd=48.245u as=35.511p ps=48.245u w=46.725u l=1u
X7928 BAT GATE DVDD DVDD pfet_06v0 ad=58.1134p pd=77.985u as=71.8771p ps=0.15481m w=76.465u l=1u
X7929 BAT GATE DVDD DVDD pfet_06v0 ad=49.3848p pd=66.5u as=49.3848p ps=66.5u w=64.98u l=1u
X7930 BAT GATE DVDD DVDD pfet_06v0 ad=35.511p pd=48.245u as=35.511p ps=48.245u w=46.725u l=1u
X7931 BAT GATE DVDD DVDD pfet_06v0 ad=58.1134p pd=77.985u as=58.1134p ps=77.985u w=76.465u l=1u
X7932 BAT GATE DVDD DVDD pfet_06v0 ad=35.511p pd=48.245u as=35.511p ps=48.245u w=46.725u l=1u
X7933 BAT GATE DVDD DVDD pfet_06v0 ad=58.1134p pd=77.985u as=58.1134p ps=77.985u w=76.465u l=1u
X7934 BAT GATE DVDD DVDD pfet_06v0 ad=58.1134p pd=77.985u as=58.1134p ps=77.985u w=76.465u l=1u
X7935 DVDD GATE BAT DVDD pfet_06v0 ad=35.511p pd=48.245u as=35.511p ps=48.245u w=46.725u l=1u
X7936 DVDD GATE BAT DVDD pfet_06v0 ad=58.0754p pd=77.935u as=58.0754p ps=77.935u w=76.41499u l=1u
X7937 BAT GATE DVDD DVDD pfet_06v0 ad=35.511p pd=48.245u as=35.511p ps=48.245u w=46.725u l=1u
X7938 DVDD GATE BAT DVDD pfet_06v0 ad=35.511p pd=48.245u as=35.511p ps=48.245u w=46.725u l=1u
X7939 BAT GATE DVDD DVDD pfet_06v0 ad=35.511p pd=48.245u as=35.511p ps=48.245u w=46.725u l=1u
X7940 DVDD GATE BAT DVDD pfet_06v0 ad=58.1134p pd=77.985u as=58.1134p ps=77.985u w=76.465u l=1u
X7941 BAT GATE DVDD DVDD pfet_06v0 ad=35.511p pd=48.245u as=35.511p ps=48.245u w=46.725u l=1u
X7942 DVDD GATE BAT DVDD pfet_06v0 ad=58.1134p pd=77.985u as=58.1134p ps=77.985u w=76.465u l=1u
X7943 DVDD GATE BAT DVDD pfet_06v0 ad=35.511p pd=48.245u as=35.511p ps=48.245u w=46.725u l=1u
X7944 DVDD GATE BAT DVDD pfet_06v0 ad=58.1134p pd=77.985u as=58.1134p ps=77.985u w=76.465u l=1u
X7945 BAT GATE DVDD DVDD pfet_06v0 ad=47.6862p pd=64.265u as=47.6862p ps=64.265u w=62.745u l=1u
X7946 BAT GATE DVDD DVDD pfet_06v0 ad=58.1172p pd=77.99u as=71.8818p ps=0.15482m w=76.47u l=1u
X7947 DVDD GATE BAT DVDD pfet_06v0 ad=35.511p pd=48.245u as=35.511p ps=48.245u w=46.725u l=1u
X7948 DVDD GATE BAT DVDD pfet_06v0 ad=35.511p pd=48.245u as=35.511p ps=48.245u w=46.725u l=1u
X7949 DVDD GATE BAT DVDD pfet_06v0 ad=58.1134p pd=77.985u as=58.1134p ps=77.985u w=76.465u l=1u
X7950 BAT GATE DVDD DVDD pfet_06v0 ad=35.511p pd=48.245u as=35.511p ps=48.245u w=46.725u l=1u
X7951 BAT GATE DVDD DVDD pfet_06v0 ad=35.5072p pd=48.24u as=35.5072p ps=48.24u w=46.72u l=1u
X7952 BAT GATE DVDD DVDD pfet_06v0 ad=58.0754p pd=77.935u as=71.8301p ps=0.15471m w=76.41499u l=1u
X7953 DVDD GATE BAT DVDD pfet_06v0 ad=35.511p pd=48.245u as=35.511p ps=48.245u w=46.725u l=1u
X7954 BAT GATE DVDD DVDD pfet_06v0 ad=35.511p pd=48.245u as=43.9215p ps=95.32999u w=46.725u l=1u
X7955 DVDD GATE BAT DVDD pfet_06v0 ad=35.511p pd=48.245u as=35.511p ps=48.245u w=46.725u l=1u
X7956 BAT GATE DVDD DVDD pfet_06v0 ad=35.511p pd=48.245u as=35.511p ps=48.245u w=46.725u l=1u
X7957 BAT GATE DVDD DVDD pfet_06v0 ad=58.1134p pd=77.985u as=58.1134p ps=77.985u w=76.465u l=1u
X7958 BAT GATE DVDD DVDD pfet_06v0 ad=35.511p pd=48.245u as=43.9215p ps=95.32999u w=46.725u l=1u
X7959 DVDD GATE BAT DVDD pfet_06v0 ad=43.9215p pd=95.32999u as=35.511p ps=48.245u w=46.725u l=1u
X7960 DVDD GATE BAT DVDD pfet_06v0 ad=58.1096p pd=77.98u as=58.1096p ps=77.98u w=76.46u l=1u
X7961 BAT GATE DVDD DVDD pfet_06v0 ad=35.511p pd=48.245u as=43.9215p ps=95.32999u w=46.725u l=1u
X7962 DVDD GATE BAT DVDD pfet_06v0 ad=58.1552p pd=78.04u as=58.1552p ps=78.04u w=76.52u l=1u
X7963 BAT GATE DVDD DVDD pfet_06v0 ad=58.1134p pd=77.985u as=58.1134p ps=77.985u w=76.465u l=1u
X7964 BAT GATE DVDD DVDD pfet_06v0 ad=35.511p pd=48.245u as=35.511p ps=48.245u w=46.725u l=1u
X7965 BAT GATE DVDD DVDD pfet_06v0 ad=35.511p pd=48.245u as=35.511p ps=48.245u w=46.725u l=1u
X7966 DVDD GATE BAT DVDD pfet_06v0 ad=35.511p pd=48.245u as=35.511p ps=48.245u w=46.725u l=1u
X7967 DVDD GATE BAT DVDD pfet_06v0 ad=58.1134p pd=77.985u as=58.1134p ps=77.985u w=76.465u l=1u
X7968 DVDD GATE BAT DVDD pfet_06v0 ad=35.511p pd=48.245u as=35.511p ps=48.245u w=46.725u l=1u
X7969 DVDD GATE BAT DVDD pfet_06v0 ad=71.8771p pd=0.15481m as=58.1134p ps=77.985u w=76.465u l=1u
X7970 DVDD GATE BAT DVDD pfet_06v0 ad=47.6862p pd=64.265u as=47.6862p ps=64.265u w=62.745u l=1u
X7971 DVDD GATE BAT DVDD pfet_06v0 ad=35.511p pd=48.245u as=35.511p ps=48.245u w=46.725u l=1u
X7972 BAT GATE DVDD DVDD pfet_06v0 ad=58.1134p pd=77.985u as=58.1134p ps=77.985u w=76.465u l=1u
X7973 DVDD GATE BAT DVDD pfet_06v0 ad=58.1134p pd=77.985u as=58.1134p ps=77.985u w=76.465u l=1u
X7974 DVDD GATE BAT DVDD pfet_06v0 ad=58.1172p pd=77.99u as=58.1172p ps=77.99u w=76.47u l=1u
X7975 BAT GATE DVDD DVDD pfet_06v0 ad=35.511p pd=48.245u as=35.511p ps=48.245u w=46.725u l=1u
X7976 DVDD GATE BAT DVDD pfet_06v0 ad=71.8818p pd=0.15482m as=58.1172p ps=77.99u w=76.47u l=1u
X7977 DVDD GATE BAT DVDD pfet_06v0 ad=35.511p pd=48.245u as=35.511p ps=48.245u w=46.725u l=1u
X7978 DVDD GATE BAT DVDD pfet_06v0 ad=58.1134p pd=77.985u as=58.1134p ps=77.985u w=76.465u l=1u
X7979 DVDD GATE BAT DVDD pfet_06v0 ad=35.511p pd=48.245u as=35.511p ps=48.245u w=46.725u l=1u
X7980 DVDD GATE BAT DVDD pfet_06v0 ad=58.1134p pd=77.985u as=58.1134p ps=77.985u w=76.465u l=1u
X7981 BAT GATE DVDD DVDD pfet_06v0 ad=49.3848p pd=66.5u as=61.0812p ps=0.13184m w=64.98u l=1u
X7982 DVDD GATE BAT DVDD pfet_06v0 ad=35.511p pd=48.245u as=35.511p ps=48.245u w=46.725u l=1u
X7983 BAT GATE DVDD DVDD pfet_06v0 ad=58.1134p pd=77.985u as=58.1134p ps=77.985u w=76.465u l=1u
X7984 BAT GATE DVDD DVDD pfet_06v0 ad=35.511p pd=48.245u as=35.511p ps=48.245u w=46.725u l=1u
X7985 DVDD GATE BAT DVDD pfet_06v0 ad=58.1552p pd=78.04u as=58.1552p ps=78.04u w=76.52u l=1u
X7986 DVDD GATE BAT DVDD pfet_06v0 ad=47.6862p pd=64.265u as=47.6862p ps=64.265u w=62.745u l=1u
X7987 BAT GATE DVDD DVDD pfet_06v0 ad=35.511p pd=48.245u as=35.511p ps=48.245u w=46.725u l=1u
X7988 DVDD GATE BAT DVDD pfet_06v0 ad=58.1134p pd=77.985u as=58.1134p ps=77.985u w=76.465u l=1u
X7989 BAT GATE DVDD DVDD pfet_06v0 ad=58.0754p pd=77.935u as=71.8301p ps=0.15471m w=76.41499u l=1u
X7990 BAT GATE DVDD DVDD pfet_06v0 ad=58.1134p pd=77.985u as=58.1134p ps=77.985u w=76.465u l=1u
X7991 BAT GATE DVDD DVDD pfet_06v0 ad=35.511p pd=48.245u as=35.511p ps=48.245u w=46.725u l=1u
X7992 BAT GATE DVDD DVDD pfet_06v0 ad=35.5072p pd=48.24u as=35.5072p ps=48.24u w=46.72u l=1u
X7993 DVDD GATE BAT DVDD pfet_06v0 ad=58.1096p pd=77.98u as=58.1096p ps=77.98u w=76.46u l=1u
X7994 BAT GATE DVDD DVDD pfet_06v0 ad=58.1134p pd=77.985u as=71.8771p ps=0.15481m w=76.465u l=1u
X7995 DVDD GATE BAT DVDD pfet_06v0 ad=35.511p pd=48.245u as=35.511p ps=48.245u w=46.725u l=1u
X7996 DVDD GATE BAT DVDD pfet_06v0 ad=58.1134p pd=77.985u as=58.1134p ps=77.985u w=76.465u l=1u
X7997 BAT GATE DVDD DVDD pfet_06v0 ad=35.511p pd=48.245u as=35.511p ps=48.245u w=46.725u l=1u
X7998 DVDD GATE BAT DVDD pfet_06v0 ad=47.6862p pd=64.265u as=47.6862p ps=64.265u w=62.745u l=1u
X7999 DVDD GATE BAT DVDD pfet_06v0 ad=58.1134p pd=77.985u as=58.1134p ps=77.985u w=76.465u l=1u
X8000 BAT GATE DVDD DVDD pfet_06v0 ad=35.511p pd=48.245u as=35.511p ps=48.245u w=46.725u l=1u
X8001 BAT GATE DVDD DVDD pfet_06v0 ad=35.511p pd=48.245u as=35.511p ps=48.245u w=46.725u l=1u
X8002 DVDD GATE BAT DVDD pfet_06v0 ad=35.511p pd=48.245u as=35.511p ps=48.245u w=46.725u l=1u
X8003 DVDD GATE BAT DVDD pfet_06v0 ad=35.511p pd=48.245u as=35.511p ps=48.245u w=46.725u l=1u
X8004 BAT GATE DVDD DVDD pfet_06v0 ad=58.1134p pd=77.985u as=58.1134p ps=77.985u w=76.465u l=1u
X8005 BAT GATE DVDD DVDD pfet_06v0 ad=58.1134p pd=77.985u as=58.1134p ps=77.985u w=76.465u l=1u
X8006 BAT GATE DVDD DVDD pfet_06v0 ad=58.1134p pd=77.985u as=58.1134p ps=77.985u w=76.465u l=1u
X8007 DVDD GATE BAT DVDD pfet_06v0 ad=58.1134p pd=77.985u as=58.1134p ps=77.985u w=76.465u l=1u
X8008 DVDD GATE BAT DVDD pfet_06v0 ad=49.3848p pd=66.5u as=49.3848p ps=66.5u w=64.98u l=1u
X8009 BAT GATE DVDD DVDD pfet_06v0 ad=35.511p pd=48.245u as=35.511p ps=48.245u w=46.725u l=1u
X8010 DVDD GATE BAT DVDD pfet_06v0 ad=58.1134p pd=77.985u as=58.1134p ps=77.985u w=76.465u l=1u
X8011 DVDD GATE BAT DVDD pfet_06v0 ad=35.511p pd=48.245u as=35.511p ps=48.245u w=46.725u l=1u
X8012 DVDD GATE BAT DVDD pfet_06v0 ad=35.511p pd=48.245u as=35.511p ps=48.245u w=46.725u l=1u
X8013 BAT GATE DVDD DVDD pfet_06v0 ad=35.511p pd=48.245u as=43.9215p ps=95.32999u w=46.725u l=1u
X8014 DVDD GATE BAT DVDD pfet_06v0 ad=43.9215p pd=95.32999u as=35.511p ps=48.245u w=46.725u l=1u
X8015 DVDD GATE BAT DVDD pfet_06v0 ad=71.8301p pd=0.15471m as=58.0754p ps=77.935u w=76.41499u l=1u
X8016 BAT GATE DVDD DVDD pfet_06v0 ad=49.3848p pd=66.5u as=61.0812p ps=0.13184m w=64.98u l=1u
X8017 DVDD GATE BAT DVDD pfet_06v0 ad=35.511p pd=48.245u as=35.511p ps=48.245u w=46.725u l=1u
X8018 BAT GATE DVDD DVDD pfet_06v0 ad=35.511p pd=48.245u as=35.511p ps=48.245u w=46.725u l=1u
X8019 BAT GATE DVDD DVDD pfet_06v0 ad=35.511p pd=48.245u as=43.9215p ps=95.32999u w=46.725u l=1u
X8020 BAT GATE DVDD DVDD pfet_06v0 ad=58.1096p pd=77.98u as=58.1096p ps=77.98u w=76.46u l=1u
X8021 BAT GATE DVDD DVDD pfet_06v0 ad=58.1134p pd=77.985u as=58.1134p ps=77.985u w=76.465u l=1u
X8022 DVDD GATE BAT DVDD pfet_06v0 ad=35.511p pd=48.245u as=35.511p ps=48.245u w=46.725u l=1u
X8023 BAT GATE DVDD DVDD pfet_06v0 ad=58.1096p pd=77.98u as=58.1096p ps=77.98u w=76.46u l=1u
X8024 DVDD GATE BAT DVDD pfet_06v0 ad=47.6862p pd=64.265u as=47.6862p ps=64.265u w=62.745u l=1u
X8025 DVDD GATE BAT DVDD pfet_06v0 ad=58.1134p pd=77.985u as=58.1134p ps=77.985u w=76.465u l=1u
X8026 BAT GATE DVDD DVDD pfet_06v0 ad=58.1552p pd=78.04u as=71.92879p ps=0.15492m w=76.52u l=1u
X8027 DVDD GATE BAT DVDD pfet_06v0 ad=49.3848p pd=66.5u as=49.3848p ps=66.5u w=64.98u l=1u
X8028 BAT GATE DVDD DVDD pfet_06v0 ad=58.1134p pd=77.985u as=58.1134p ps=77.985u w=76.465u l=1u
X8029 BAT GATE DVDD DVDD pfet_06v0 ad=58.1552p pd=78.04u as=58.1552p ps=78.04u w=76.52u l=1u
X8030 BAT GATE DVDD DVDD pfet_06v0 ad=58.0754p pd=77.935u as=71.8301p ps=0.15471m w=76.41499u l=1u
X8031 BAT GATE DVDD DVDD pfet_06v0 ad=35.511p pd=48.245u as=35.511p ps=48.245u w=46.725u l=1u
X8032 DVDD GATE BAT DVDD pfet_06v0 ad=58.1134p pd=77.985u as=58.1134p ps=77.985u w=76.465u l=1u
X8033 BAT GATE DVDD DVDD pfet_06v0 ad=35.5072p pd=48.24u as=35.5072p ps=48.24u w=46.72u l=1u
X8034 BAT GATE DVDD DVDD pfet_06v0 ad=58.1134p pd=77.985u as=58.1134p ps=77.985u w=76.465u l=1u
X8035 BAT GATE DVDD DVDD pfet_06v0 ad=58.0754p pd=77.935u as=58.0754p ps=77.935u w=76.41499u l=1u
X8036 DVDD GATE BAT DVDD pfet_06v0 ad=35.511p pd=48.245u as=35.511p ps=48.245u w=46.725u l=1u
X8037 DVDD GATE BAT DVDD pfet_06v0 ad=43.9215p pd=95.32999u as=35.511p ps=48.245u w=46.725u l=1u
X8038 BAT GATE DVDD DVDD pfet_06v0 ad=35.5072p pd=48.24u as=35.5072p ps=48.24u w=46.72u l=1u
X8039 BAT GATE DVDD DVDD pfet_06v0 ad=58.0754p pd=77.935u as=58.0754p ps=77.935u w=76.41499u l=1u
X8040 BAT GATE DVDD DVDD pfet_06v0 ad=58.1096p pd=77.98u as=58.1096p ps=77.98u w=76.46u l=1u
X8041 DVDD GATE BAT DVDD pfet_06v0 ad=47.6862p pd=64.265u as=47.6862p ps=64.265u w=62.745u l=1u
X8042 BAT GATE DVDD DVDD pfet_06v0 ad=35.511p pd=48.245u as=43.9215p ps=95.32999u w=46.725u l=1u
X8043 BAT GATE DVDD DVDD pfet_06v0 ad=58.1134p pd=77.985u as=58.1134p ps=77.985u w=76.465u l=1u
X8044 DVDD GATE BAT DVDD pfet_06v0 ad=58.0754p pd=77.935u as=58.0754p ps=77.935u w=76.41499u l=1u
X8045 BAT GATE DVDD DVDD pfet_06v0 ad=35.511p pd=48.245u as=35.511p ps=48.245u w=46.725u l=1u
X8046 BAT GATE DVDD DVDD pfet_06v0 ad=35.511p pd=48.245u as=35.511p ps=48.245u w=46.725u l=1u
X8047 DVDD GATE BAT DVDD pfet_06v0 ad=58.1134p pd=77.985u as=58.1134p ps=77.985u w=76.465u l=1u
X8048 BAT GATE DVDD DVDD pfet_06v0 ad=35.511p pd=48.245u as=35.511p ps=48.245u w=46.725u l=1u
X8049 BAT GATE DVDD DVDD pfet_06v0 ad=35.5072p pd=48.24u as=35.5072p ps=48.24u w=46.72u l=1u
X8050 BAT GATE DVDD DVDD pfet_06v0 ad=58.1172p pd=77.99u as=58.1172p ps=77.99u w=76.47u l=1u
X8051 DVDD GATE BAT DVDD pfet_06v0 ad=35.511p pd=48.245u as=35.511p ps=48.245u w=46.725u l=1u
X8052 BAT GATE DVDD DVDD pfet_06v0 ad=58.1134p pd=77.985u as=71.8771p ps=0.15481m w=76.465u l=1u
X8053 DVDD GATE BAT DVDD pfet_06v0 ad=43.9215p pd=95.32999u as=35.511p ps=48.245u w=46.725u l=1u
X8054 DVDD GATE BAT DVDD pfet_06v0 ad=49.3848p pd=66.5u as=49.3848p ps=66.5u w=64.98u l=1u
X8055 BAT GATE DVDD DVDD pfet_06v0 ad=35.511p pd=48.245u as=35.511p ps=48.245u w=46.725u l=1u
X8056 BAT GATE DVDD DVDD pfet_06v0 ad=58.1096p pd=77.98u as=58.1096p ps=77.98u w=76.46u l=1u
X8057 DVDD GATE BAT DVDD pfet_06v0 ad=49.3848p pd=66.5u as=49.3848p ps=66.5u w=64.98u l=1u
X8058 DVDD GATE BAT DVDD pfet_06v0 ad=43.9215p pd=95.32999u as=35.511p ps=48.245u w=46.725u l=1u
X8059 DVDD GATE BAT DVDD pfet_06v0 ad=35.5072p pd=48.24u as=35.5072p ps=48.24u w=46.72u l=1u
X8060 DVDD GATE BAT DVDD pfet_06v0 ad=35.511p pd=48.245u as=35.511p ps=48.245u w=46.725u l=1u
X8061 BAT GATE DVDD DVDD pfet_06v0 ad=58.1552p pd=78.04u as=58.1552p ps=78.04u w=76.52u l=1u
X8062 DVDD GATE BAT DVDD pfet_06v0 ad=35.511p pd=48.245u as=35.511p ps=48.245u w=46.725u l=1u
X8063 DVDD GATE BAT DVDD pfet_06v0 ad=35.5072p pd=48.24u as=35.5072p ps=48.24u w=46.72u l=1u
X8064 DVDD GATE BAT DVDD pfet_06v0 ad=71.8771p pd=0.15481m as=58.1134p ps=77.985u w=76.465u l=1u
X8065 DVDD GATE BAT DVDD pfet_06v0 ad=58.1134p pd=77.985u as=58.1134p ps=77.985u w=76.465u l=1u
X8066 BAT GATE DVDD DVDD pfet_06v0 ad=35.511p pd=48.245u as=35.511p ps=48.245u w=46.725u l=1u
X8067 BAT GATE DVDD DVDD pfet_06v0 ad=58.1134p pd=77.985u as=58.1134p ps=77.985u w=76.465u l=1u
X8068 BAT GATE DVDD DVDD pfet_06v0 ad=35.511p pd=48.245u as=43.9215p ps=95.32999u w=46.725u l=1u
X8069 BAT GATE DVDD DVDD pfet_06v0 ad=49.3848p pd=66.5u as=49.3848p ps=66.5u w=64.98u l=1u
X8070 BAT GATE DVDD DVDD pfet_06v0 ad=58.1096p pd=77.98u as=71.8724p ps=0.1548m w=76.46u l=1u
X8071 DVDD GATE BAT DVDD pfet_06v0 ad=35.511p pd=48.245u as=35.511p ps=48.245u w=46.725u l=1u
X8072 BAT GATE DVDD DVDD pfet_06v0 ad=35.511p pd=48.245u as=35.511p ps=48.245u w=46.725u l=1u
X8073 DVDD GATE BAT DVDD pfet_06v0 ad=58.1134p pd=77.985u as=58.1134p ps=77.985u w=76.465u l=1u
X8074 DVDD GATE BAT DVDD pfet_06v0 ad=47.6862p pd=64.265u as=47.6862p ps=64.265u w=62.745u l=1u
X8075 DVDD GATE BAT DVDD pfet_06v0 ad=58.1134p pd=77.985u as=58.1134p ps=77.985u w=76.465u l=1u
X8076 DVDD GATE BAT DVDD pfet_06v0 ad=35.511p pd=48.245u as=35.511p ps=48.245u w=46.725u l=1u
X8077 BAT GATE DVDD DVDD pfet_06v0 ad=58.1134p pd=77.985u as=58.1134p ps=77.985u w=76.465u l=1u
X8078 DVDD GATE BAT DVDD pfet_06v0 ad=35.511p pd=48.245u as=35.511p ps=48.245u w=46.725u l=1u
X8079 DVDD GATE BAT DVDD pfet_06v0 ad=43.9215p pd=95.32999u as=35.511p ps=48.245u w=46.725u l=1u
X8080 BAT GATE DVDD DVDD pfet_06v0 ad=58.1134p pd=77.985u as=58.1134p ps=77.985u w=76.465u l=1u
X8081 BAT GATE DVDD DVDD pfet_06v0 ad=35.511p pd=48.245u as=35.511p ps=48.245u w=46.725u l=1u
X8082 DVDD GATE BAT DVDD pfet_06v0 ad=71.8771p pd=0.15481m as=58.1134p ps=77.985u w=76.465u l=1u
X8083 BAT GATE DVDD DVDD pfet_06v0 ad=35.511p pd=48.245u as=35.511p ps=48.245u w=46.725u l=1u
X8084 DVDD GATE BAT DVDD pfet_06v0 ad=49.3848p pd=66.5u as=49.3848p ps=66.5u w=64.98u l=1u
X8085 DVDD GATE BAT DVDD pfet_06v0 ad=35.511p pd=48.245u as=35.511p ps=48.245u w=46.725u l=1u
X8086 BAT GATE DVDD DVDD pfet_06v0 ad=58.1134p pd=77.985u as=71.8771p ps=0.15481m w=76.465u l=1u
X8087 BAT GATE DVDD DVDD pfet_06v0 ad=58.1134p pd=77.985u as=58.1134p ps=77.985u w=76.465u l=1u
X8088 BAT GATE DVDD DVDD pfet_06v0 ad=35.511p pd=48.245u as=43.9215p ps=95.32999u w=46.725u l=1u
X8089 BAT GATE DVDD DVDD pfet_06v0 ad=58.1134p pd=77.985u as=58.1134p ps=77.985u w=76.465u l=1u
X8090 BAT GATE DVDD DVDD pfet_06v0 ad=35.511p pd=48.245u as=35.511p ps=48.245u w=46.725u l=1u
X8091 DVDD GATE BAT DVDD pfet_06v0 ad=58.1134p pd=77.985u as=58.1134p ps=77.985u w=76.465u l=1u
X8092 BAT GATE DVDD DVDD pfet_06v0 ad=35.511p pd=48.245u as=35.511p ps=48.245u w=46.725u l=1u
X8093 BAT GATE DVDD DVDD pfet_06v0 ad=35.511p pd=48.245u as=35.511p ps=48.245u w=46.725u l=1u
X8094 DVDD GATE BAT DVDD pfet_06v0 ad=35.511p pd=48.245u as=35.511p ps=48.245u w=46.725u l=1u
X8095 DVDD GATE BAT DVDD pfet_06v0 ad=49.3848p pd=66.5u as=49.3848p ps=66.5u w=64.98u l=1u
X8096 DVDD GATE BAT DVDD pfet_06v0 ad=35.511p pd=48.245u as=35.511p ps=48.245u w=46.725u l=1u
X8097 BAT GATE DVDD DVDD pfet_06v0 ad=35.511p pd=48.245u as=35.511p ps=48.245u w=46.725u l=1u
X8098 BAT GATE DVDD DVDD pfet_06v0 ad=58.1134p pd=77.985u as=58.1134p ps=77.985u w=76.465u l=1u
X8099 DVDD GATE BAT DVDD pfet_06v0 ad=58.0754p pd=77.935u as=58.0754p ps=77.935u w=76.41499u l=1u
X8100 BAT GATE DVDD DVDD pfet_06v0 ad=47.6862p pd=64.265u as=47.6862p ps=64.265u w=62.745u l=1u
X8101 BAT GATE DVDD DVDD pfet_06v0 ad=35.511p pd=48.245u as=43.9215p ps=95.32999u w=46.725u l=1u
X8102 DVDD GATE BAT DVDD pfet_06v0 ad=58.1134p pd=77.985u as=58.1134p ps=77.985u w=76.465u l=1u
X8103 BAT GATE DVDD DVDD pfet_06v0 ad=35.511p pd=48.245u as=35.511p ps=48.245u w=46.725u l=1u
X8104 BAT GATE DVDD DVDD pfet_06v0 ad=35.511p pd=48.245u as=35.511p ps=48.245u w=46.725u l=1u
X8105 DVDD GATE BAT DVDD pfet_06v0 ad=58.0754p pd=77.935u as=58.0754p ps=77.935u w=76.41499u l=1u
X8106 DVDD GATE BAT DVDD pfet_06v0 ad=35.511p pd=48.245u as=35.511p ps=48.245u w=46.725u l=1u
X8107 BAT GATE DVDD DVDD pfet_06v0 ad=35.511p pd=48.245u as=35.511p ps=48.245u w=46.725u l=1u
X8108 BAT GATE DVDD DVDD pfet_06v0 ad=58.1134p pd=77.985u as=58.1134p ps=77.985u w=76.465u l=1u
X8109 DVDD GATE BAT DVDD pfet_06v0 ad=58.1134p pd=77.985u as=58.1134p ps=77.985u w=76.465u l=1u
X8110 BAT GATE DVDD DVDD pfet_06v0 ad=35.511p pd=48.245u as=35.511p ps=48.245u w=46.725u l=1u
X8111 BAT GATE DVDD DVDD pfet_06v0 ad=35.511p pd=48.245u as=35.511p ps=48.245u w=46.725u l=1u
X8112 BAT GATE DVDD DVDD pfet_06v0 ad=35.511p pd=48.245u as=35.511p ps=48.245u w=46.725u l=1u
X8113 DVDD GATE BAT DVDD pfet_06v0 ad=35.511p pd=48.245u as=35.511p ps=48.245u w=46.725u l=1u
X8114 DVDD GATE BAT DVDD pfet_06v0 ad=35.511p pd=48.245u as=35.511p ps=48.245u w=46.725u l=1u
X8115 DVDD GATE BAT DVDD pfet_06v0 ad=47.6862p pd=64.265u as=47.6862p ps=64.265u w=62.745u l=1u
X8116 BAT GATE DVDD DVDD pfet_06v0 ad=47.6862p pd=64.265u as=47.6862p ps=64.265u w=62.745u l=1u
X8117 BAT GATE DVDD DVDD pfet_06v0 ad=35.511p pd=48.245u as=43.9215p ps=95.32999u w=46.725u l=1u
X8118 DVDD GATE BAT DVDD pfet_06v0 ad=47.6862p pd=64.265u as=47.6862p ps=64.265u w=62.745u l=1u
X8119 DVDD GATE BAT DVDD pfet_06v0 ad=58.1134p pd=77.985u as=58.1134p ps=77.985u w=76.465u l=1u
X8120 DVDD GATE BAT DVDD pfet_06v0 ad=58.1134p pd=77.985u as=58.1134p ps=77.985u w=76.465u l=1u
X8121 BAT GATE DVDD DVDD pfet_06v0 ad=58.1134p pd=77.985u as=58.1134p ps=77.985u w=76.465u l=1u
X8122 BAT GATE DVDD DVDD pfet_06v0 ad=49.3848p pd=66.5u as=49.3848p ps=66.5u w=64.98u l=1u
X8123 BAT GATE DVDD DVDD pfet_06v0 ad=58.1134p pd=77.985u as=58.1134p ps=77.985u w=76.465u l=1u
X8124 BAT GATE DVDD DVDD pfet_06v0 ad=35.511p pd=48.245u as=43.9215p ps=95.32999u w=46.725u l=1u
X8125 BAT GATE DVDD DVDD pfet_06v0 ad=35.511p pd=48.245u as=35.511p ps=48.245u w=46.725u l=1u
X8126 BAT GATE DVDD DVDD pfet_06v0 ad=49.3848p pd=66.5u as=49.3848p ps=66.5u w=64.98u l=1u
X8127 BAT GATE DVDD DVDD pfet_06v0 ad=35.511p pd=48.245u as=35.511p ps=48.245u w=46.725u l=1u
X8128 BAT GATE DVDD DVDD pfet_06v0 ad=58.1134p pd=77.985u as=71.8771p ps=0.15481m w=76.465u l=1u
X8129 DVDD GATE BAT DVDD pfet_06v0 ad=71.8771p pd=0.15481m as=58.1134p ps=77.985u w=76.465u l=1u
X8130 DVDD GATE BAT DVDD pfet_06v0 ad=35.511p pd=48.245u as=35.511p ps=48.245u w=46.725u l=1u
X8131 DVDD GATE BAT DVDD pfet_06v0 ad=58.1134p pd=77.985u as=58.1134p ps=77.985u w=76.465u l=1u
X8132 DVDD GATE BAT DVDD pfet_06v0 ad=58.1096p pd=77.98u as=58.1096p ps=77.98u w=76.46u l=1u
X8133 BAT GATE DVDD DVDD pfet_06v0 ad=35.511p pd=48.245u as=35.511p ps=48.245u w=46.725u l=1u
X8134 DVDD GATE BAT DVDD pfet_06v0 ad=71.8771p pd=0.15481m as=58.1134p ps=77.985u w=76.465u l=1u
X8135 BAT GATE DVDD DVDD pfet_06v0 ad=49.3848p pd=66.5u as=49.3848p ps=66.5u w=64.98u l=1u
X8136 DVDD GATE BAT DVDD pfet_06v0 ad=58.0754p pd=77.935u as=58.0754p ps=77.935u w=76.41499u l=1u
X8137 DVDD GATE BAT DVDD pfet_06v0 ad=49.3848p pd=66.5u as=49.3848p ps=66.5u w=64.98u l=1u
X8138 BAT GATE DVDD DVDD pfet_06v0 ad=35.511p pd=48.245u as=35.511p ps=48.245u w=46.725u l=1u
X8139 DVDD GATE BAT DVDD pfet_06v0 ad=35.5072p pd=48.24u as=35.5072p ps=48.24u w=46.72u l=1u
X8140 BAT GATE DVDD DVDD pfet_06v0 ad=35.511p pd=48.245u as=35.511p ps=48.245u w=46.725u l=1u
X8141 BAT GATE DVDD DVDD pfet_06v0 ad=58.1172p pd=77.99u as=58.1172p ps=77.99u w=76.47u l=1u
X8142 DVDD GATE BAT DVDD pfet_06v0 ad=35.511p pd=48.245u as=35.511p ps=48.245u w=46.725u l=1u
X8143 DVDD GATE BAT DVDD pfet_06v0 ad=43.9215p pd=95.32999u as=35.511p ps=48.245u w=46.725u l=1u
X8144 DVDD GATE BAT DVDD pfet_06v0 ad=58.1134p pd=77.985u as=58.1134p ps=77.985u w=76.465u l=1u
X8145 DVDD GATE BAT DVDD pfet_06v0 ad=35.5072p pd=48.24u as=35.5072p ps=48.24u w=46.72u l=1u
X8146 DVDD GATE BAT DVDD pfet_06v0 ad=58.1172p pd=77.99u as=58.1172p ps=77.99u w=76.47u l=1u
X8147 BAT GATE DVDD DVDD pfet_06v0 ad=58.1134p pd=77.985u as=58.1134p ps=77.985u w=76.465u l=1u
X8148 DVDD GATE BAT DVDD pfet_06v0 ad=58.0754p pd=77.935u as=58.0754p ps=77.935u w=76.41499u l=1u
X8149 BAT GATE DVDD DVDD pfet_06v0 ad=35.511p pd=48.245u as=35.511p ps=48.245u w=46.725u l=1u
X8150 DVDD GATE BAT DVDD pfet_06v0 ad=35.511p pd=48.245u as=35.511p ps=48.245u w=46.725u l=1u
X8151 BAT GATE DVDD DVDD pfet_06v0 ad=35.511p pd=48.245u as=35.511p ps=48.245u w=46.725u l=1u
X8152 DVDD GATE BAT DVDD pfet_06v0 ad=71.8771p pd=0.15481m as=58.1134p ps=77.985u w=76.465u l=1u
X8153 DVDD GATE BAT DVDD pfet_06v0 ad=71.8771p pd=0.15481m as=58.1134p ps=77.985u w=76.465u l=1u
X8154 BAT GATE DVDD DVDD pfet_06v0 ad=58.1134p pd=77.985u as=58.1134p ps=77.985u w=76.465u l=1u
X8155 BAT GATE DVDD DVDD pfet_06v0 ad=58.1134p pd=77.985u as=58.1134p ps=77.985u w=76.465u l=1u
X8156 BAT GATE DVDD DVDD pfet_06v0 ad=58.1096p pd=77.98u as=58.1096p ps=77.98u w=76.46u l=1u
X8157 DVDD GATE BAT DVDD pfet_06v0 ad=47.6862p pd=64.265u as=47.6862p ps=64.265u w=62.745u l=1u
X8158 BAT GATE DVDD DVDD pfet_06v0 ad=35.5072p pd=48.24u as=43.9168p ps=95.32u w=46.72u l=1u
X8159 BAT GATE DVDD DVDD pfet_06v0 ad=35.5072p pd=48.24u as=35.5072p ps=48.24u w=46.72u l=1u
X8160 DVDD GATE BAT DVDD pfet_06v0 ad=71.8771p pd=0.15481m as=58.1134p ps=77.985u w=76.465u l=1u
X8161 BAT GATE DVDD DVDD pfet_06v0 ad=49.3848p pd=66.5u as=49.3848p ps=66.5u w=64.98u l=1u
X8162 DVDD GATE BAT DVDD pfet_06v0 ad=71.8771p pd=0.15481m as=58.1134p ps=77.985u w=76.465u l=1u
X8163 BAT GATE DVDD DVDD pfet_06v0 ad=58.1552p pd=78.04u as=58.1552p ps=78.04u w=76.52u l=1u
X8164 DVDD GATE BAT DVDD pfet_06v0 ad=58.1134p pd=77.985u as=58.1134p ps=77.985u w=76.465u l=1u
X8165 DVDD GATE BAT DVDD pfet_06v0 ad=35.511p pd=48.245u as=35.511p ps=48.245u w=46.725u l=1u
X8166 BAT GATE DVDD DVDD pfet_06v0 ad=35.511p pd=48.245u as=35.511p ps=48.245u w=46.725u l=1u
X8167 BAT GATE DVDD DVDD pfet_06v0 ad=35.511p pd=48.245u as=35.511p ps=48.245u w=46.725u l=1u
X8168 DVDD GATE BAT DVDD pfet_06v0 ad=35.511p pd=48.245u as=35.511p ps=48.245u w=46.725u l=1u
X8169 DVDD GATE BAT DVDD pfet_06v0 ad=58.1134p pd=77.985u as=58.1134p ps=77.985u w=76.465u l=1u
X8170 DVDD GATE BAT DVDD pfet_06v0 ad=35.511p pd=48.245u as=35.511p ps=48.245u w=46.725u l=1u
X8171 DVDD GATE BAT DVDD pfet_06v0 ad=58.1552p pd=78.04u as=58.1552p ps=78.04u w=76.52u l=1u
X8172 DVDD GATE BAT DVDD pfet_06v0 ad=71.8771p pd=0.15481m as=58.1134p ps=77.985u w=76.465u l=1u
X8173 DVDD GATE BAT DVDD pfet_06v0 ad=58.1134p pd=77.985u as=58.1134p ps=77.985u w=76.465u l=1u
X8174 BAT GATE DVDD DVDD pfet_06v0 ad=58.0754p pd=77.935u as=58.0754p ps=77.935u w=76.41499u l=1u
X8175 BAT GATE DVDD DVDD pfet_06v0 ad=35.511p pd=48.245u as=43.9215p ps=95.32999u w=46.725u l=1u
X8176 BAT GATE DVDD DVDD pfet_06v0 ad=35.5072p pd=48.24u as=35.5072p ps=48.24u w=46.72u l=1u
X8177 DVDD GATE BAT DVDD pfet_06v0 ad=35.511p pd=48.245u as=35.511p ps=48.245u w=46.725u l=1u
X8178 BAT GATE DVDD DVDD pfet_06v0 ad=58.1134p pd=77.985u as=58.1134p ps=77.985u w=76.465u l=1u
X8179 DVDD GATE BAT DVDD pfet_06v0 ad=43.9215p pd=95.32999u as=35.511p ps=48.245u w=46.725u l=1u
X8180 DVDD GATE BAT DVDD pfet_06v0 ad=43.9215p pd=95.32999u as=35.511p ps=48.245u w=46.725u l=1u
X8181 DVDD GATE BAT DVDD pfet_06v0 ad=35.511p pd=48.245u as=35.511p ps=48.245u w=46.725u l=1u
X8182 DVDD GATE BAT DVDD pfet_06v0 ad=43.9215p pd=95.32999u as=35.511p ps=48.245u w=46.725u l=1u
X8183 DVDD GATE BAT DVDD pfet_06v0 ad=43.9215p pd=95.32999u as=35.511p ps=48.245u w=46.725u l=1u
X8184 BAT GATE DVDD DVDD pfet_06v0 ad=35.511p pd=48.245u as=35.511p ps=48.245u w=46.725u l=1u
X8185 BAT GATE DVDD DVDD pfet_06v0 ad=35.511p pd=48.245u as=35.511p ps=48.245u w=46.725u l=1u
X8186 BAT GATE DVDD DVDD pfet_06v0 ad=58.1134p pd=77.985u as=58.1134p ps=77.985u w=76.465u l=1u
X8187 BAT GATE DVDD DVDD pfet_06v0 ad=58.1134p pd=77.985u as=58.1134p ps=77.985u w=76.465u l=1u
X8188 BAT GATE DVDD DVDD pfet_06v0 ad=58.1134p pd=77.985u as=58.1134p ps=77.985u w=76.465u l=1u
X8189 DVDD GATE BAT DVDD pfet_06v0 ad=58.1172p pd=77.99u as=58.1172p ps=77.99u w=76.47u l=1u
X8190 BAT GATE DVDD DVDD pfet_06v0 ad=35.511p pd=48.245u as=35.511p ps=48.245u w=46.725u l=1u
X8191 BAT GATE DVDD DVDD pfet_06v0 ad=35.511p pd=48.245u as=35.511p ps=48.245u w=46.725u l=1u
X8192 DVDD GATE BAT DVDD pfet_06v0 ad=58.1134p pd=77.985u as=58.1134p ps=77.985u w=76.465u l=1u
X8193 DVDD GATE BAT DVDD pfet_06v0 ad=35.511p pd=48.245u as=35.511p ps=48.245u w=46.725u l=1u
X8194 DVDD GATE BAT DVDD pfet_06v0 ad=35.511p pd=48.245u as=35.511p ps=48.245u w=46.725u l=1u
X8195 DVDD GATE BAT DVDD pfet_06v0 ad=71.8771p pd=0.15481m as=58.1134p ps=77.985u w=76.465u l=1u
X8196 BAT GATE DVDD DVDD pfet_06v0 ad=58.1096p pd=77.98u as=58.1096p ps=77.98u w=76.46u l=1u
X8197 BAT GATE DVDD DVDD pfet_06v0 ad=49.3848p pd=66.5u as=49.3848p ps=66.5u w=64.98u l=1u
X8198 BAT GATE DVDD DVDD pfet_06v0 ad=58.1552p pd=78.04u as=58.1552p ps=78.04u w=76.52u l=1u
X8199 BAT GATE DVDD DVDD pfet_06v0 ad=35.511p pd=48.245u as=35.511p ps=48.245u w=46.725u l=1u
X8200 BAT GATE DVDD DVDD pfet_06v0 ad=58.1134p pd=77.985u as=71.8771p ps=0.15481m w=76.465u l=1u
X8201 DVDD GATE BAT DVDD pfet_06v0 ad=35.511p pd=48.245u as=35.511p ps=48.245u w=46.725u l=1u
X8202 BAT GATE DVDD DVDD pfet_06v0 ad=35.511p pd=48.245u as=35.511p ps=48.245u w=46.725u l=1u
X8203 BAT GATE DVDD DVDD pfet_06v0 ad=58.1134p pd=77.985u as=58.1134p ps=77.985u w=76.465u l=1u
X8204 DVDD GATE BAT DVDD pfet_06v0 ad=58.1134p pd=77.985u as=58.1134p ps=77.985u w=76.465u l=1u
X8205 DVDD GATE BAT DVDD pfet_06v0 ad=35.511p pd=48.245u as=35.511p ps=48.245u w=46.725u l=1u
X8206 DVDD GATE BAT DVDD pfet_06v0 ad=43.9215p pd=95.32999u as=35.511p ps=48.245u w=46.725u l=1u
X8207 BAT GATE DVDD DVDD pfet_06v0 ad=35.511p pd=48.245u as=35.511p ps=48.245u w=46.725u l=1u
X8208 BAT GATE DVDD DVDD pfet_06v0 ad=58.1134p pd=77.985u as=58.1134p ps=77.985u w=76.465u l=1u
X8209 BAT GATE DVDD DVDD pfet_06v0 ad=35.511p pd=48.245u as=35.511p ps=48.245u w=46.725u l=1u
X8210 DVDD GATE BAT DVDD pfet_06v0 ad=58.1134p pd=77.985u as=58.1134p ps=77.985u w=76.465u l=1u
X8211 DVDD GATE BAT DVDD pfet_06v0 ad=35.511p pd=48.245u as=35.511p ps=48.245u w=46.725u l=1u
X8212 DVDD GATE BAT DVDD pfet_06v0 ad=35.511p pd=48.245u as=35.511p ps=48.245u w=46.725u l=1u
X8213 DVDD GATE BAT DVDD pfet_06v0 ad=35.511p pd=48.245u as=35.511p ps=48.245u w=46.725u l=1u
X8214 BAT GATE DVDD DVDD pfet_06v0 ad=35.511p pd=48.245u as=35.511p ps=48.245u w=46.725u l=1u
X8215 DVDD GATE BAT DVDD pfet_06v0 ad=71.8771p pd=0.15481m as=58.1134p ps=77.985u w=76.465u l=1u
X8216 BAT GATE DVDD DVDD pfet_06v0 ad=58.1134p pd=77.985u as=58.1134p ps=77.985u w=76.465u l=1u
X8217 DVDD GATE BAT DVDD pfet_06v0 ad=35.511p pd=48.245u as=35.511p ps=48.245u w=46.725u l=1u
X8218 DVDD GATE BAT DVDD pfet_06v0 ad=71.8771p pd=0.15481m as=58.1134p ps=77.985u w=76.465u l=1u
X8219 BAT GATE DVDD DVDD pfet_06v0 ad=58.1134p pd=77.985u as=58.1134p ps=77.985u w=76.465u l=1u
X8220 DVDD GATE BAT DVDD pfet_06v0 ad=49.3848p pd=66.5u as=49.3848p ps=66.5u w=64.98u l=1u
X8221 DVDD GATE BAT DVDD pfet_06v0 ad=47.6862p pd=64.265u as=47.6862p ps=64.265u w=62.745u l=1u
X8222 BAT GATE DVDD DVDD pfet_06v0 ad=58.1134p pd=77.985u as=58.1134p ps=77.985u w=76.465u l=1u
X8223 BAT GATE DVDD DVDD pfet_06v0 ad=58.1552p pd=78.04u as=58.1552p ps=78.04u w=76.52u l=1u
X8224 DVDD GATE BAT DVDD pfet_06v0 ad=43.9168p pd=95.32u as=35.5072p ps=48.24u w=46.72u l=1u
X8225 BAT GATE DVDD DVDD pfet_06v0 ad=58.1096p pd=77.98u as=58.1096p ps=77.98u w=76.46u l=1u
X8226 BAT GATE DVDD DVDD pfet_06v0 ad=47.6862p pd=64.265u as=47.6862p ps=64.265u w=62.745u l=1u
X8227 BAT GATE DVDD DVDD pfet_06v0 ad=58.1134p pd=77.985u as=58.1134p ps=77.985u w=76.465u l=1u
X8228 DVDD GATE BAT DVDD pfet_06v0 ad=49.3848p pd=66.5u as=49.3848p ps=66.5u w=64.98u l=1u
X8229 DVDD GATE BAT DVDD pfet_06v0 ad=35.511p pd=48.245u as=35.511p ps=48.245u w=46.725u l=1u
X8230 BAT GATE DVDD DVDD pfet_06v0 ad=58.1134p pd=77.985u as=58.1134p ps=77.985u w=76.465u l=1u
X8231 BAT GATE DVDD DVDD pfet_06v0 ad=58.1134p pd=77.985u as=58.1134p ps=77.985u w=76.465u l=1u
X8232 BAT GATE DVDD DVDD pfet_06v0 ad=49.3848p pd=66.5u as=49.3848p ps=66.5u w=64.98u l=1u
X8233 BAT GATE DVDD DVDD pfet_06v0 ad=35.511p pd=48.245u as=43.9215p ps=95.32999u w=46.725u l=1u
X8234 BAT GATE DVDD DVDD pfet_06v0 ad=58.1552p pd=78.04u as=71.92879p ps=0.15492m w=76.52u l=1u
X8235 BAT GATE DVDD DVDD pfet_06v0 ad=58.0754p pd=77.935u as=58.0754p ps=77.935u w=76.41499u l=1u
X8236 BAT GATE DVDD DVDD pfet_06v0 ad=35.511p pd=48.245u as=43.9215p ps=95.32999u w=46.725u l=1u
X8237 BAT GATE DVDD DVDD pfet_06v0 ad=58.0754p pd=77.935u as=71.8301p ps=0.15471m w=76.41499u l=1u
X8238 BAT GATE DVDD DVDD pfet_06v0 ad=58.1134p pd=77.985u as=58.1134p ps=77.985u w=76.465u l=1u
X8239 DVDD GATE BAT DVDD pfet_06v0 ad=35.511p pd=48.245u as=35.511p ps=48.245u w=46.725u l=1u
X8240 DVDD GATE BAT DVDD pfet_06v0 ad=35.511p pd=48.245u as=35.511p ps=48.245u w=46.725u l=1u
X8241 DVDD GATE BAT DVDD pfet_06v0 ad=35.511p pd=48.245u as=35.511p ps=48.245u w=46.725u l=1u
X8242 DVDD GATE BAT DVDD pfet_06v0 ad=58.1096p pd=77.98u as=58.1096p ps=77.98u w=76.46u l=1u
X8243 BAT GATE DVDD DVDD pfet_06v0 ad=58.0754p pd=77.935u as=58.0754p ps=77.935u w=76.41499u l=1u
X8244 DVDD GATE BAT DVDD pfet_06v0 ad=71.8771p pd=0.15481m as=58.1134p ps=77.985u w=76.465u l=1u
X8245 DVDD GATE BAT DVDD pfet_06v0 ad=71.8771p pd=0.15481m as=58.1134p ps=77.985u w=76.465u l=1u
X8246 BAT GATE DVDD DVDD pfet_06v0 ad=35.511p pd=48.245u as=43.9215p ps=95.32999u w=46.725u l=1u
X8247 DVDD GATE BAT DVDD pfet_06v0 ad=47.6862p pd=64.265u as=47.6862p ps=64.265u w=62.745u l=1u
X8248 DVDD GATE BAT DVDD pfet_06v0 ad=35.511p pd=48.245u as=35.511p ps=48.245u w=46.725u l=1u
X8249 BAT GATE DVDD DVDD pfet_06v0 ad=58.1134p pd=77.985u as=58.1134p ps=77.985u w=76.465u l=1u
X8250 BAT GATE DVDD DVDD pfet_06v0 ad=35.511p pd=48.245u as=43.9215p ps=95.32999u w=46.725u l=1u
X8251 DVDD GATE BAT DVDD pfet_06v0 ad=58.1134p pd=77.985u as=58.1134p ps=77.985u w=76.465u l=1u
X8252 BAT GATE DVDD DVDD pfet_06v0 ad=58.1172p pd=77.99u as=58.1172p ps=77.99u w=76.47u l=1u
X8253 DVDD GATE BAT DVDD pfet_06v0 ad=58.1134p pd=77.985u as=58.1134p ps=77.985u w=76.465u l=1u
X8254 DVDD GATE BAT DVDD pfet_06v0 ad=58.1134p pd=77.985u as=58.1134p ps=77.985u w=76.465u l=1u
X8255 BAT GATE DVDD DVDD pfet_06v0 ad=47.6862p pd=64.265u as=58.9803p ps=0.12737m w=62.745u l=1u
X8256 DVDD GATE BAT DVDD pfet_06v0 ad=35.5072p pd=48.24u as=35.5072p ps=48.24u w=46.72u l=1u
X8257 DVDD GATE BAT DVDD pfet_06v0 ad=58.1096p pd=77.98u as=58.1096p ps=77.98u w=76.46u l=1u
X8258 DVDD GATE BAT DVDD pfet_06v0 ad=35.511p pd=48.245u as=35.511p ps=48.245u w=46.725u l=1u
X8259 BAT GATE DVDD DVDD pfet_06v0 ad=58.1172p pd=77.99u as=58.1172p ps=77.99u w=76.47u l=1u
X8260 DVDD GATE BAT DVDD pfet_06v0 ad=43.9215p pd=95.32999u as=35.511p ps=48.245u w=46.725u l=1u
X8261 BAT GATE DVDD DVDD pfet_06v0 ad=35.511p pd=48.245u as=35.511p ps=48.245u w=46.725u l=1u
X8262 BAT GATE DVDD DVDD pfet_06v0 ad=35.511p pd=48.245u as=35.511p ps=48.245u w=46.725u l=1u
X8263 DVDD GATE BAT DVDD pfet_06v0 ad=58.1096p pd=77.98u as=58.1096p ps=77.98u w=76.46u l=1u
X8264 DVDD GATE BAT DVDD pfet_06v0 ad=61.0812p pd=0.13184m as=49.3848p ps=66.5u w=64.98u l=1u
X8265 DVDD GATE BAT DVDD pfet_06v0 ad=58.1552p pd=78.04u as=58.1552p ps=78.04u w=76.52u l=1u
X8266 DVDD GATE BAT DVDD pfet_06v0 ad=58.1134p pd=77.985u as=58.1134p ps=77.985u w=76.465u l=1u
X8267 BAT GATE DVDD DVDD pfet_06v0 ad=49.3848p pd=66.5u as=49.3848p ps=66.5u w=64.98u l=1u
X8268 BAT GATE DVDD DVDD pfet_06v0 ad=35.511p pd=48.245u as=35.511p ps=48.245u w=46.725u l=1u
X8269 DVDD GATE BAT DVDD pfet_06v0 ad=43.9215p pd=95.32999u as=35.511p ps=48.245u w=46.725u l=1u
X8270 DVDD GATE BAT DVDD pfet_06v0 ad=35.511p pd=48.245u as=35.511p ps=48.245u w=46.725u l=1u
X8271 DVDD GATE BAT DVDD pfet_06v0 ad=58.1134p pd=77.985u as=58.1134p ps=77.985u w=76.465u l=1u
X8272 BAT GATE DVDD DVDD pfet_06v0 ad=35.511p pd=48.245u as=35.511p ps=48.245u w=46.725u l=1u
X8273 BAT GATE DVDD DVDD pfet_06v0 ad=58.1134p pd=77.985u as=58.1134p ps=77.985u w=76.465u l=1u
X8274 BAT GATE DVDD DVDD pfet_06v0 ad=58.1134p pd=77.985u as=58.1134p ps=77.985u w=76.465u l=1u
X8275 BAT GATE DVDD DVDD pfet_06v0 ad=58.1134p pd=77.985u as=71.8771p ps=0.15481m w=76.465u l=1u
X8276 DVDD GATE BAT DVDD pfet_06v0 ad=58.0754p pd=77.935u as=58.0754p ps=77.935u w=76.41499u l=1u
X8277 DVDD GATE BAT DVDD pfet_06v0 ad=35.511p pd=48.245u as=35.511p ps=48.245u w=46.725u l=1u
X8278 BAT GATE DVDD DVDD pfet_06v0 ad=35.511p pd=48.245u as=35.511p ps=48.245u w=46.725u l=1u
X8279 BAT GATE DVDD DVDD pfet_06v0 ad=35.511p pd=48.245u as=35.511p ps=48.245u w=46.725u l=1u
X8280 BAT GATE DVDD DVDD pfet_06v0 ad=35.511p pd=48.245u as=35.511p ps=48.245u w=46.725u l=1u
X8281 BAT GATE DVDD DVDD pfet_06v0 ad=35.511p pd=48.245u as=35.511p ps=48.245u w=46.725u l=1u
X8282 DVDD GATE BAT DVDD pfet_06v0 ad=58.1172p pd=77.99u as=58.1172p ps=77.99u w=76.47u l=1u
X8283 BAT GATE DVDD DVDD pfet_06v0 ad=35.511p pd=48.245u as=35.511p ps=48.245u w=46.725u l=1u
X8284 BAT GATE DVDD DVDD pfet_06v0 ad=35.511p pd=48.245u as=43.9215p ps=95.32999u w=46.725u l=1u
X8285 DVDD GATE BAT DVDD pfet_06v0 ad=71.8771p pd=0.15481m as=58.1134p ps=77.985u w=76.465u l=1u
X8286 DVDD GATE BAT DVDD pfet_06v0 ad=35.511p pd=48.245u as=35.511p ps=48.245u w=46.725u l=1u
X8287 BAT GATE DVDD DVDD pfet_06v0 ad=47.6862p pd=64.265u as=47.6862p ps=64.265u w=62.745u l=1u
X8288 DVDD GATE BAT DVDD pfet_06v0 ad=35.511p pd=48.245u as=35.511p ps=48.245u w=46.725u l=1u
X8289 DVDD GATE BAT DVDD pfet_06v0 ad=35.511p pd=48.245u as=35.511p ps=48.245u w=46.725u l=1u
X8290 DVDD GATE BAT DVDD pfet_06v0 ad=58.1134p pd=77.985u as=58.1134p ps=77.985u w=76.465u l=1u
X8291 BAT GATE DVDD DVDD pfet_06v0 ad=35.511p pd=48.245u as=35.511p ps=48.245u w=46.725u l=1u
X8292 BAT GATE DVDD DVDD pfet_06v0 ad=35.511p pd=48.245u as=35.511p ps=48.245u w=46.725u l=1u
X8293 DVDD GATE BAT DVDD pfet_06v0 ad=58.1134p pd=77.985u as=58.1134p ps=77.985u w=76.465u l=1u
X8294 DVDD GATE BAT DVDD pfet_06v0 ad=35.511p pd=48.245u as=35.511p ps=48.245u w=46.725u l=1u
X8295 DVDD GATE BAT DVDD pfet_06v0 ad=35.511p pd=48.245u as=35.511p ps=48.245u w=46.725u l=1u
X8296 BAT GATE DVDD DVDD pfet_06v0 ad=58.1134p pd=77.985u as=58.1134p ps=77.985u w=76.465u l=1u
X8297 DVDD GATE BAT DVDD pfet_06v0 ad=35.511p pd=48.245u as=35.511p ps=48.245u w=46.725u l=1u
X8298 DVDD GATE BAT DVDD pfet_06v0 ad=58.1552p pd=78.04u as=58.1552p ps=78.04u w=76.52u l=1u
X8299 BAT GATE DVDD DVDD pfet_06v0 ad=58.1134p pd=77.985u as=58.1134p ps=77.985u w=76.465u l=1u
X8300 BAT GATE DVDD DVDD pfet_06v0 ad=58.1134p pd=77.985u as=58.1134p ps=77.985u w=76.465u l=1u
X8301 BAT GATE DVDD DVDD pfet_06v0 ad=35.511p pd=48.245u as=43.9215p ps=95.32999u w=46.725u l=1u
X8302 DVDD GATE BAT DVDD pfet_06v0 ad=35.511p pd=48.245u as=35.511p ps=48.245u w=46.725u l=1u
X8303 BAT GATE DVDD DVDD pfet_06v0 ad=35.511p pd=48.245u as=35.511p ps=48.245u w=46.725u l=1u
X8304 BAT GATE DVDD DVDD pfet_06v0 ad=58.1134p pd=77.985u as=58.1134p ps=77.985u w=76.465u l=1u
X8305 DVDD GATE BAT DVDD pfet_06v0 ad=71.8301p pd=0.15471m as=58.0754p ps=77.935u w=76.41499u l=1u
X8306 BAT GATE DVDD DVDD pfet_06v0 ad=58.1134p pd=77.985u as=58.1134p ps=77.985u w=76.465u l=1u
X8307 DVDD GATE BAT DVDD pfet_06v0 ad=58.1134p pd=77.985u as=58.1134p ps=77.985u w=76.465u l=1u
X8308 DVDD GATE BAT DVDD pfet_06v0 ad=35.511p pd=48.245u as=35.511p ps=48.245u w=46.725u l=1u
X8309 DVDD GATE BAT DVDD pfet_06v0 ad=35.511p pd=48.245u as=35.511p ps=48.245u w=46.725u l=1u
X8310 DVDD GATE BAT DVDD pfet_06v0 ad=58.1134p pd=77.985u as=58.1134p ps=77.985u w=76.465u l=1u
X8311 DVDD GATE BAT DVDD pfet_06v0 ad=71.92879p pd=0.15492m as=58.1552p ps=78.04u w=76.52u l=1u
X8312 DVDD GATE BAT DVDD pfet_06v0 ad=35.511p pd=48.245u as=35.511p ps=48.245u w=46.725u l=1u
X8313 BAT GATE DVDD DVDD pfet_06v0 ad=58.1134p pd=77.985u as=71.8771p ps=0.15481m w=76.465u l=1u
X8314 DVDD GATE BAT DVDD pfet_06v0 ad=58.1134p pd=77.985u as=58.1134p ps=77.985u w=76.465u l=1u
X8315 DVDD GATE BAT DVDD pfet_06v0 ad=35.511p pd=48.245u as=35.511p ps=48.245u w=46.725u l=1u
X8316 BAT GATE DVDD DVDD pfet_06v0 ad=35.511p pd=48.245u as=35.511p ps=48.245u w=46.725u l=1u
X8317 DVDD GATE BAT DVDD pfet_06v0 ad=58.1134p pd=77.985u as=58.1134p ps=77.985u w=76.465u l=1u
X8318 BAT GATE DVDD DVDD pfet_06v0 ad=58.1134p pd=77.985u as=58.1134p ps=77.985u w=76.465u l=1u
X8319 BAT GATE DVDD DVDD pfet_06v0 ad=35.511p pd=48.245u as=35.511p ps=48.245u w=46.725u l=1u
X8320 DVDD GATE BAT DVDD pfet_06v0 ad=58.1172p pd=77.99u as=58.1172p ps=77.99u w=76.47u l=1u
X8321 BAT GATE DVDD DVDD pfet_06v0 ad=58.1134p pd=77.985u as=58.1134p ps=77.985u w=76.465u l=1u
X8322 DVDD GATE BAT DVDD pfet_06v0 ad=35.511p pd=48.245u as=35.511p ps=48.245u w=46.725u l=1u
X8323 DVDD GATE BAT DVDD pfet_06v0 ad=58.1134p pd=77.985u as=58.1134p ps=77.985u w=76.465u l=1u
X8324 DVDD GATE BAT DVDD pfet_06v0 ad=35.511p pd=48.245u as=35.511p ps=48.245u w=46.725u l=1u
X8325 DVDD GATE BAT DVDD pfet_06v0 ad=58.1134p pd=77.985u as=58.1134p ps=77.985u w=76.465u l=1u
X8326 DVDD GATE BAT DVDD pfet_06v0 ad=35.511p pd=48.245u as=35.511p ps=48.245u w=46.725u l=1u
X8327 BAT GATE DVDD DVDD pfet_06v0 ad=58.1134p pd=77.985u as=58.1134p ps=77.985u w=76.465u l=1u
X8328 BAT GATE DVDD DVDD pfet_06v0 ad=49.3848p pd=66.5u as=49.3848p ps=66.5u w=64.98u l=1u
X8329 DVDD GATE BAT DVDD pfet_06v0 ad=35.5072p pd=48.24u as=35.5072p ps=48.24u w=46.72u l=1u
X8330 DVDD GATE BAT DVDD pfet_06v0 ad=71.8818p pd=0.15482m as=58.1172p ps=77.99u w=76.47u l=1u
X8331 BAT GATE DVDD DVDD pfet_06v0 ad=49.3848p pd=66.5u as=61.0812p ps=0.13184m w=64.98u l=1u
X8332 DVDD GATE BAT DVDD pfet_06v0 ad=47.6862p pd=64.265u as=47.6862p ps=64.265u w=62.745u l=1u
X8333 BAT GATE DVDD DVDD pfet_06v0 ad=35.511p pd=48.245u as=43.9215p ps=95.32999u w=46.725u l=1u
X8334 BAT GATE DVDD DVDD pfet_06v0 ad=58.0754p pd=77.935u as=58.0754p ps=77.935u w=76.41499u l=1u
X8335 BAT GATE DVDD DVDD pfet_06v0 ad=58.1134p pd=77.985u as=58.1134p ps=77.985u w=76.465u l=1u
X8336 DVDD GATE BAT DVDD pfet_06v0 ad=35.511p pd=48.245u as=35.511p ps=48.245u w=46.725u l=1u
X8337 DVDD GATE BAT DVDD pfet_06v0 ad=58.1134p pd=77.985u as=58.1134p ps=77.985u w=76.465u l=1u
X8338 DVDD GATE BAT DVDD pfet_06v0 ad=58.1096p pd=77.98u as=58.1096p ps=77.98u w=76.46u l=1u
X8339 DVDD GATE BAT DVDD pfet_06v0 ad=35.511p pd=48.245u as=35.511p ps=48.245u w=46.725u l=1u
X8340 DVDD GATE BAT DVDD pfet_06v0 ad=71.8771p pd=0.15481m as=58.1134p ps=77.985u w=76.465u l=1u
X8341 BAT GATE DVDD DVDD pfet_06v0 ad=35.511p pd=48.245u as=35.511p ps=48.245u w=46.725u l=1u
X8342 DVDD GATE BAT DVDD pfet_06v0 ad=58.1134p pd=77.985u as=58.1134p ps=77.985u w=76.465u l=1u
X8343 BAT GATE DVDD DVDD pfet_06v0 ad=35.511p pd=48.245u as=35.511p ps=48.245u w=46.725u l=1u
X8344 BAT GATE DVDD DVDD pfet_06v0 ad=58.1134p pd=77.985u as=71.8771p ps=0.15481m w=76.465u l=1u
X8345 BAT GATE DVDD DVDD pfet_06v0 ad=47.6862p pd=64.265u as=47.6862p ps=64.265u w=62.745u l=1u
X8346 BAT GATE DVDD DVDD pfet_06v0 ad=58.1134p pd=77.985u as=71.8771p ps=0.15481m w=76.465u l=1u
X8347 DVDD GATE BAT DVDD pfet_06v0 ad=58.1134p pd=77.985u as=58.1134p ps=77.985u w=76.465u l=1u
X8348 BAT GATE DVDD DVDD pfet_06v0 ad=35.511p pd=48.245u as=35.511p ps=48.245u w=46.725u l=1u
X8349 DVDD GATE BAT DVDD pfet_06v0 ad=35.511p pd=48.245u as=35.511p ps=48.245u w=46.725u l=1u
X8350 BAT GATE DVDD DVDD pfet_06v0 ad=58.1134p pd=77.985u as=58.1134p ps=77.985u w=76.465u l=1u
X8351 BAT GATE DVDD DVDD pfet_06v0 ad=58.1134p pd=77.985u as=58.1134p ps=77.985u w=76.465u l=1u
X8352 DVDD GATE BAT DVDD pfet_06v0 ad=35.511p pd=48.245u as=35.511p ps=48.245u w=46.725u l=1u
X8353 DVDD GATE BAT DVDD pfet_06v0 ad=58.0754p pd=77.935u as=58.0754p ps=77.935u w=76.41499u l=1u
X8354 DVDD GATE BAT DVDD pfet_06v0 ad=35.511p pd=48.245u as=35.511p ps=48.245u w=46.725u l=1u
X8355 BAT GATE DVDD DVDD pfet_06v0 ad=58.1096p pd=77.98u as=71.8724p ps=0.1548m w=76.46u l=1u
X8356 BAT GATE DVDD DVDD pfet_06v0 ad=58.1096p pd=77.98u as=58.1096p ps=77.98u w=76.46u l=1u
X8357 BAT GATE DVDD DVDD pfet_06v0 ad=35.511p pd=48.245u as=43.9215p ps=95.32999u w=46.725u l=1u
X8358 DVDD GATE BAT DVDD pfet_06v0 ad=58.1172p pd=77.99u as=58.1172p ps=77.99u w=76.47u l=1u
X8359 DVDD GATE BAT DVDD pfet_06v0 ad=71.8818p pd=0.15482m as=58.1172p ps=77.99u w=76.47u l=1u
X8360 DVDD GATE BAT DVDD pfet_06v0 ad=49.3848p pd=66.5u as=49.3848p ps=66.5u w=64.98u l=1u
X8361 BAT GATE DVDD DVDD pfet_06v0 ad=35.5072p pd=48.24u as=35.5072p ps=48.24u w=46.72u l=1u
X8362 DVDD GATE BAT DVDD pfet_06v0 ad=58.1172p pd=77.99u as=58.1172p ps=77.99u w=76.47u l=1u
X8363 BAT GATE DVDD DVDD pfet_06v0 ad=58.1134p pd=77.985u as=58.1134p ps=77.985u w=76.465u l=1u
X8364 BAT GATE DVDD DVDD pfet_06v0 ad=58.1134p pd=77.985u as=71.8771p ps=0.15481m w=76.465u l=1u
X8365 BAT GATE DVDD DVDD pfet_06v0 ad=58.1134p pd=77.985u as=58.1134p ps=77.985u w=76.465u l=1u
X8366 BAT GATE DVDD DVDD pfet_06v0 ad=35.511p pd=48.245u as=35.511p ps=48.245u w=46.725u l=1u
X8367 BAT GATE DVDD DVDD pfet_06v0 ad=35.511p pd=48.245u as=35.511p ps=48.245u w=46.725u l=1u
X8368 DVDD GATE BAT DVDD pfet_06v0 ad=71.8771p pd=0.15481m as=58.1134p ps=77.985u w=76.465u l=1u
X8369 BAT GATE DVDD DVDD pfet_06v0 ad=58.1172p pd=77.99u as=71.8818p ps=0.15482m w=76.47u l=1u
X8370 BAT GATE DVDD DVDD pfet_06v0 ad=58.1096p pd=77.98u as=58.1096p ps=77.98u w=76.46u l=1u
X8371 BAT GATE DVDD DVDD pfet_06v0 ad=58.0754p pd=77.935u as=58.0754p ps=77.935u w=76.41499u l=1u
X8372 BAT GATE DVDD DVDD pfet_06v0 ad=58.1552p pd=78.04u as=58.1552p ps=78.04u w=76.52u l=1u
X8373 BAT GATE DVDD DVDD pfet_06v0 ad=58.1096p pd=77.98u as=58.1096p ps=77.98u w=76.46u l=1u
X8374 BAT GATE DVDD DVDD pfet_06v0 ad=35.511p pd=48.245u as=35.511p ps=48.245u w=46.725u l=1u
X8375 DVDD GATE BAT DVDD pfet_06v0 ad=47.6862p pd=64.265u as=47.6862p ps=64.265u w=62.745u l=1u
X8376 BAT GATE DVDD DVDD pfet_06v0 ad=58.1134p pd=77.985u as=58.1134p ps=77.985u w=76.465u l=1u
X8377 DVDD GATE BAT DVDD pfet_06v0 ad=71.92879p pd=0.15492m as=58.1552p ps=78.04u w=76.52u l=1u
X8378 BAT GATE DVDD DVDD pfet_06v0 ad=35.511p pd=48.245u as=43.9215p ps=95.32999u w=46.725u l=1u
X8379 DVDD GATE BAT DVDD pfet_06v0 ad=58.1134p pd=77.985u as=58.1134p ps=77.985u w=76.465u l=1u
X8380 DVDD GATE BAT DVDD pfet_06v0 ad=58.1134p pd=77.985u as=58.1134p ps=77.985u w=76.465u l=1u
X8381 DVDD GATE BAT DVDD pfet_06v0 ad=58.1552p pd=78.04u as=58.1552p ps=78.04u w=76.52u l=1u
X8382 BAT GATE DVDD DVDD pfet_06v0 ad=35.511p pd=48.245u as=35.511p ps=48.245u w=46.725u l=1u
X8383 BAT GATE DVDD DVDD pfet_06v0 ad=35.5072p pd=48.24u as=35.5072p ps=48.24u w=46.72u l=1u
X8384 BAT GATE DVDD DVDD pfet_06v0 ad=58.1134p pd=77.985u as=58.1134p ps=77.985u w=76.465u l=1u
X8385 BAT GATE DVDD DVDD pfet_06v0 ad=58.1134p pd=77.985u as=58.1134p ps=77.985u w=76.465u l=1u
X8386 BAT GATE DVDD DVDD pfet_06v0 ad=58.1552p pd=78.04u as=58.1552p ps=78.04u w=76.52u l=1u
X8387 BAT GATE DVDD DVDD pfet_06v0 ad=58.1134p pd=77.985u as=58.1134p ps=77.985u w=76.465u l=1u
X8388 BAT GATE DVDD DVDD pfet_06v0 ad=58.1172p pd=77.99u as=58.1172p ps=77.99u w=76.47u l=1u
X8389 DVDD GATE BAT DVDD pfet_06v0 ad=35.511p pd=48.245u as=35.511p ps=48.245u w=46.725u l=1u
X8390 DVDD GATE BAT DVDD pfet_06v0 ad=49.3848p pd=66.5u as=49.3848p ps=66.5u w=64.98u l=1u
X8391 BAT GATE DVDD DVDD pfet_06v0 ad=35.511p pd=48.245u as=35.511p ps=48.245u w=46.725u l=1u
X8392 BAT GATE DVDD DVDD pfet_06v0 ad=58.1134p pd=77.985u as=71.8771p ps=0.15481m w=76.465u l=1u
X8393 DVDD GATE BAT DVDD pfet_06v0 ad=58.1134p pd=77.985u as=58.1134p ps=77.985u w=76.465u l=1u
X8394 BAT GATE DVDD DVDD pfet_06v0 ad=35.511p pd=48.245u as=43.9215p ps=95.32999u w=46.725u l=1u
X8395 DVDD GATE BAT DVDD pfet_06v0 ad=71.92879p pd=0.15492m as=58.1552p ps=78.04u w=76.52u l=1u
X8396 BAT GATE DVDD DVDD pfet_06v0 ad=58.1096p pd=77.98u as=58.1096p ps=77.98u w=76.46u l=1u
X8397 DVDD GATE BAT DVDD pfet_06v0 ad=35.511p pd=48.245u as=35.511p ps=48.245u w=46.725u l=1u
X8398 BAT GATE DVDD DVDD pfet_06v0 ad=35.511p pd=48.245u as=35.511p ps=48.245u w=46.725u l=1u
X8399 BAT GATE DVDD DVDD pfet_06v0 ad=58.1552p pd=78.04u as=58.1552p ps=78.04u w=76.52u l=1u
X8400 DVDD GATE BAT DVDD pfet_06v0 ad=58.1134p pd=77.985u as=58.1134p ps=77.985u w=76.465u l=1u
X8401 DVDD GATE BAT DVDD pfet_06v0 ad=35.5072p pd=48.24u as=35.5072p ps=48.24u w=46.72u l=1u
X8402 DVDD GATE BAT DVDD pfet_06v0 ad=58.1134p pd=77.985u as=58.1134p ps=77.985u w=76.465u l=1u
X8403 DVDD GATE BAT DVDD pfet_06v0 ad=43.9168p pd=95.32u as=35.5072p ps=48.24u w=46.72u l=1u
X8404 BAT GATE DVDD DVDD pfet_06v0 ad=58.1134p pd=77.985u as=58.1134p ps=77.985u w=76.465u l=1u
X8405 BAT GATE DVDD DVDD pfet_06v0 ad=35.511p pd=48.245u as=35.511p ps=48.245u w=46.725u l=1u
X8406 BAT GATE DVDD DVDD pfet_06v0 ad=35.511p pd=48.245u as=35.511p ps=48.245u w=46.725u l=1u
X8407 BAT GATE DVDD DVDD pfet_06v0 ad=58.1134p pd=77.985u as=58.1134p ps=77.985u w=76.465u l=1u
X8408 BAT GATE DVDD DVDD pfet_06v0 ad=35.511p pd=48.245u as=35.511p ps=48.245u w=46.725u l=1u
X8409 DVDD GATE BAT DVDD pfet_06v0 ad=35.511p pd=48.245u as=35.511p ps=48.245u w=46.725u l=1u
X8410 BAT GATE DVDD DVDD pfet_06v0 ad=49.3848p pd=66.5u as=49.3848p ps=66.5u w=64.98u l=1u
X8411 BAT GATE DVDD DVDD pfet_06v0 ad=35.511p pd=48.245u as=35.511p ps=48.245u w=46.725u l=1u
X8412 DVDD GATE BAT DVDD pfet_06v0 ad=43.9215p pd=95.32999u as=35.511p ps=48.245u w=46.725u l=1u
X8413 BAT GATE DVDD DVDD pfet_06v0 ad=58.1552p pd=78.04u as=58.1552p ps=78.04u w=76.52u l=1u
X8414 BAT GATE DVDD DVDD pfet_06v0 ad=35.511p pd=48.245u as=35.511p ps=48.245u w=46.725u l=1u
X8415 DVDD GATE BAT DVDD pfet_06v0 ad=58.1134p pd=77.985u as=58.1134p ps=77.985u w=76.465u l=1u
X8416 DVDD GATE BAT DVDD pfet_06v0 ad=58.1134p pd=77.985u as=58.1134p ps=77.985u w=76.465u l=1u
X8417 DVDD GATE BAT DVDD pfet_06v0 ad=35.511p pd=48.245u as=35.511p ps=48.245u w=46.725u l=1u
X8418 DVDD GATE BAT DVDD pfet_06v0 ad=35.511p pd=48.245u as=35.511p ps=48.245u w=46.725u l=1u
X8419 DVDD GATE BAT DVDD pfet_06v0 ad=43.9215p pd=95.32999u as=35.511p ps=48.245u w=46.725u l=1u
X8420 BAT GATE DVDD DVDD pfet_06v0 ad=58.1134p pd=77.985u as=58.1134p ps=77.985u w=76.465u l=1u
X8421 BAT GATE DVDD DVDD pfet_06v0 ad=35.511p pd=48.245u as=35.511p ps=48.245u w=46.725u l=1u
X8422 BAT GATE DVDD DVDD pfet_06v0 ad=35.511p pd=48.245u as=43.9215p ps=95.32999u w=46.725u l=1u
X8423 DVDD GATE BAT DVDD pfet_06v0 ad=49.3848p pd=66.5u as=49.3848p ps=66.5u w=64.98u l=1u
X8424 DVDD GATE BAT DVDD pfet_06v0 ad=35.511p pd=48.245u as=35.511p ps=48.245u w=46.725u l=1u
X8425 DVDD GATE BAT DVDD pfet_06v0 ad=58.1134p pd=77.985u as=58.1134p ps=77.985u w=76.465u l=1u
X8426 BAT GATE DVDD DVDD pfet_06v0 ad=58.1134p pd=77.985u as=58.1134p ps=77.985u w=76.465u l=1u
X8427 DVDD GATE BAT DVDD pfet_06v0 ad=35.511p pd=48.245u as=35.511p ps=48.245u w=46.725u l=1u
X8428 BAT GATE DVDD DVDD pfet_06v0 ad=35.511p pd=48.245u as=35.511p ps=48.245u w=46.725u l=1u
X8429 DVDD GATE BAT DVDD pfet_06v0 ad=71.8724p pd=0.1548m as=58.1096p ps=77.98u w=76.46u l=1u
X8430 DVDD GATE BAT DVDD pfet_06v0 ad=35.511p pd=48.245u as=35.511p ps=48.245u w=46.725u l=1u
X8431 BAT GATE DVDD DVDD pfet_06v0 ad=35.511p pd=48.245u as=43.9215p ps=95.32999u w=46.725u l=1u
X8432 DVDD GATE BAT DVDD pfet_06v0 ad=71.8724p pd=0.1548m as=58.1096p ps=77.98u w=76.46u l=1u
X8433 BAT GATE DVDD DVDD pfet_06v0 ad=35.511p pd=48.245u as=35.511p ps=48.245u w=46.725u l=1u
X8434 DVDD GATE BAT DVDD pfet_06v0 ad=49.3848p pd=66.5u as=49.3848p ps=66.5u w=64.98u l=1u
X8435 DVDD GATE BAT DVDD pfet_06v0 ad=58.1134p pd=77.985u as=58.1134p ps=77.985u w=76.465u l=1u
X8436 BAT GATE DVDD DVDD pfet_06v0 ad=58.1134p pd=77.985u as=71.8771p ps=0.15481m w=76.465u l=1u
X8437 BAT GATE DVDD DVDD pfet_06v0 ad=47.6862p pd=64.265u as=47.6862p ps=64.265u w=62.745u l=1u
X8438 DVDD GATE BAT DVDD pfet_06v0 ad=58.1134p pd=77.985u as=58.1134p ps=77.985u w=76.465u l=1u
X8439 BAT GATE DVDD DVDD pfet_06v0 ad=58.1134p pd=77.985u as=58.1134p ps=77.985u w=76.465u l=1u
X8440 BAT GATE DVDD DVDD pfet_06v0 ad=35.511p pd=48.245u as=35.511p ps=48.245u w=46.725u l=1u
X8441 DVDD GATE BAT DVDD pfet_06v0 ad=58.0754p pd=77.935u as=58.0754p ps=77.935u w=76.41499u l=1u
X8442 BAT GATE DVDD DVDD pfet_06v0 ad=35.511p pd=48.245u as=35.511p ps=48.245u w=46.725u l=1u
X8443 DVDD GATE BAT DVDD pfet_06v0 ad=43.9168p pd=95.32u as=35.5072p ps=48.24u w=46.72u l=1u
X8444 DVDD GATE BAT DVDD pfet_06v0 ad=71.8771p pd=0.15481m as=58.1134p ps=77.985u w=76.465u l=1u
X8445 DVDD GATE BAT DVDD pfet_06v0 ad=71.8301p pd=0.15471m as=58.0754p ps=77.935u w=76.41499u l=1u
X8446 BAT GATE DVDD DVDD pfet_06v0 ad=58.1134p pd=77.985u as=58.1134p ps=77.985u w=76.465u l=1u
X8447 BAT GATE DVDD DVDD pfet_06v0 ad=35.511p pd=48.245u as=35.511p ps=48.245u w=46.725u l=1u
X8448 DVDD GATE BAT DVDD pfet_06v0 ad=43.9168p pd=95.32u as=35.5072p ps=48.24u w=46.72u l=1u
X8449 BAT GATE DVDD DVDD pfet_06v0 ad=58.1134p pd=77.985u as=58.1134p ps=77.985u w=76.465u l=1u
X8450 DVDD GATE BAT DVDD pfet_06v0 ad=71.8724p pd=0.1548m as=58.1096p ps=77.98u w=76.46u l=1u
X8451 BAT GATE DVDD DVDD pfet_06v0 ad=58.1134p pd=77.985u as=58.1134p ps=77.985u w=76.465u l=1u
X8452 BAT GATE DVDD DVDD pfet_06v0 ad=47.6862p pd=64.265u as=47.6862p ps=64.265u w=62.745u l=1u
X8453 DVDD GATE BAT DVDD pfet_06v0 ad=35.511p pd=48.245u as=35.511p ps=48.245u w=46.725u l=1u
X8454 DVDD GATE BAT DVDD pfet_06v0 ad=43.9215p pd=95.32999u as=35.511p ps=48.245u w=46.725u l=1u
X8455 DVDD GATE BAT DVDD pfet_06v0 ad=47.6862p pd=64.265u as=47.6862p ps=64.265u w=62.745u l=1u
X8456 BAT GATE DVDD DVDD pfet_06v0 ad=58.1134p pd=77.985u as=58.1134p ps=77.985u w=76.465u l=1u
X8457 DVDD GATE BAT DVDD pfet_06v0 ad=43.9215p pd=95.32999u as=35.511p ps=48.245u w=46.725u l=1u
X8458 DVDD GATE BAT DVDD pfet_06v0 ad=43.9168p pd=95.32u as=35.5072p ps=48.24u w=46.72u l=1u
X8459 BAT GATE DVDD DVDD pfet_06v0 ad=35.511p pd=48.245u as=35.511p ps=48.245u w=46.725u l=1u
X8460 DVDD GATE BAT DVDD pfet_06v0 ad=71.8818p pd=0.15482m as=58.1172p ps=77.99u w=76.47u l=1u
X8461 BAT GATE DVDD DVDD pfet_06v0 ad=35.511p pd=48.245u as=35.511p ps=48.245u w=46.725u l=1u
X8462 DVDD GATE BAT DVDD pfet_06v0 ad=58.1134p pd=77.985u as=58.1134p ps=77.985u w=76.465u l=1u
X8463 DVDD GATE BAT DVDD pfet_06v0 ad=58.1134p pd=77.985u as=58.1134p ps=77.985u w=76.465u l=1u
X8464 BAT GATE DVDD DVDD pfet_06v0 ad=49.3848p pd=66.5u as=49.3848p ps=66.5u w=64.98u l=1u
X8465 BAT GATE DVDD DVDD pfet_06v0 ad=49.3848p pd=66.5u as=49.3848p ps=66.5u w=64.98u l=1u
X8466 BAT GATE DVDD DVDD pfet_06v0 ad=58.1172p pd=77.99u as=58.1172p ps=77.99u w=76.47u l=1u
X8467 BAT GATE DVDD DVDD pfet_06v0 ad=35.511p pd=48.245u as=35.511p ps=48.245u w=46.725u l=1u
X8468 DVDD GATE BAT DVDD pfet_06v0 ad=58.1134p pd=77.985u as=58.1134p ps=77.985u w=76.465u l=1u
X8469 BAT GATE DVDD DVDD pfet_06v0 ad=49.3848p pd=66.5u as=49.3848p ps=66.5u w=64.98u l=1u
X8470 BAT GATE DVDD DVDD pfet_06v0 ad=58.1134p pd=77.985u as=58.1134p ps=77.985u w=76.465u l=1u
X8471 BAT GATE DVDD DVDD pfet_06v0 ad=35.511p pd=48.245u as=35.511p ps=48.245u w=46.725u l=1u
X8472 BAT GATE DVDD DVDD pfet_06v0 ad=35.511p pd=48.245u as=35.511p ps=48.245u w=46.725u l=1u
X8473 DVDD GATE BAT DVDD pfet_06v0 ad=35.5072p pd=48.24u as=35.5072p ps=48.24u w=46.72u l=1u
X8474 BAT GATE DVDD DVDD pfet_06v0 ad=35.511p pd=48.245u as=35.511p ps=48.245u w=46.725u l=1u
X8475 DVDD GATE BAT DVDD pfet_06v0 ad=35.511p pd=48.245u as=35.511p ps=48.245u w=46.725u l=1u
X8476 BAT GATE DVDD DVDD pfet_06v0 ad=35.5072p pd=48.24u as=35.5072p ps=48.24u w=46.72u l=1u
X8477 BAT GATE DVDD DVDD pfet_06v0 ad=35.511p pd=48.245u as=35.511p ps=48.245u w=46.725u l=1u
X8478 BAT GATE DVDD DVDD pfet_06v0 ad=58.1134p pd=77.985u as=58.1134p ps=77.985u w=76.465u l=1u
X8479 BAT GATE DVDD DVDD pfet_06v0 ad=58.1134p pd=77.985u as=58.1134p ps=77.985u w=76.465u l=1u
X8480 DVDD GATE BAT DVDD pfet_06v0 ad=58.1134p pd=77.985u as=58.1134p ps=77.985u w=76.465u l=1u
X8481 BAT GATE DVDD DVDD pfet_06v0 ad=35.511p pd=48.245u as=35.511p ps=48.245u w=46.725u l=1u
X8482 DVDD GATE BAT DVDD pfet_06v0 ad=58.1134p pd=77.985u as=58.1134p ps=77.985u w=76.465u l=1u
X8483 DVDD GATE BAT DVDD pfet_06v0 ad=58.1134p pd=77.985u as=58.1134p ps=77.985u w=76.465u l=1u
X8484 DVDD GATE BAT DVDD pfet_06v0 ad=35.511p pd=48.245u as=35.511p ps=48.245u w=46.725u l=1u
X8485 DVDD GATE BAT DVDD pfet_06v0 ad=35.511p pd=48.245u as=35.511p ps=48.245u w=46.725u l=1u
X8486 BAT GATE DVDD DVDD pfet_06v0 ad=58.1134p pd=77.985u as=58.1134p ps=77.985u w=76.465u l=1u
X8487 BAT GATE DVDD DVDD pfet_06v0 ad=58.1134p pd=77.985u as=58.1134p ps=77.985u w=76.465u l=1u
X8488 DVDD GATE BAT DVDD pfet_06v0 ad=43.9215p pd=95.32999u as=35.511p ps=48.245u w=46.725u l=1u
X8489 DVDD GATE BAT DVDD pfet_06v0 ad=43.9215p pd=95.32999u as=35.511p ps=48.245u w=46.725u l=1u
X8490 BAT GATE DVDD DVDD pfet_06v0 ad=47.6862p pd=64.265u as=47.6862p ps=64.265u w=62.745u l=1u
X8491 BAT GATE DVDD DVDD pfet_06v0 ad=58.1552p pd=78.04u as=58.1552p ps=78.04u w=76.52u l=1u
X8492 DVDD GATE BAT DVDD pfet_06v0 ad=43.9215p pd=95.32999u as=35.511p ps=48.245u w=46.725u l=1u
X8493 DVDD GATE BAT DVDD pfet_06v0 ad=35.511p pd=48.245u as=35.511p ps=48.245u w=46.725u l=1u
X8494 DVDD GATE BAT DVDD pfet_06v0 ad=35.511p pd=48.245u as=35.511p ps=48.245u w=46.725u l=1u
X8495 BAT GATE DVDD DVDD pfet_06v0 ad=49.3848p pd=66.5u as=49.3848p ps=66.5u w=64.98u l=1u
X8496 BAT GATE DVDD DVDD pfet_06v0 ad=49.3848p pd=66.5u as=49.3848p ps=66.5u w=64.98u l=1u
X8497 BAT GATE DVDD DVDD pfet_06v0 ad=58.1134p pd=77.985u as=58.1134p ps=77.985u w=76.465u l=1u
X8498 DVDD GATE BAT DVDD pfet_06v0 ad=58.1134p pd=77.985u as=58.1134p ps=77.985u w=76.465u l=1u
X8499 BAT GATE DVDD DVDD pfet_06v0 ad=58.1552p pd=78.04u as=71.92879p ps=0.15492m w=76.52u l=1u
X8500 DVDD GATE BAT DVDD pfet_06v0 ad=58.1134p pd=77.985u as=58.1134p ps=77.985u w=76.465u l=1u
X8501 BAT GATE DVDD DVDD pfet_06v0 ad=35.511p pd=48.245u as=35.511p ps=48.245u w=46.725u l=1u
X8502 DVDD GATE BAT DVDD pfet_06v0 ad=35.511p pd=48.245u as=35.511p ps=48.245u w=46.725u l=1u
X8503 BAT GATE DVDD DVDD pfet_06v0 ad=35.511p pd=48.245u as=35.511p ps=48.245u w=46.725u l=1u
X8504 BAT GATE DVDD DVDD pfet_06v0 ad=35.511p pd=48.245u as=35.511p ps=48.245u w=46.725u l=1u
X8505 DVDD GATE BAT DVDD pfet_06v0 ad=35.511p pd=48.245u as=35.511p ps=48.245u w=46.725u l=1u
X8506 DVDD GATE BAT DVDD pfet_06v0 ad=35.511p pd=48.245u as=35.511p ps=48.245u w=46.725u l=1u
X8507 DVDD GATE BAT DVDD pfet_06v0 ad=71.8771p pd=0.15481m as=58.1134p ps=77.985u w=76.465u l=1u
X8508 DVDD GATE BAT DVDD pfet_06v0 ad=58.1134p pd=77.985u as=58.1134p ps=77.985u w=76.465u l=1u
X8509 BAT GATE DVDD DVDD pfet_06v0 ad=58.0754p pd=77.935u as=58.0754p ps=77.935u w=76.41499u l=1u
X8510 DVDD GATE BAT DVDD pfet_06v0 ad=35.511p pd=48.245u as=35.511p ps=48.245u w=46.725u l=1u
X8511 DVDD GATE BAT DVDD pfet_06v0 ad=35.511p pd=48.245u as=35.511p ps=48.245u w=46.725u l=1u
X8512 BAT GATE DVDD DVDD pfet_06v0 ad=58.1134p pd=77.985u as=58.1134p ps=77.985u w=76.465u l=1u
X8513 DVDD GATE BAT DVDD pfet_06v0 ad=35.511p pd=48.245u as=35.511p ps=48.245u w=46.725u l=1u
X8514 DVDD GATE BAT DVDD pfet_06v0 ad=35.511p pd=48.245u as=35.511p ps=48.245u w=46.725u l=1u
X8515 DVDD GATE BAT DVDD pfet_06v0 ad=35.511p pd=48.245u as=35.511p ps=48.245u w=46.725u l=1u
X8516 DVDD GATE BAT DVDD pfet_06v0 ad=35.511p pd=48.245u as=35.511p ps=48.245u w=46.725u l=1u
X8517 DVDD GATE BAT DVDD pfet_06v0 ad=58.1134p pd=77.985u as=58.1134p ps=77.985u w=76.465u l=1u
X8518 DVDD GATE BAT DVDD pfet_06v0 ad=35.511p pd=48.245u as=35.511p ps=48.245u w=46.725u l=1u
X8519 BAT GATE DVDD DVDD pfet_06v0 ad=58.1134p pd=77.985u as=58.1134p ps=77.985u w=76.465u l=1u
X8520 DVDD GATE BAT DVDD pfet_06v0 ad=35.511p pd=48.245u as=35.511p ps=48.245u w=46.725u l=1u
X8521 BAT GATE DVDD DVDD pfet_06v0 ad=35.511p pd=48.245u as=35.511p ps=48.245u w=46.725u l=1u
X8522 BAT GATE DVDD DVDD pfet_06v0 ad=35.511p pd=48.245u as=35.511p ps=48.245u w=46.725u l=1u
X8523 BAT GATE DVDD DVDD pfet_06v0 ad=35.511p pd=48.245u as=35.511p ps=48.245u w=46.725u l=1u
X8524 BAT GATE DVDD DVDD pfet_06v0 ad=58.1134p pd=77.985u as=58.1134p ps=77.985u w=76.465u l=1u
X8525 DVDD GATE BAT DVDD pfet_06v0 ad=35.511p pd=48.245u as=35.511p ps=48.245u w=46.725u l=1u
X8526 BAT GATE DVDD DVDD pfet_06v0 ad=58.1134p pd=77.985u as=58.1134p ps=77.985u w=76.465u l=1u
X8527 DVDD GATE BAT DVDD pfet_06v0 ad=43.9215p pd=95.32999u as=35.511p ps=48.245u w=46.725u l=1u
X8528 BAT GATE DVDD DVDD pfet_06v0 ad=47.6862p pd=64.265u as=47.6862p ps=64.265u w=62.745u l=1u
X8529 BAT GATE DVDD DVDD pfet_06v0 ad=58.1134p pd=77.985u as=58.1134p ps=77.985u w=76.465u l=1u
X8530 DVDD GATE BAT DVDD pfet_06v0 ad=58.1096p pd=77.98u as=58.1096p ps=77.98u w=76.46u l=1u
X8531 BAT GATE DVDD DVDD pfet_06v0 ad=35.511p pd=48.245u as=35.511p ps=48.245u w=46.725u l=1u
X8532 DVDD GATE BAT DVDD pfet_06v0 ad=58.1134p pd=77.985u as=58.1134p ps=77.985u w=76.465u l=1u
X8533 DVDD GATE BAT DVDD pfet_06v0 ad=35.511p pd=48.245u as=35.511p ps=48.245u w=46.725u l=1u
X8534 DVDD GATE BAT DVDD pfet_06v0 ad=58.1552p pd=78.04u as=58.1552p ps=78.04u w=76.52u l=1u
X8535 BAT GATE DVDD DVDD pfet_06v0 ad=49.3848p pd=66.5u as=49.3848p ps=66.5u w=64.98u l=1u
X8536 BAT GATE DVDD DVDD pfet_06v0 ad=58.1552p pd=78.04u as=71.92879p ps=0.15492m w=76.52u l=1u
X8537 DVDD GATE BAT DVDD pfet_06v0 ad=58.1134p pd=77.985u as=58.1134p ps=77.985u w=76.465u l=1u
X8538 DVDD GATE BAT DVDD pfet_06v0 ad=43.9215p pd=95.32999u as=35.511p ps=48.245u w=46.725u l=1u
X8539 BAT GATE DVDD DVDD pfet_06v0 ad=35.511p pd=48.245u as=35.511p ps=48.245u w=46.725u l=1u
X8540 BAT GATE DVDD DVDD pfet_06v0 ad=35.511p pd=48.245u as=35.511p ps=48.245u w=46.725u l=1u
X8541 DVDD GATE BAT DVDD pfet_06v0 ad=43.9215p pd=95.32999u as=35.511p ps=48.245u w=46.725u l=1u
X8542 BAT GATE DVDD DVDD pfet_06v0 ad=58.1134p pd=77.985u as=58.1134p ps=77.985u w=76.465u l=1u
X8543 DVDD GATE BAT DVDD pfet_06v0 ad=58.1134p pd=77.985u as=58.1134p ps=77.985u w=76.465u l=1u
X8544 BAT GATE DVDD DVDD pfet_06v0 ad=58.1096p pd=77.98u as=58.1096p ps=77.98u w=76.46u l=1u
X8545 DVDD GATE BAT DVDD pfet_06v0 ad=35.511p pd=48.245u as=35.511p ps=48.245u w=46.725u l=1u
X8546 BAT GATE DVDD DVDD pfet_06v0 ad=35.511p pd=48.245u as=35.511p ps=48.245u w=46.725u l=1u
X8547 DVDD GATE BAT DVDD pfet_06v0 ad=58.9803p pd=0.12737m as=47.6862p ps=64.265u w=62.745u l=1u
X8548 BAT GATE DVDD DVDD pfet_06v0 ad=35.511p pd=48.245u as=43.9215p ps=95.32999u w=46.725u l=1u
X8549 BAT GATE DVDD DVDD pfet_06v0 ad=35.5072p pd=48.24u as=35.5072p ps=48.24u w=46.72u l=1u
X8550 DVDD GATE BAT DVDD pfet_06v0 ad=35.511p pd=48.245u as=35.511p ps=48.245u w=46.725u l=1u
X8551 BAT GATE DVDD DVDD pfet_06v0 ad=35.511p pd=48.245u as=35.511p ps=48.245u w=46.725u l=1u
X8552 BAT GATE DVDD DVDD pfet_06v0 ad=58.1134p pd=77.985u as=58.1134p ps=77.985u w=76.465u l=1u
X8553 BAT GATE DVDD DVDD pfet_06v0 ad=35.5072p pd=48.24u as=35.5072p ps=48.24u w=46.72u l=1u
X8554 DVDD GATE BAT DVDD pfet_06v0 ad=71.8724p pd=0.1548m as=58.1096p ps=77.98u w=76.46u l=1u
X8555 DVDD GATE BAT DVDD pfet_06v0 ad=58.1134p pd=77.985u as=58.1134p ps=77.985u w=76.465u l=1u
X8556 DVDD GATE BAT DVDD pfet_06v0 ad=58.1134p pd=77.985u as=58.1134p ps=77.985u w=76.465u l=1u
X8557 BAT GATE DVDD DVDD pfet_06v0 ad=58.1134p pd=77.985u as=58.1134p ps=77.985u w=76.465u l=1u
X8558 BAT GATE DVDD DVDD pfet_06v0 ad=58.0754p pd=77.935u as=58.0754p ps=77.935u w=76.41499u l=1u
X8559 DVDD GATE BAT DVDD pfet_06v0 ad=35.511p pd=48.245u as=35.511p ps=48.245u w=46.725u l=1u
X8560 BAT GATE DVDD DVDD pfet_06v0 ad=58.1096p pd=77.98u as=58.1096p ps=77.98u w=76.46u l=1u
X8561 BAT GATE DVDD DVDD pfet_06v0 ad=58.1134p pd=77.985u as=71.8771p ps=0.15481m w=76.465u l=1u
X8562 BAT GATE DVDD DVDD pfet_06v0 ad=49.3848p pd=66.5u as=61.0812p ps=0.13184m w=64.98u l=1u
X8563 DVDD GATE BAT DVDD pfet_06v0 ad=71.8771p pd=0.15481m as=58.1134p ps=77.985u w=76.465u l=1u
X8564 DVDD GATE BAT DVDD pfet_06v0 ad=35.511p pd=48.245u as=35.511p ps=48.245u w=46.725u l=1u
X8565 DVDD GATE BAT DVDD pfet_06v0 ad=43.9168p pd=95.32u as=35.5072p ps=48.24u w=46.72u l=1u
X8566 DVDD GATE BAT DVDD pfet_06v0 ad=35.511p pd=48.245u as=35.511p ps=48.245u w=46.725u l=1u
X8567 BAT GATE DVDD DVDD pfet_06v0 ad=35.511p pd=48.245u as=35.511p ps=48.245u w=46.725u l=1u
X8568 BAT GATE DVDD DVDD pfet_06v0 ad=35.5072p pd=48.24u as=35.5072p ps=48.24u w=46.72u l=1u
X8569 BAT GATE DVDD DVDD pfet_06v0 ad=58.1096p pd=77.98u as=58.1096p ps=77.98u w=76.46u l=1u
X8570 BAT GATE DVDD DVDD pfet_06v0 ad=47.6862p pd=64.265u as=47.6862p ps=64.265u w=62.745u l=1u
X8571 BAT GATE DVDD DVDD pfet_06v0 ad=58.1134p pd=77.985u as=58.1134p ps=77.985u w=76.465u l=1u
X8572 DVDD GATE BAT DVDD pfet_06v0 ad=35.5072p pd=48.24u as=35.5072p ps=48.24u w=46.72u l=1u
X8573 DVDD GATE BAT DVDD pfet_06v0 ad=49.3848p pd=66.5u as=49.3848p ps=66.5u w=64.98u l=1u
X8574 BAT GATE DVDD DVDD pfet_06v0 ad=58.1134p pd=77.985u as=58.1134p ps=77.985u w=76.465u l=1u
X8575 DVDD GATE BAT DVDD pfet_06v0 ad=58.1552p pd=78.04u as=58.1552p ps=78.04u w=76.52u l=1u
X8576 BAT GATE DVDD DVDD pfet_06v0 ad=58.1134p pd=77.985u as=58.1134p ps=77.985u w=76.465u l=1u
X8577 DVDD GATE BAT DVDD pfet_06v0 ad=35.511p pd=48.245u as=35.511p ps=48.245u w=46.725u l=1u
X8578 BAT GATE DVDD DVDD pfet_06v0 ad=58.1134p pd=77.985u as=71.8771p ps=0.15481m w=76.465u l=1u
X8579 DVDD GATE BAT DVDD pfet_06v0 ad=58.0754p pd=77.935u as=58.0754p ps=77.935u w=76.41499u l=1u
X8580 DVDD GATE BAT DVDD pfet_06v0 ad=35.511p pd=48.245u as=35.511p ps=48.245u w=46.725u l=1u
X8581 BAT GATE DVDD DVDD pfet_06v0 ad=35.511p pd=48.245u as=35.511p ps=48.245u w=46.725u l=1u
X8582 BAT GATE DVDD DVDD pfet_06v0 ad=35.511p pd=48.245u as=35.511p ps=48.245u w=46.725u l=1u
X8583 BAT GATE DVDD DVDD pfet_06v0 ad=58.1134p pd=77.985u as=58.1134p ps=77.985u w=76.465u l=1u
X8584 DVDD GATE BAT DVDD pfet_06v0 ad=35.511p pd=48.245u as=35.511p ps=48.245u w=46.725u l=1u
X8585 DVDD GATE BAT DVDD pfet_06v0 ad=71.8301p pd=0.15471m as=58.0754p ps=77.935u w=76.41499u l=1u
X8586 BAT GATE DVDD DVDD pfet_06v0 ad=47.6862p pd=64.265u as=47.6862p ps=64.265u w=62.745u l=1u
X8587 DVDD GATE BAT DVDD pfet_06v0 ad=35.511p pd=48.245u as=35.511p ps=48.245u w=46.725u l=1u
X8588 DVDD GATE BAT DVDD pfet_06v0 ad=35.511p pd=48.245u as=35.511p ps=48.245u w=46.725u l=1u
X8589 BAT GATE DVDD DVDD pfet_06v0 ad=35.511p pd=48.245u as=35.511p ps=48.245u w=46.725u l=1u
X8590 DVDD GATE BAT DVDD pfet_06v0 ad=35.5072p pd=48.24u as=35.5072p ps=48.24u w=46.72u l=1u
X8591 BAT GATE DVDD DVDD pfet_06v0 ad=58.0754p pd=77.935u as=58.0754p ps=77.935u w=76.41499u l=1u
X8592 DVDD GATE BAT DVDD pfet_06v0 ad=35.511p pd=48.245u as=35.511p ps=48.245u w=46.725u l=1u
X8593 DVDD GATE BAT DVDD pfet_06v0 ad=43.9215p pd=95.32999u as=35.511p ps=48.245u w=46.725u l=1u
X8594 DVDD GATE BAT DVDD pfet_06v0 ad=35.511p pd=48.245u as=35.511p ps=48.245u w=46.725u l=1u
X8595 DVDD GATE BAT DVDD pfet_06v0 ad=47.6862p pd=64.265u as=47.6862p ps=64.265u w=62.745u l=1u
X8596 DVDD GATE BAT DVDD pfet_06v0 ad=71.8771p pd=0.15481m as=58.1134p ps=77.985u w=76.465u l=1u
X8597 BAT GATE DVDD DVDD pfet_06v0 ad=35.511p pd=48.245u as=43.9215p ps=95.32999u w=46.725u l=1u
X8598 DVDD GATE BAT DVDD pfet_06v0 ad=71.8771p pd=0.15481m as=58.1134p ps=77.985u w=76.465u l=1u
X8599 DVDD GATE BAT DVDD pfet_06v0 ad=71.8771p pd=0.15481m as=58.1134p ps=77.985u w=76.465u l=1u
X8600 DVDD GATE BAT DVDD pfet_06v0 ad=71.8771p pd=0.15481m as=58.1134p ps=77.985u w=76.465u l=1u
X8601 BAT GATE DVDD DVDD pfet_06v0 ad=35.511p pd=48.245u as=35.511p ps=48.245u w=46.725u l=1u
X8602 DVDD GATE BAT DVDD pfet_06v0 ad=35.511p pd=48.245u as=35.511p ps=48.245u w=46.725u l=1u
X8603 BAT GATE DVDD DVDD pfet_06v0 ad=58.1172p pd=77.99u as=58.1172p ps=77.99u w=76.47u l=1u
X8604 DVDD GATE BAT DVDD pfet_06v0 ad=35.511p pd=48.245u as=35.511p ps=48.245u w=46.725u l=1u
X8605 BAT GATE DVDD DVDD pfet_06v0 ad=35.511p pd=48.245u as=43.9215p ps=95.32999u w=46.725u l=1u
X8606 BAT GATE DVDD DVDD pfet_06v0 ad=58.1134p pd=77.985u as=58.1134p ps=77.985u w=76.465u l=1u
X8607 BAT GATE DVDD DVDD pfet_06v0 ad=35.511p pd=48.245u as=35.511p ps=48.245u w=46.725u l=1u
X8608 BAT GATE DVDD DVDD pfet_06v0 ad=35.511p pd=48.245u as=35.511p ps=48.245u w=46.725u l=1u
X8609 DVDD GATE BAT DVDD pfet_06v0 ad=49.3848p pd=66.5u as=49.3848p ps=66.5u w=64.98u l=1u
X8610 DVDD GATE BAT DVDD pfet_06v0 ad=58.1096p pd=77.98u as=58.1096p ps=77.98u w=76.46u l=1u
X8611 DVDD GATE BAT DVDD pfet_06v0 ad=58.1552p pd=78.04u as=58.1552p ps=78.04u w=76.52u l=1u
X8612 DVDD GATE BAT DVDD pfet_06v0 ad=71.8724p pd=0.1548m as=58.1096p ps=77.98u w=76.46u l=1u
X8613 DVDD GATE BAT DVDD pfet_06v0 ad=58.1134p pd=77.985u as=58.1134p ps=77.985u w=76.465u l=1u
X8614 BAT GATE DVDD DVDD pfet_06v0 ad=47.6862p pd=64.265u as=58.9803p ps=0.12737m w=62.745u l=1u
X8615 BAT GATE DVDD DVDD pfet_06v0 ad=35.511p pd=48.245u as=35.511p ps=48.245u w=46.725u l=1u
X8616 DVDD GATE BAT DVDD pfet_06v0 ad=35.511p pd=48.245u as=35.511p ps=48.245u w=46.725u l=1u
X8617 DVDD GATE BAT DVDD pfet_06v0 ad=35.511p pd=48.245u as=35.511p ps=48.245u w=46.725u l=1u
X8618 DVDD GATE BAT DVDD pfet_06v0 ad=58.1134p pd=77.985u as=58.1134p ps=77.985u w=76.465u l=1u
X8619 DVDD GATE BAT DVDD pfet_06v0 ad=71.8771p pd=0.15481m as=58.1134p ps=77.985u w=76.465u l=1u
X8620 BAT GATE DVDD DVDD pfet_06v0 ad=35.511p pd=48.245u as=35.511p ps=48.245u w=46.725u l=1u
X8621 BAT GATE DVDD DVDD pfet_06v0 ad=58.1134p pd=77.985u as=58.1134p ps=77.985u w=76.465u l=1u
X8622 DVDD GATE BAT DVDD pfet_06v0 ad=58.1134p pd=77.985u as=58.1134p ps=77.985u w=76.465u l=1u
X8623 DVDD GATE BAT DVDD pfet_06v0 ad=35.511p pd=48.245u as=35.511p ps=48.245u w=46.725u l=1u
X8624 BAT GATE DVDD DVDD pfet_06v0 ad=58.1134p pd=77.985u as=58.1134p ps=77.985u w=76.465u l=1u
X8625 BAT GATE DVDD DVDD pfet_06v0 ad=58.1134p pd=77.985u as=71.8771p ps=0.15481m w=76.465u l=1u
X8626 DVDD GATE BAT DVDD pfet_06v0 ad=58.0754p pd=77.935u as=58.0754p ps=77.935u w=76.41499u l=1u
X8627 BAT GATE DVDD DVDD pfet_06v0 ad=35.511p pd=48.245u as=43.9215p ps=95.32999u w=46.725u l=1u
X8628 BAT GATE DVDD DVDD pfet_06v0 ad=58.1134p pd=77.985u as=71.8771p ps=0.15481m w=76.465u l=1u
X8629 BAT GATE DVDD DVDD pfet_06v0 ad=35.511p pd=48.245u as=35.511p ps=48.245u w=46.725u l=1u
X8630 BAT GATE DVDD DVDD pfet_06v0 ad=35.511p pd=48.245u as=35.511p ps=48.245u w=46.725u l=1u
X8631 BAT GATE DVDD DVDD pfet_06v0 ad=35.511p pd=48.245u as=35.511p ps=48.245u w=46.725u l=1u
X8632 BAT GATE DVDD DVDD pfet_06v0 ad=35.511p pd=48.245u as=35.511p ps=48.245u w=46.725u l=1u
X8633 DVDD GATE BAT DVDD pfet_06v0 ad=58.1172p pd=77.99u as=58.1172p ps=77.99u w=76.47u l=1u
X8634 DVDD GATE BAT DVDD pfet_06v0 ad=58.1134p pd=77.985u as=58.1134p ps=77.985u w=76.465u l=1u
X8635 DVDD GATE BAT DVDD pfet_06v0 ad=58.1552p pd=78.04u as=58.1552p ps=78.04u w=76.52u l=1u
X8636 BAT GATE DVDD DVDD pfet_06v0 ad=35.511p pd=48.245u as=35.511p ps=48.245u w=46.725u l=1u
X8637 DVDD GATE BAT DVDD pfet_06v0 ad=35.511p pd=48.245u as=35.511p ps=48.245u w=46.725u l=1u
X8638 DVDD GATE BAT DVDD pfet_06v0 ad=58.1134p pd=77.985u as=58.1134p ps=77.985u w=76.465u l=1u
X8639 BAT GATE DVDD DVDD pfet_06v0 ad=47.6862p pd=64.265u as=47.6862p ps=64.265u w=62.745u l=1u
X8640 DVDD GATE BAT DVDD pfet_06v0 ad=58.1134p pd=77.985u as=58.1134p ps=77.985u w=76.465u l=1u
X8641 BAT GATE DVDD DVDD pfet_06v0 ad=58.1552p pd=78.04u as=58.1552p ps=78.04u w=76.52u l=1u
X8642 BAT GATE DVDD DVDD pfet_06v0 ad=35.511p pd=48.245u as=35.511p ps=48.245u w=46.725u l=1u
X8643 BAT GATE DVDD DVDD pfet_06v0 ad=35.511p pd=48.245u as=35.511p ps=48.245u w=46.725u l=1u
X8644 DVDD GATE BAT DVDD pfet_06v0 ad=58.1134p pd=77.985u as=58.1134p ps=77.985u w=76.465u l=1u
X8645 DVDD GATE BAT DVDD pfet_06v0 ad=35.511p pd=48.245u as=35.511p ps=48.245u w=46.725u l=1u
X8646 BAT GATE DVDD DVDD pfet_06v0 ad=58.1134p pd=77.985u as=58.1134p ps=77.985u w=76.465u l=1u
X8647 DVDD GATE BAT DVDD pfet_06v0 ad=71.8724p pd=0.1548m as=58.1096p ps=77.98u w=76.46u l=1u
X8648 DVDD GATE BAT DVDD pfet_06v0 ad=58.1134p pd=77.985u as=58.1134p ps=77.985u w=76.465u l=1u
X8649 BAT GATE DVDD DVDD pfet_06v0 ad=35.511p pd=48.245u as=35.511p ps=48.245u w=46.725u l=1u
X8650 BAT GATE DVDD DVDD pfet_06v0 ad=58.1134p pd=77.985u as=58.1134p ps=77.985u w=76.465u l=1u
X8651 DVDD GATE BAT DVDD pfet_06v0 ad=35.511p pd=48.245u as=35.511p ps=48.245u w=46.725u l=1u
X8652 DVDD GATE BAT DVDD pfet_06v0 ad=35.511p pd=48.245u as=35.511p ps=48.245u w=46.725u l=1u
X8653 BAT GATE DVDD DVDD pfet_06v0 ad=58.1134p pd=77.985u as=58.1134p ps=77.985u w=76.465u l=1u
X8654 DVDD GATE BAT DVDD pfet_06v0 ad=58.0754p pd=77.935u as=58.0754p ps=77.935u w=76.41499u l=1u
X8655 BAT GATE DVDD DVDD pfet_06v0 ad=35.511p pd=48.245u as=35.511p ps=48.245u w=46.725u l=1u
X8656 DVDD GATE BAT DVDD pfet_06v0 ad=61.0812p pd=0.13184m as=49.3848p ps=66.5u w=64.98u l=1u
X8657 DVDD GATE BAT DVDD pfet_06v0 ad=35.511p pd=48.245u as=35.511p ps=48.245u w=46.725u l=1u
X8658 DVDD GATE BAT DVDD pfet_06v0 ad=58.1134p pd=77.985u as=58.1134p ps=77.985u w=76.465u l=1u
X8659 DVDD GATE BAT DVDD pfet_06v0 ad=58.1552p pd=78.04u as=58.1552p ps=78.04u w=76.52u l=1u
X8660 DVDD GATE BAT DVDD pfet_06v0 ad=58.1552p pd=78.04u as=58.1552p ps=78.04u w=76.52u l=1u
X8661 DVDD GATE BAT DVDD pfet_06v0 ad=71.8771p pd=0.15481m as=58.1134p ps=77.985u w=76.465u l=1u
X8662 DVDD GATE BAT DVDD pfet_06v0 ad=35.511p pd=48.245u as=35.511p ps=48.245u w=46.725u l=1u
X8663 DVDD GATE BAT DVDD pfet_06v0 ad=58.0754p pd=77.935u as=58.0754p ps=77.935u w=76.41499u l=1u
X8664 BAT GATE DVDD DVDD pfet_06v0 ad=47.6862p pd=64.265u as=47.6862p ps=64.265u w=62.745u l=1u
X8665 BAT GATE DVDD DVDD pfet_06v0 ad=35.511p pd=48.245u as=35.511p ps=48.245u w=46.725u l=1u
X8666 DVDD GATE BAT DVDD pfet_06v0 ad=58.1134p pd=77.985u as=58.1134p ps=77.985u w=76.465u l=1u
X8667 BAT GATE DVDD DVDD pfet_06v0 ad=35.511p pd=48.245u as=35.511p ps=48.245u w=46.725u l=1u
X8668 BAT GATE DVDD DVDD pfet_06v0 ad=35.511p pd=48.245u as=35.511p ps=48.245u w=46.725u l=1u
X8669 DVDD GATE BAT DVDD pfet_06v0 ad=58.1134p pd=77.985u as=58.1134p ps=77.985u w=76.465u l=1u
X8670 BAT GATE DVDD DVDD pfet_06v0 ad=58.1134p pd=77.985u as=58.1134p ps=77.985u w=76.465u l=1u
X8671 BAT GATE DVDD DVDD pfet_06v0 ad=58.1096p pd=77.98u as=58.1096p ps=77.98u w=76.46u l=1u
X8672 BAT GATE DVDD DVDD pfet_06v0 ad=58.1134p pd=77.985u as=58.1134p ps=77.985u w=76.465u l=1u
X8673 BAT GATE DVDD DVDD pfet_06v0 ad=35.511p pd=48.245u as=35.511p ps=48.245u w=46.725u l=1u
X8674 DVDD GATE BAT DVDD pfet_06v0 ad=58.1134p pd=77.985u as=58.1134p ps=77.985u w=76.465u l=1u
X8675 DVDD GATE BAT DVDD pfet_06v0 ad=35.511p pd=48.245u as=35.511p ps=48.245u w=46.725u l=1u
X8676 BAT GATE DVDD DVDD pfet_06v0 ad=58.1134p pd=77.985u as=71.8771p ps=0.15481m w=76.465u l=1u
X8677 DVDD GATE BAT DVDD pfet_06v0 ad=35.511p pd=48.245u as=35.511p ps=48.245u w=46.725u l=1u
X8678 BAT GATE DVDD DVDD pfet_06v0 ad=58.1134p pd=77.985u as=58.1134p ps=77.985u w=76.465u l=1u
X8679 BAT GATE DVDD DVDD pfet_06v0 ad=49.3848p pd=66.5u as=61.0812p ps=0.13184m w=64.98u l=1u
X8680 DVDD GATE BAT DVDD pfet_06v0 ad=43.9215p pd=95.32999u as=35.511p ps=48.245u w=46.725u l=1u
X8681 BAT GATE DVDD DVDD pfet_06v0 ad=58.1134p pd=77.985u as=58.1134p ps=77.985u w=76.465u l=1u
X8682 DVDD GATE BAT DVDD pfet_06v0 ad=47.6862p pd=64.265u as=47.6862p ps=64.265u w=62.745u l=1u
X8683 BAT GATE DVDD DVDD pfet_06v0 ad=35.5072p pd=48.24u as=35.5072p ps=48.24u w=46.72u l=1u
X8684 BAT GATE DVDD DVDD pfet_06v0 ad=58.1134p pd=77.985u as=71.8771p ps=0.15481m w=76.465u l=1u
X8685 DVDD GATE BAT DVDD pfet_06v0 ad=71.8818p pd=0.15482m as=58.1172p ps=77.99u w=76.47u l=1u
X8686 BAT GATE DVDD DVDD pfet_06v0 ad=58.0754p pd=77.935u as=58.0754p ps=77.935u w=76.41499u l=1u
X8687 DVDD GATE BAT DVDD pfet_06v0 ad=35.511p pd=48.245u as=35.511p ps=48.245u w=46.725u l=1u
X8688 BAT GATE DVDD DVDD pfet_06v0 ad=58.1134p pd=77.985u as=58.1134p ps=77.985u w=76.465u l=1u
X8689 DVDD GATE BAT DVDD pfet_06v0 ad=35.511p pd=48.245u as=35.511p ps=48.245u w=46.725u l=1u
X8690 DVDD GATE BAT DVDD pfet_06v0 ad=58.1096p pd=77.98u as=58.1096p ps=77.98u w=76.46u l=1u
X8691 DVDD GATE BAT DVDD pfet_06v0 ad=58.1134p pd=77.985u as=58.1134p ps=77.985u w=76.465u l=1u
X8692 DVDD GATE BAT DVDD pfet_06v0 ad=35.511p pd=48.245u as=35.511p ps=48.245u w=46.725u l=1u
X8693 BAT GATE DVDD DVDD pfet_06v0 ad=58.1096p pd=77.98u as=58.1096p ps=77.98u w=76.46u l=1u
X8694 BAT GATE DVDD DVDD pfet_06v0 ad=49.3848p pd=66.5u as=61.0812p ps=0.13184m w=64.98u l=1u
X8695 DVDD GATE BAT DVDD pfet_06v0 ad=58.1134p pd=77.985u as=58.1134p ps=77.985u w=76.465u l=1u
X8696 BAT GATE DVDD DVDD pfet_06v0 ad=35.511p pd=48.245u as=43.9215p ps=95.32999u w=46.725u l=1u
X8697 BAT GATE DVDD DVDD pfet_06v0 ad=35.5072p pd=48.24u as=35.5072p ps=48.24u w=46.72u l=1u
X8698 BAT GATE DVDD DVDD pfet_06v0 ad=35.511p pd=48.245u as=35.511p ps=48.245u w=46.725u l=1u
X8699 DVDD GATE BAT DVDD pfet_06v0 ad=58.1134p pd=77.985u as=58.1134p ps=77.985u w=76.465u l=1u
X8700 DVDD GATE BAT DVDD pfet_06v0 ad=43.9215p pd=95.32999u as=35.511p ps=48.245u w=46.725u l=1u
X8701 BAT GATE DVDD DVDD pfet_06v0 ad=35.511p pd=48.245u as=35.511p ps=48.245u w=46.725u l=1u
X8702 DVDD GATE BAT DVDD pfet_06v0 ad=43.9215p pd=95.32999u as=35.511p ps=48.245u w=46.725u l=1u
X8703 BAT GATE DVDD DVDD pfet_06v0 ad=47.6862p pd=64.265u as=47.6862p ps=64.265u w=62.745u l=1u
X8704 DVDD GATE BAT DVDD pfet_06v0 ad=58.1134p pd=77.985u as=58.1134p ps=77.985u w=76.465u l=1u
X8705 BAT GATE DVDD DVDD pfet_06v0 ad=35.511p pd=48.245u as=35.511p ps=48.245u w=46.725u l=1u
X8706 BAT GATE DVDD DVDD pfet_06v0 ad=58.0754p pd=77.935u as=58.0754p ps=77.935u w=76.41499u l=1u
X8707 DVDD GATE BAT DVDD pfet_06v0 ad=47.6862p pd=64.265u as=47.6862p ps=64.265u w=62.745u l=1u
X8708 DVDD GATE BAT DVDD pfet_06v0 ad=58.1134p pd=77.985u as=58.1134p ps=77.985u w=76.465u l=1u
X8709 BAT GATE DVDD DVDD pfet_06v0 ad=58.1134p pd=77.985u as=71.8771p ps=0.15481m w=76.465u l=1u
X8710 DVDD GATE BAT DVDD pfet_06v0 ad=35.511p pd=48.245u as=35.511p ps=48.245u w=46.725u l=1u
X8711 DVDD GATE BAT DVDD pfet_06v0 ad=35.511p pd=48.245u as=35.511p ps=48.245u w=46.725u l=1u
X8712 BAT GATE DVDD DVDD pfet_06v0 ad=58.1172p pd=77.99u as=58.1172p ps=77.99u w=76.47u l=1u
X8713 DVDD GATE BAT DVDD pfet_06v0 ad=58.0754p pd=77.935u as=58.0754p ps=77.935u w=76.41499u l=1u
X8714 DVDD GATE BAT DVDD pfet_06v0 ad=71.92879p pd=0.15492m as=58.1552p ps=78.04u w=76.52u l=1u
X8715 BAT GATE DVDD DVDD pfet_06v0 ad=35.511p pd=48.245u as=43.9215p ps=95.32999u w=46.725u l=1u
X8716 DVDD GATE BAT DVDD pfet_06v0 ad=35.511p pd=48.245u as=35.511p ps=48.245u w=46.725u l=1u
X8717 BAT GATE DVDD DVDD pfet_06v0 ad=35.511p pd=48.245u as=35.511p ps=48.245u w=46.725u l=1u
X8718 DVDD GATE BAT DVDD pfet_06v0 ad=58.9803p pd=0.12737m as=47.6862p ps=64.265u w=62.745u l=1u
X8719 DVDD GATE BAT DVDD pfet_06v0 ad=71.8771p pd=0.15481m as=58.1134p ps=77.985u w=76.465u l=1u
X8720 DVDD GATE BAT DVDD pfet_06v0 ad=58.1172p pd=77.99u as=58.1172p ps=77.99u w=76.47u l=1u
X8721 DVDD GATE BAT DVDD pfet_06v0 ad=58.1134p pd=77.985u as=58.1134p ps=77.985u w=76.465u l=1u
X8722 DVDD GATE BAT DVDD pfet_06v0 ad=58.1172p pd=77.99u as=58.1172p ps=77.99u w=76.47u l=1u
X8723 DVDD GATE BAT DVDD pfet_06v0 ad=35.511p pd=48.245u as=35.511p ps=48.245u w=46.725u l=1u
X8724 BAT GATE DVDD DVDD pfet_06v0 ad=47.6862p pd=64.265u as=47.6862p ps=64.265u w=62.745u l=1u
X8725 BAT GATE DVDD DVDD pfet_06v0 ad=58.1134p pd=77.985u as=58.1134p ps=77.985u w=76.465u l=1u
X8726 BAT GATE DVDD DVDD pfet_06v0 ad=58.1134p pd=77.985u as=58.1134p ps=77.985u w=76.465u l=1u
X8727 DVDD GATE BAT DVDD pfet_06v0 ad=49.3848p pd=66.5u as=49.3848p ps=66.5u w=64.98u l=1u
X8728 BAT GATE DVDD DVDD pfet_06v0 ad=58.1134p pd=77.985u as=58.1134p ps=77.985u w=76.465u l=1u
X8729 BAT GATE DVDD DVDD pfet_06v0 ad=35.511p pd=48.245u as=35.511p ps=48.245u w=46.725u l=1u
X8730 BAT GATE DVDD DVDD pfet_06v0 ad=35.5072p pd=48.24u as=35.5072p ps=48.24u w=46.72u l=1u
X8731 BAT GATE DVDD DVDD pfet_06v0 ad=58.1134p pd=77.985u as=58.1134p ps=77.985u w=76.465u l=1u
X8732 DVDD GATE BAT DVDD pfet_06v0 ad=58.1134p pd=77.985u as=58.1134p ps=77.985u w=76.465u l=1u
X8733 BAT GATE DVDD DVDD pfet_06v0 ad=35.511p pd=48.245u as=43.9215p ps=95.32999u w=46.725u l=1u
X8734 BAT GATE DVDD DVDD pfet_06v0 ad=35.511p pd=48.245u as=35.511p ps=48.245u w=46.725u l=1u
X8735 DVDD GATE BAT DVDD pfet_06v0 ad=58.1134p pd=77.985u as=58.1134p ps=77.985u w=76.465u l=1u
X8736 BAT GATE DVDD DVDD pfet_06v0 ad=58.0754p pd=77.935u as=71.8301p ps=0.15471m w=76.41499u l=1u
X8737 BAT GATE DVDD DVDD pfet_06v0 ad=58.1552p pd=78.04u as=58.1552p ps=78.04u w=76.52u l=1u
X8738 BAT GATE DVDD DVDD pfet_06v0 ad=58.1096p pd=77.98u as=58.1096p ps=77.98u w=76.46u l=1u
X8739 BAT GATE DVDD DVDD pfet_06v0 ad=35.511p pd=48.245u as=35.511p ps=48.245u w=46.725u l=1u
X8740 BAT GATE DVDD DVDD pfet_06v0 ad=35.511p pd=48.245u as=35.511p ps=48.245u w=46.725u l=1u
X8741 BAT GATE DVDD DVDD pfet_06v0 ad=58.1134p pd=77.985u as=58.1134p ps=77.985u w=76.465u l=1u
X8742 DVDD GATE BAT DVDD pfet_06v0 ad=43.9168p pd=95.32u as=35.5072p ps=48.24u w=46.72u l=1u
X8743 BAT GATE DVDD DVDD pfet_06v0 ad=35.511p pd=48.245u as=35.511p ps=48.245u w=46.725u l=1u
X8744 BAT GATE DVDD DVDD pfet_06v0 ad=35.511p pd=48.245u as=35.511p ps=48.245u w=46.725u l=1u
X8745 DVDD GATE BAT DVDD pfet_06v0 ad=35.511p pd=48.245u as=35.511p ps=48.245u w=46.725u l=1u
X8746 DVDD GATE BAT DVDD pfet_06v0 ad=35.511p pd=48.245u as=35.511p ps=48.245u w=46.725u l=1u
X8747 DVDD GATE BAT DVDD pfet_06v0 ad=58.1552p pd=78.04u as=58.1552p ps=78.04u w=76.52u l=1u
X8748 DVDD GATE BAT DVDD pfet_06v0 ad=58.1134p pd=77.985u as=58.1134p ps=77.985u w=76.465u l=1u
X8749 BAT GATE DVDD DVDD pfet_06v0 ad=58.1134p pd=77.985u as=71.8771p ps=0.15481m w=76.465u l=1u
X8750 BAT GATE DVDD DVDD pfet_06v0 ad=58.1552p pd=78.04u as=71.92879p ps=0.15492m w=76.52u l=1u
X8751 BAT GATE DVDD DVDD pfet_06v0 ad=35.5072p pd=48.24u as=35.5072p ps=48.24u w=46.72u l=1u
X8752 BAT GATE DVDD DVDD pfet_06v0 ad=58.1134p pd=77.985u as=58.1134p ps=77.985u w=76.465u l=1u
X8753 BAT GATE DVDD DVDD pfet_06v0 ad=58.1172p pd=77.99u as=58.1172p ps=77.99u w=76.47u l=1u
X8754 DVDD GATE BAT DVDD pfet_06v0 ad=35.511p pd=48.245u as=35.511p ps=48.245u w=46.725u l=1u
X8755 BAT GATE DVDD DVDD pfet_06v0 ad=58.1134p pd=77.985u as=58.1134p ps=77.985u w=76.465u l=1u
X8756 BAT GATE DVDD DVDD pfet_06v0 ad=35.511p pd=48.245u as=35.511p ps=48.245u w=46.725u l=1u
X8757 BAT GATE DVDD DVDD pfet_06v0 ad=35.511p pd=48.245u as=35.511p ps=48.245u w=46.725u l=1u
X8758 BAT GATE DVDD DVDD pfet_06v0 ad=35.511p pd=48.245u as=35.511p ps=48.245u w=46.725u l=1u
X8759 DVDD GATE BAT DVDD pfet_06v0 ad=58.1134p pd=77.985u as=58.1134p ps=77.985u w=76.465u l=1u
X8760 BAT GATE DVDD DVDD pfet_06v0 ad=58.1134p pd=77.985u as=58.1134p ps=77.985u w=76.465u l=1u
X8761 BAT GATE DVDD DVDD pfet_06v0 ad=58.1096p pd=77.98u as=58.1096p ps=77.98u w=76.46u l=1u
X8762 DVDD GATE BAT DVDD pfet_06v0 ad=49.3848p pd=66.5u as=49.3848p ps=66.5u w=64.98u l=1u
X8763 BAT GATE DVDD DVDD pfet_06v0 ad=58.1552p pd=78.04u as=58.1552p ps=78.04u w=76.52u l=1u
X8764 BAT GATE DVDD DVDD pfet_06v0 ad=58.1134p pd=77.985u as=58.1134p ps=77.985u w=76.465u l=1u
X8765 DVDD GATE BAT DVDD pfet_06v0 ad=58.0754p pd=77.935u as=58.0754p ps=77.935u w=76.41499u l=1u
X8766 DVDD GATE BAT DVDD pfet_06v0 ad=58.1134p pd=77.985u as=58.1134p ps=77.985u w=76.465u l=1u
X8767 BAT GATE DVDD DVDD pfet_06v0 ad=58.1096p pd=77.98u as=58.1096p ps=77.98u w=76.46u l=1u
X8768 BAT GATE DVDD DVDD pfet_06v0 ad=35.511p pd=48.245u as=35.511p ps=48.245u w=46.725u l=1u
X8769 BAT GATE DVDD DVDD pfet_06v0 ad=58.1134p pd=77.985u as=58.1134p ps=77.985u w=76.465u l=1u
X8770 BAT GATE DVDD DVDD pfet_06v0 ad=58.1096p pd=77.98u as=58.1096p ps=77.98u w=76.46u l=1u
X8771 BAT GATE DVDD DVDD pfet_06v0 ad=35.511p pd=48.245u as=35.511p ps=48.245u w=46.725u l=1u
X8772 DVDD GATE BAT DVDD pfet_06v0 ad=35.511p pd=48.245u as=35.511p ps=48.245u w=46.725u l=1u
X8773 BAT GATE DVDD DVDD pfet_06v0 ad=58.1134p pd=77.985u as=71.8771p ps=0.15481m w=76.465u l=1u
X8774 BAT GATE DVDD DVDD pfet_06v0 ad=49.3848p pd=66.5u as=49.3848p ps=66.5u w=64.98u l=1u
X8775 BAT GATE DVDD DVDD pfet_06v0 ad=35.511p pd=48.245u as=35.511p ps=48.245u w=46.725u l=1u
X8776 DVDD GATE BAT DVDD pfet_06v0 ad=35.511p pd=48.245u as=35.511p ps=48.245u w=46.725u l=1u
X8777 BAT GATE DVDD DVDD pfet_06v0 ad=58.1552p pd=78.04u as=58.1552p ps=78.04u w=76.52u l=1u
X8778 BAT GATE DVDD DVDD pfet_06v0 ad=35.511p pd=48.245u as=35.511p ps=48.245u w=46.725u l=1u
X8779 BAT GATE DVDD DVDD pfet_06v0 ad=58.1552p pd=78.04u as=58.1552p ps=78.04u w=76.52u l=1u
X8780 DVDD GATE BAT DVDD pfet_06v0 ad=47.6862p pd=64.265u as=47.6862p ps=64.265u w=62.745u l=1u
X8781 DVDD GATE BAT DVDD pfet_06v0 ad=58.1134p pd=77.985u as=58.1134p ps=77.985u w=76.465u l=1u
X8782 DVDD GATE BAT DVDD pfet_06v0 ad=58.1172p pd=77.99u as=58.1172p ps=77.99u w=76.47u l=1u
X8783 DVDD GATE BAT DVDD pfet_06v0 ad=58.1134p pd=77.985u as=58.1134p ps=77.985u w=76.465u l=1u
X8784 DVDD GATE BAT DVDD pfet_06v0 ad=35.511p pd=48.245u as=35.511p ps=48.245u w=46.725u l=1u
X8785 DVDD GATE BAT DVDD pfet_06v0 ad=35.511p pd=48.245u as=35.511p ps=48.245u w=46.725u l=1u
X8786 BAT GATE DVDD DVDD pfet_06v0 ad=35.511p pd=48.245u as=35.511p ps=48.245u w=46.725u l=1u
X8787 BAT GATE DVDD DVDD pfet_06v0 ad=35.5072p pd=48.24u as=35.5072p ps=48.24u w=46.72u l=1u
X8788 DVDD GATE BAT DVDD pfet_06v0 ad=58.1134p pd=77.985u as=58.1134p ps=77.985u w=76.465u l=1u
X8789 DVDD GATE BAT DVDD pfet_06v0 ad=35.511p pd=48.245u as=35.511p ps=48.245u w=46.725u l=1u
X8790 DVDD GATE BAT DVDD pfet_06v0 ad=58.1134p pd=77.985u as=58.1134p ps=77.985u w=76.465u l=1u
X8791 DVDD GATE BAT DVDD pfet_06v0 ad=49.3848p pd=66.5u as=49.3848p ps=66.5u w=64.98u l=1u
X8792 BAT GATE DVDD DVDD pfet_06v0 ad=58.1134p pd=77.985u as=71.8771p ps=0.15481m w=76.465u l=1u
X8793 BAT GATE DVDD DVDD pfet_06v0 ad=35.511p pd=48.245u as=35.511p ps=48.245u w=46.725u l=1u
X8794 BAT GATE DVDD DVDD pfet_06v0 ad=35.511p pd=48.245u as=35.511p ps=48.245u w=46.725u l=1u
X8795 DVDD GATE BAT DVDD pfet_06v0 ad=35.511p pd=48.245u as=35.511p ps=48.245u w=46.725u l=1u
X8796 DVDD GATE BAT DVDD pfet_06v0 ad=58.1096p pd=77.98u as=58.1096p ps=77.98u w=76.46u l=1u
X8797 DVDD GATE BAT DVDD pfet_06v0 ad=58.9803p pd=0.12737m as=47.6862p ps=64.265u w=62.745u l=1u
X8798 BAT GATE DVDD DVDD pfet_06v0 ad=35.511p pd=48.245u as=35.511p ps=48.245u w=46.725u l=1u
X8799 BAT GATE DVDD DVDD pfet_06v0 ad=47.6862p pd=64.265u as=47.6862p ps=64.265u w=62.745u l=1u
X8800 BAT GATE DVDD DVDD pfet_06v0 ad=58.1134p pd=77.985u as=58.1134p ps=77.985u w=76.465u l=1u
X8801 BAT GATE DVDD DVDD pfet_06v0 ad=35.511p pd=48.245u as=43.9215p ps=95.32999u w=46.725u l=1u
X8802 DVDD GATE BAT DVDD pfet_06v0 ad=35.5072p pd=48.24u as=35.5072p ps=48.24u w=46.72u l=1u
X8803 BAT GATE DVDD DVDD pfet_06v0 ad=58.1172p pd=77.99u as=58.1172p ps=77.99u w=76.47u l=1u
X8804 DVDD GATE BAT DVDD pfet_06v0 ad=58.1134p pd=77.985u as=58.1134p ps=77.985u w=76.465u l=1u
X8805 BAT GATE DVDD DVDD pfet_06v0 ad=35.511p pd=48.245u as=43.9215p ps=95.32999u w=46.725u l=1u
X8806 BAT GATE DVDD DVDD pfet_06v0 ad=58.1134p pd=77.985u as=58.1134p ps=77.985u w=76.465u l=1u
X8807 BAT GATE DVDD DVDD pfet_06v0 ad=35.511p pd=48.245u as=43.9215p ps=95.32999u w=46.725u l=1u
X8808 DVDD GATE BAT DVDD pfet_06v0 ad=58.1096p pd=77.98u as=58.1096p ps=77.98u w=76.46u l=1u
X8809 DVDD GATE BAT DVDD pfet_06v0 ad=71.92879p pd=0.15492m as=58.1552p ps=78.04u w=76.52u l=1u
X8810 BAT GATE DVDD DVDD pfet_06v0 ad=58.1134p pd=77.985u as=71.8771p ps=0.15481m w=76.465u l=1u
X8811 BAT GATE DVDD DVDD pfet_06v0 ad=58.1134p pd=77.985u as=71.8771p ps=0.15481m w=76.465u l=1u
X8812 DVDD GATE BAT DVDD pfet_06v0 ad=58.1096p pd=77.98u as=58.1096p ps=77.98u w=76.46u l=1u
X8813 BAT GATE DVDD DVDD pfet_06v0 ad=47.6862p pd=64.265u as=47.6862p ps=64.265u w=62.745u l=1u
X8814 DVDD GATE BAT DVDD pfet_06v0 ad=35.511p pd=48.245u as=35.511p ps=48.245u w=46.725u l=1u
X8815 DVDD GATE BAT DVDD pfet_06v0 ad=47.6862p pd=64.265u as=47.6862p ps=64.265u w=62.745u l=1u
X8816 BAT GATE DVDD DVDD pfet_06v0 ad=58.1134p pd=77.985u as=58.1134p ps=77.985u w=76.465u l=1u
X8817 BAT GATE DVDD DVDD pfet_06v0 ad=58.1172p pd=77.99u as=58.1172p ps=77.99u w=76.47u l=1u
X8818 BAT GATE DVDD DVDD pfet_06v0 ad=35.511p pd=48.245u as=35.511p ps=48.245u w=46.725u l=1u
X8819 DVDD GATE BAT DVDD pfet_06v0 ad=35.5072p pd=48.24u as=35.5072p ps=48.24u w=46.72u l=1u
X8820 DVDD GATE BAT DVDD pfet_06v0 ad=58.1134p pd=77.985u as=58.1134p ps=77.985u w=76.465u l=1u
X8821 DVDD GATE BAT DVDD pfet_06v0 ad=58.1172p pd=77.99u as=58.1172p ps=77.99u w=76.47u l=1u
X8822 BAT GATE DVDD DVDD pfet_06v0 ad=35.511p pd=48.245u as=35.511p ps=48.245u w=46.725u l=1u
X8823 BAT GATE DVDD DVDD pfet_06v0 ad=58.1134p pd=77.985u as=58.1134p ps=77.985u w=76.465u l=1u
X8824 DVDD GATE BAT DVDD pfet_06v0 ad=58.1134p pd=77.985u as=58.1134p ps=77.985u w=76.465u l=1u
X8825 BAT GATE DVDD DVDD pfet_06v0 ad=49.3848p pd=66.5u as=61.0812p ps=0.13184m w=64.98u l=1u
X8826 BAT GATE DVDD DVDD pfet_06v0 ad=49.3848p pd=66.5u as=49.3848p ps=66.5u w=64.98u l=1u
X8827 BAT GATE DVDD DVDD pfet_06v0 ad=58.1172p pd=77.99u as=71.8818p ps=0.15482m w=76.47u l=1u
X8828 BAT GATE DVDD DVDD pfet_06v0 ad=47.6862p pd=64.265u as=47.6862p ps=64.265u w=62.745u l=1u
X8829 BAT GATE DVDD DVDD pfet_06v0 ad=58.1134p pd=77.985u as=58.1134p ps=77.985u w=76.465u l=1u
X8830 BAT GATE DVDD DVDD pfet_06v0 ad=58.0754p pd=77.935u as=58.0754p ps=77.935u w=76.41499u l=1u
X8831 BAT GATE DVDD DVDD pfet_06v0 ad=58.1134p pd=77.985u as=71.8771p ps=0.15481m w=76.465u l=1u
X8832 BAT GATE DVDD DVDD pfet_06v0 ad=35.511p pd=48.245u as=35.511p ps=48.245u w=46.725u l=1u
X8833 DVDD GATE BAT DVDD pfet_06v0 ad=47.6862p pd=64.265u as=47.6862p ps=64.265u w=62.745u l=1u
X8834 DVDD GATE BAT DVDD pfet_06v0 ad=35.511p pd=48.245u as=35.511p ps=48.245u w=46.725u l=1u
X8835 BAT GATE DVDD DVDD pfet_06v0 ad=35.511p pd=48.245u as=43.9215p ps=95.32999u w=46.725u l=1u
X8836 BAT GATE DVDD DVDD pfet_06v0 ad=35.5072p pd=48.24u as=35.5072p ps=48.24u w=46.72u l=1u
X8837 BAT GATE DVDD DVDD pfet_06v0 ad=35.511p pd=48.245u as=43.9215p ps=95.32999u w=46.725u l=1u
X8838 DVDD GATE BAT DVDD pfet_06v0 ad=35.511p pd=48.245u as=35.511p ps=48.245u w=46.725u l=1u
X8839 BAT GATE DVDD DVDD pfet_06v0 ad=58.1134p pd=77.985u as=58.1134p ps=77.985u w=76.465u l=1u
X8840 DVDD GATE BAT DVDD pfet_06v0 ad=58.1134p pd=77.985u as=58.1134p ps=77.985u w=76.465u l=1u
X8841 BAT GATE DVDD DVDD pfet_06v0 ad=35.511p pd=48.245u as=43.9215p ps=95.32999u w=46.725u l=1u
X8842 DVDD GATE BAT DVDD pfet_06v0 ad=58.1134p pd=77.985u as=58.1134p ps=77.985u w=76.465u l=1u
X8843 DVDD GATE BAT DVDD pfet_06v0 ad=35.511p pd=48.245u as=35.511p ps=48.245u w=46.725u l=1u
X8844 DVDD GATE BAT DVDD pfet_06v0 ad=35.511p pd=48.245u as=35.511p ps=48.245u w=46.725u l=1u
X8845 DVDD GATE BAT DVDD pfet_06v0 ad=35.511p pd=48.245u as=35.511p ps=48.245u w=46.725u l=1u
X8846 DVDD GATE BAT DVDD pfet_06v0 ad=35.511p pd=48.245u as=35.511p ps=48.245u w=46.725u l=1u
X8847 BAT GATE DVDD DVDD pfet_06v0 ad=58.1134p pd=77.985u as=58.1134p ps=77.985u w=76.465u l=1u
X8848 BAT GATE DVDD DVDD pfet_06v0 ad=58.1134p pd=77.985u as=58.1134p ps=77.985u w=76.465u l=1u
X8849 BAT GATE DVDD DVDD pfet_06v0 ad=58.1134p pd=77.985u as=58.1134p ps=77.985u w=76.465u l=1u
X8850 BAT GATE DVDD DVDD pfet_06v0 ad=58.1552p pd=78.04u as=58.1552p ps=78.04u w=76.52u l=1u
X8851 DVDD GATE BAT DVDD pfet_06v0 ad=71.8771p pd=0.15481m as=58.1134p ps=77.985u w=76.465u l=1u
X8852 DVDD GATE BAT DVDD pfet_06v0 ad=35.511p pd=48.245u as=35.511p ps=48.245u w=46.725u l=1u
X8853 DVDD GATE BAT DVDD pfet_06v0 ad=35.511p pd=48.245u as=35.511p ps=48.245u w=46.725u l=1u
X8854 BAT GATE DVDD DVDD pfet_06v0 ad=49.3848p pd=66.5u as=49.3848p ps=66.5u w=64.98u l=1u
X8855 DVDD GATE BAT DVDD pfet_06v0 ad=35.511p pd=48.245u as=35.511p ps=48.245u w=46.725u l=1u
X8856 DVDD GATE BAT DVDD pfet_06v0 ad=58.1134p pd=77.985u as=58.1134p ps=77.985u w=76.465u l=1u
X8857 BAT GATE DVDD DVDD pfet_06v0 ad=35.511p pd=48.245u as=35.511p ps=48.245u w=46.725u l=1u
X8858 BAT GATE DVDD DVDD pfet_06v0 ad=58.1134p pd=77.985u as=58.1134p ps=77.985u w=76.465u l=1u
X8859 DVDD GATE BAT DVDD pfet_06v0 ad=35.511p pd=48.245u as=35.511p ps=48.245u w=46.725u l=1u
X8860 DVDD GATE BAT DVDD pfet_06v0 ad=58.1134p pd=77.985u as=58.1134p ps=77.985u w=76.465u l=1u
X8861 BAT GATE DVDD DVDD pfet_06v0 ad=58.1552p pd=78.04u as=71.92879p ps=0.15492m w=76.52u l=1u
X8862 DVDD GATE BAT DVDD pfet_06v0 ad=58.1134p pd=77.985u as=58.1134p ps=77.985u w=76.465u l=1u
X8863 DVDD GATE BAT DVDD pfet_06v0 ad=71.8771p pd=0.15481m as=58.1134p ps=77.985u w=76.465u l=1u
X8864 DVDD GATE BAT DVDD pfet_06v0 ad=58.1552p pd=78.04u as=58.1552p ps=78.04u w=76.52u l=1u
X8865 BAT GATE DVDD DVDD pfet_06v0 ad=58.0754p pd=77.935u as=58.0754p ps=77.935u w=76.41499u l=1u
X8866 DVDD GATE BAT DVDD pfet_06v0 ad=35.511p pd=48.245u as=35.511p ps=48.245u w=46.725u l=1u
X8867 BAT GATE DVDD DVDD pfet_06v0 ad=58.1134p pd=77.985u as=58.1134p ps=77.985u w=76.465u l=1u
X8868 DVDD GATE BAT DVDD pfet_06v0 ad=35.511p pd=48.245u as=35.511p ps=48.245u w=46.725u l=1u
X8869 DVDD GATE BAT DVDD pfet_06v0 ad=35.511p pd=48.245u as=35.511p ps=48.245u w=46.725u l=1u
X8870 BAT GATE DVDD DVDD pfet_06v0 ad=35.511p pd=48.245u as=35.511p ps=48.245u w=46.725u l=1u
X8871 DVDD GATE BAT DVDD pfet_06v0 ad=58.1134p pd=77.985u as=58.1134p ps=77.985u w=76.465u l=1u
X8872 DVDD GATE BAT DVDD pfet_06v0 ad=58.0754p pd=77.935u as=58.0754p ps=77.935u w=76.41499u l=1u
X8873 DVDD GATE BAT DVDD pfet_06v0 ad=58.1134p pd=77.985u as=58.1134p ps=77.985u w=76.465u l=1u
X8874 DVDD GATE BAT DVDD pfet_06v0 ad=71.8771p pd=0.15481m as=58.1134p ps=77.985u w=76.465u l=1u
X8875 BAT GATE DVDD DVDD pfet_06v0 ad=35.511p pd=48.245u as=35.511p ps=48.245u w=46.725u l=1u
X8876 BAT GATE DVDD DVDD pfet_06v0 ad=58.1134p pd=77.985u as=58.1134p ps=77.985u w=76.465u l=1u
X8877 DVDD GATE BAT DVDD pfet_06v0 ad=35.511p pd=48.245u as=35.511p ps=48.245u w=46.725u l=1u
X8878 BAT GATE DVDD DVDD pfet_06v0 ad=58.1172p pd=77.99u as=71.8818p ps=0.15482m w=76.47u l=1u
X8879 BAT GATE DVDD DVDD pfet_06v0 ad=47.6862p pd=64.265u as=47.6862p ps=64.265u w=62.745u l=1u
X8880 BAT GATE DVDD DVDD pfet_06v0 ad=58.1134p pd=77.985u as=58.1134p ps=77.985u w=76.465u l=1u
X8881 BAT GATE DVDD DVDD pfet_06v0 ad=58.1134p pd=77.985u as=58.1134p ps=77.985u w=76.465u l=1u
X8882 DVDD GATE BAT DVDD pfet_06v0 ad=71.8771p pd=0.15481m as=58.1134p ps=77.985u w=76.465u l=1u
X8883 BAT GATE DVDD DVDD pfet_06v0 ad=35.511p pd=48.245u as=43.9215p ps=95.32999u w=46.725u l=1u
X8884 DVDD GATE BAT DVDD pfet_06v0 ad=43.9215p pd=95.32999u as=35.511p ps=48.245u w=46.725u l=1u
X8885 BAT GATE DVDD DVDD pfet_06v0 ad=58.1134p pd=77.985u as=58.1134p ps=77.985u w=76.465u l=1u
X8886 DVDD GATE BAT DVDD pfet_06v0 ad=58.1134p pd=77.985u as=58.1134p ps=77.985u w=76.465u l=1u
X8887 DVDD GATE BAT DVDD pfet_06v0 ad=35.511p pd=48.245u as=35.511p ps=48.245u w=46.725u l=1u
X8888 DVDD GATE BAT DVDD pfet_06v0 ad=35.511p pd=48.245u as=35.511p ps=48.245u w=46.725u l=1u
X8889 BAT GATE DVDD DVDD pfet_06v0 ad=35.511p pd=48.245u as=43.9215p ps=95.32999u w=46.725u l=1u
X8890 DVDD GATE BAT DVDD pfet_06v0 ad=35.511p pd=48.245u as=35.511p ps=48.245u w=46.725u l=1u
X8891 DVDD GATE BAT DVDD pfet_06v0 ad=35.511p pd=48.245u as=35.511p ps=48.245u w=46.725u l=1u
X8892 DVDD GATE BAT DVDD pfet_06v0 ad=58.1134p pd=77.985u as=58.1134p ps=77.985u w=76.465u l=1u
X8893 BAT GATE DVDD DVDD pfet_06v0 ad=58.1096p pd=77.98u as=58.1096p ps=77.98u w=76.46u l=1u
X8894 DVDD GATE BAT DVDD pfet_06v0 ad=47.6862p pd=64.265u as=47.6862p ps=64.265u w=62.745u l=1u
X8895 BAT GATE DVDD DVDD pfet_06v0 ad=58.0754p pd=77.935u as=58.0754p ps=77.935u w=76.41499u l=1u
X8896 DVDD GATE BAT DVDD pfet_06v0 ad=35.511p pd=48.245u as=35.511p ps=48.245u w=46.725u l=1u
X8897 DVDD GATE BAT DVDD pfet_06v0 ad=35.511p pd=48.245u as=35.511p ps=48.245u w=46.725u l=1u
X8898 DVDD GATE BAT DVDD pfet_06v0 ad=35.511p pd=48.245u as=35.511p ps=48.245u w=46.725u l=1u
X8899 BAT GATE DVDD DVDD pfet_06v0 ad=35.5072p pd=48.24u as=35.5072p ps=48.24u w=46.72u l=1u
X8900 DVDD GATE BAT DVDD pfet_06v0 ad=35.511p pd=48.245u as=35.511p ps=48.245u w=46.725u l=1u
X8901 DVDD GATE BAT DVDD pfet_06v0 ad=58.1134p pd=77.985u as=58.1134p ps=77.985u w=76.465u l=1u
X8902 DVDD GATE BAT DVDD pfet_06v0 ad=58.1134p pd=77.985u as=58.1134p ps=77.985u w=76.465u l=1u
X8903 DVDD GATE BAT DVDD pfet_06v0 ad=35.511p pd=48.245u as=35.511p ps=48.245u w=46.725u l=1u
X8904 DVDD GATE BAT DVDD pfet_06v0 ad=71.8771p pd=0.15481m as=58.1134p ps=77.985u w=76.465u l=1u
X8905 BAT GATE DVDD DVDD pfet_06v0 ad=35.511p pd=48.245u as=35.511p ps=48.245u w=46.725u l=1u
X8906 DVDD GATE BAT DVDD pfet_06v0 ad=58.1134p pd=77.985u as=58.1134p ps=77.985u w=76.465u l=1u
X8907 DVDD GATE BAT DVDD pfet_06v0 ad=35.511p pd=48.245u as=35.511p ps=48.245u w=46.725u l=1u
X8908 DVDD GATE BAT DVDD pfet_06v0 ad=35.511p pd=48.245u as=35.511p ps=48.245u w=46.725u l=1u
X8909 DVDD GATE BAT DVDD pfet_06v0 ad=43.9215p pd=95.32999u as=35.511p ps=48.245u w=46.725u l=1u
X8910 DVDD GATE BAT DVDD pfet_06v0 ad=58.1134p pd=77.985u as=58.1134p ps=77.985u w=76.465u l=1u
X8911 BAT GATE DVDD DVDD pfet_06v0 ad=58.1134p pd=77.985u as=71.8771p ps=0.15481m w=76.465u l=1u
X8912 BAT GATE DVDD DVDD pfet_06v0 ad=58.1134p pd=77.985u as=71.8771p ps=0.15481m w=76.465u l=1u
X8913 BAT GATE DVDD DVDD pfet_06v0 ad=58.1096p pd=77.98u as=58.1096p ps=77.98u w=76.46u l=1u
X8914 DVDD GATE BAT DVDD pfet_06v0 ad=71.8771p pd=0.15481m as=58.1134p ps=77.985u w=76.465u l=1u
X8915 DVDD GATE BAT DVDD pfet_06v0 ad=58.1552p pd=78.04u as=58.1552p ps=78.04u w=76.52u l=1u
X8916 BAT GATE DVDD DVDD pfet_06v0 ad=58.1134p pd=77.985u as=58.1134p ps=77.985u w=76.465u l=1u
X8917 DVDD GATE BAT DVDD pfet_06v0 ad=35.5072p pd=48.24u as=35.5072p ps=48.24u w=46.72u l=1u
X8918 BAT GATE DVDD DVDD pfet_06v0 ad=35.511p pd=48.245u as=35.511p ps=48.245u w=46.725u l=1u
X8919 DVDD GATE BAT DVDD pfet_06v0 ad=58.0754p pd=77.935u as=58.0754p ps=77.935u w=76.41499u l=1u
X8920 DVDD GATE BAT DVDD pfet_06v0 ad=35.511p pd=48.245u as=35.511p ps=48.245u w=46.725u l=1u
X8921 DVDD GATE BAT DVDD pfet_06v0 ad=43.9215p pd=95.32999u as=35.511p ps=48.245u w=46.725u l=1u
X8922 BAT GATE DVDD DVDD pfet_06v0 ad=35.511p pd=48.245u as=35.511p ps=48.245u w=46.725u l=1u
X8923 BAT GATE DVDD DVDD pfet_06v0 ad=35.511p pd=48.245u as=35.511p ps=48.245u w=46.725u l=1u
X8924 DVDD GATE BAT DVDD pfet_06v0 ad=58.0754p pd=77.935u as=58.0754p ps=77.935u w=76.41499u l=1u
X8925 DVDD GATE BAT DVDD pfet_06v0 ad=71.8724p pd=0.1548m as=58.1096p ps=77.98u w=76.46u l=1u
X8926 BAT GATE DVDD DVDD pfet_06v0 ad=58.1134p pd=77.985u as=58.1134p ps=77.985u w=76.465u l=1u
X8927 DVDD GATE BAT DVDD pfet_06v0 ad=58.0754p pd=77.935u as=58.0754p ps=77.935u w=76.41499u l=1u
X8928 BAT GATE DVDD DVDD pfet_06v0 ad=35.511p pd=48.245u as=35.511p ps=48.245u w=46.725u l=1u
X8929 BAT GATE DVDD DVDD pfet_06v0 ad=47.6862p pd=64.265u as=58.9803p ps=0.12737m w=62.745u l=1u
X8930 BAT GATE DVDD DVDD pfet_06v0 ad=35.511p pd=48.245u as=35.511p ps=48.245u w=46.725u l=1u
X8931 DVDD GATE BAT DVDD pfet_06v0 ad=35.511p pd=48.245u as=35.511p ps=48.245u w=46.725u l=1u
X8932 DVDD GATE BAT DVDD pfet_06v0 ad=71.8771p pd=0.15481m as=58.1134p ps=77.985u w=76.465u l=1u
X8933 BAT GATE DVDD DVDD pfet_06v0 ad=58.1134p pd=77.985u as=71.8771p ps=0.15481m w=76.465u l=1u
X8934 BAT GATE DVDD DVDD pfet_06v0 ad=58.0754p pd=77.935u as=58.0754p ps=77.935u w=76.41499u l=1u
X8935 BAT GATE DVDD DVDD pfet_06v0 ad=58.1552p pd=78.04u as=58.1552p ps=78.04u w=76.52u l=1u
X8936 DVDD GATE BAT DVDD pfet_06v0 ad=35.511p pd=48.245u as=35.511p ps=48.245u w=46.725u l=1u
X8937 DVDD GATE BAT DVDD pfet_06v0 ad=58.1134p pd=77.985u as=58.1134p ps=77.985u w=76.465u l=1u
X8938 DVDD GATE BAT DVDD pfet_06v0 ad=71.8771p pd=0.15481m as=58.1134p ps=77.985u w=76.465u l=1u
X8939 BAT GATE DVDD DVDD pfet_06v0 ad=35.511p pd=48.245u as=35.511p ps=48.245u w=46.725u l=1u
X8940 DVDD GATE BAT DVDD pfet_06v0 ad=58.1134p pd=77.985u as=58.1134p ps=77.985u w=76.465u l=1u
X8941 DVDD GATE BAT DVDD pfet_06v0 ad=58.1134p pd=77.985u as=58.1134p ps=77.985u w=76.465u l=1u
X8942 DVDD GATE BAT DVDD pfet_06v0 ad=71.8818p pd=0.15482m as=58.1172p ps=77.99u w=76.47u l=1u
X8943 BAT GATE DVDD DVDD pfet_06v0 ad=58.0754p pd=77.935u as=71.8301p ps=0.15471m w=76.41499u l=1u
X8944 DVDD GATE BAT DVDD pfet_06v0 ad=58.1134p pd=77.985u as=58.1134p ps=77.985u w=76.465u l=1u
X8945 BAT GATE DVDD DVDD pfet_06v0 ad=49.3848p pd=66.5u as=49.3848p ps=66.5u w=64.98u l=1u
X8946 BAT GATE DVDD DVDD pfet_06v0 ad=35.511p pd=48.245u as=35.511p ps=48.245u w=46.725u l=1u
X8947 DVDD GATE BAT DVDD pfet_06v0 ad=35.511p pd=48.245u as=35.511p ps=48.245u w=46.725u l=1u
X8948 DVDD GATE BAT DVDD pfet_06v0 ad=58.1134p pd=77.985u as=58.1134p ps=77.985u w=76.465u l=1u
X8949 BAT GATE DVDD DVDD pfet_06v0 ad=58.1172p pd=77.99u as=58.1172p ps=77.99u w=76.47u l=1u
X8950 DVDD GATE BAT DVDD pfet_06v0 ad=35.511p pd=48.245u as=35.511p ps=48.245u w=46.725u l=1u
X8951 BAT GATE DVDD DVDD pfet_06v0 ad=35.511p pd=48.245u as=35.511p ps=48.245u w=46.725u l=1u
X8952 BAT GATE DVDD DVDD pfet_06v0 ad=58.1134p pd=77.985u as=58.1134p ps=77.985u w=76.465u l=1u
X8953 BAT GATE DVDD DVDD pfet_06v0 ad=58.1552p pd=78.04u as=58.1552p ps=78.04u w=76.52u l=1u
X8954 BAT GATE DVDD DVDD pfet_06v0 ad=35.511p pd=48.245u as=35.511p ps=48.245u w=46.725u l=1u
X8955 DVDD GATE BAT DVDD pfet_06v0 ad=49.3848p pd=66.5u as=49.3848p ps=66.5u w=64.98u l=1u
X8956 DVDD GATE BAT DVDD pfet_06v0 ad=35.511p pd=48.245u as=35.511p ps=48.245u w=46.725u l=1u
X8957 DVDD GATE BAT DVDD pfet_06v0 ad=58.1552p pd=78.04u as=58.1552p ps=78.04u w=76.52u l=1u
X8958 DVDD GATE BAT DVDD pfet_06v0 ad=58.1096p pd=77.98u as=58.1096p ps=77.98u w=76.46u l=1u
X8959 BAT GATE DVDD DVDD pfet_06v0 ad=58.1134p pd=77.985u as=58.1134p ps=77.985u w=76.465u l=1u
X8960 DVDD GATE BAT DVDD pfet_06v0 ad=58.1134p pd=77.985u as=58.1134p ps=77.985u w=76.465u l=1u
X8961 BAT GATE DVDD DVDD pfet_06v0 ad=35.511p pd=48.245u as=35.511p ps=48.245u w=46.725u l=1u
X8962 DVDD GATE BAT DVDD pfet_06v0 ad=35.511p pd=48.245u as=35.511p ps=48.245u w=46.725u l=1u
X8963 DVDD GATE BAT DVDD pfet_06v0 ad=58.1134p pd=77.985u as=58.1134p ps=77.985u w=76.465u l=1u
X8964 BAT GATE DVDD DVDD pfet_06v0 ad=58.1134p pd=77.985u as=58.1134p ps=77.985u w=76.465u l=1u
X8965 DVDD GATE BAT DVDD pfet_06v0 ad=71.8771p pd=0.15481m as=58.1134p ps=77.985u w=76.465u l=1u
X8966 DVDD GATE BAT DVDD pfet_06v0 ad=35.511p pd=48.245u as=35.511p ps=48.245u w=46.725u l=1u
X8967 BAT GATE DVDD DVDD pfet_06v0 ad=58.1134p pd=77.985u as=58.1134p ps=77.985u w=76.465u l=1u
X8968 BAT GATE DVDD DVDD pfet_06v0 ad=35.511p pd=48.245u as=43.9215p ps=95.32999u w=46.725u l=1u
X8969 BAT GATE DVDD DVDD pfet_06v0 ad=58.1134p pd=77.985u as=58.1134p ps=77.985u w=76.465u l=1u
X8970 BAT GATE DVDD DVDD pfet_06v0 ad=58.1552p pd=78.04u as=58.1552p ps=78.04u w=76.52u l=1u
X8971 DVDD GATE BAT DVDD pfet_06v0 ad=58.0754p pd=77.935u as=58.0754p ps=77.935u w=76.41499u l=1u
X8972 BAT GATE DVDD DVDD pfet_06v0 ad=35.511p pd=48.245u as=43.9215p ps=95.32999u w=46.725u l=1u
X8973 DVDD GATE BAT DVDD pfet_06v0 ad=35.5072p pd=48.24u as=35.5072p ps=48.24u w=46.72u l=1u
X8974 BAT GATE DVDD DVDD pfet_06v0 ad=35.511p pd=48.245u as=35.511p ps=48.245u w=46.725u l=1u
X8975 DVDD GATE BAT DVDD pfet_06v0 ad=43.9215p pd=95.32999u as=35.511p ps=48.245u w=46.725u l=1u
X8976 BAT GATE DVDD DVDD pfet_06v0 ad=35.511p pd=48.245u as=43.9215p ps=95.32999u w=46.725u l=1u
X8977 DVDD GATE BAT DVDD pfet_06v0 ad=58.1134p pd=77.985u as=58.1134p ps=77.985u w=76.465u l=1u
X8978 BAT GATE DVDD DVDD pfet_06v0 ad=58.1134p pd=77.985u as=58.1134p ps=77.985u w=76.465u l=1u
X8979 BAT GATE DVDD DVDD pfet_06v0 ad=47.6862p pd=64.265u as=47.6862p ps=64.265u w=62.745u l=1u
X8980 BAT GATE DVDD DVDD pfet_06v0 ad=58.1134p pd=77.985u as=58.1134p ps=77.985u w=76.465u l=1u
X8981 DVDD GATE BAT DVDD pfet_06v0 ad=58.1134p pd=77.985u as=58.1134p ps=77.985u w=76.465u l=1u
X8982 BAT GATE DVDD DVDD pfet_06v0 ad=58.1552p pd=78.04u as=58.1552p ps=78.04u w=76.52u l=1u
X8983 BAT GATE DVDD DVDD pfet_06v0 ad=35.511p pd=48.245u as=35.511p ps=48.245u w=46.725u l=1u
X8984 DVDD GATE BAT DVDD pfet_06v0 ad=58.1134p pd=77.985u as=58.1134p ps=77.985u w=76.465u l=1u
X8985 BAT GATE DVDD DVDD pfet_06v0 ad=35.511p pd=48.245u as=43.9215p ps=95.32999u w=46.725u l=1u
X8986 BAT GATE DVDD DVDD pfet_06v0 ad=49.3848p pd=66.5u as=49.3848p ps=66.5u w=64.98u l=1u
X8987 DVDD GATE BAT DVDD pfet_06v0 ad=35.511p pd=48.245u as=35.511p ps=48.245u w=46.725u l=1u
X8988 DVDD GATE BAT DVDD pfet_06v0 ad=58.1134p pd=77.985u as=58.1134p ps=77.985u w=76.465u l=1u
X8989 BAT GATE DVDD DVDD pfet_06v0 ad=35.511p pd=48.245u as=35.511p ps=48.245u w=46.725u l=1u
X8990 BAT GATE DVDD DVDD pfet_06v0 ad=58.1134p pd=77.985u as=71.8771p ps=0.15481m w=76.465u l=1u
X8991 DVDD GATE BAT DVDD pfet_06v0 ad=43.9215p pd=95.32999u as=35.511p ps=48.245u w=46.725u l=1u
X8992 DVDD GATE BAT DVDD pfet_06v0 ad=58.1096p pd=77.98u as=58.1096p ps=77.98u w=76.46u l=1u
X8993 DVDD GATE BAT DVDD pfet_06v0 ad=58.1134p pd=77.985u as=58.1134p ps=77.985u w=76.465u l=1u
X8994 DVDD GATE BAT DVDD pfet_06v0 ad=71.8771p pd=0.15481m as=58.1134p ps=77.985u w=76.465u l=1u
X8995 DVDD GATE BAT DVDD pfet_06v0 ad=58.1096p pd=77.98u as=58.1096p ps=77.98u w=76.46u l=1u
X8996 BAT GATE DVDD DVDD pfet_06v0 ad=58.1134p pd=77.985u as=71.8771p ps=0.15481m w=76.465u l=1u
X8997 BAT GATE DVDD DVDD pfet_06v0 ad=35.511p pd=48.245u as=35.511p ps=48.245u w=46.725u l=1u
X8998 DVDD GATE BAT DVDD pfet_06v0 ad=35.511p pd=48.245u as=35.511p ps=48.245u w=46.725u l=1u
X8999 BAT GATE DVDD DVDD pfet_06v0 ad=58.1134p pd=77.985u as=58.1134p ps=77.985u w=76.465u l=1u
X9000 DVDD GATE BAT DVDD pfet_06v0 ad=35.511p pd=48.245u as=35.511p ps=48.245u w=46.725u l=1u
X9001 BAT GATE DVDD DVDD pfet_06v0 ad=58.0754p pd=77.935u as=58.0754p ps=77.935u w=76.41499u l=1u
X9002 DVDD GATE BAT DVDD pfet_06v0 ad=58.1552p pd=78.04u as=58.1552p ps=78.04u w=76.52u l=1u
X9003 DVDD GATE BAT DVDD pfet_06v0 ad=58.1134p pd=77.985u as=58.1134p ps=77.985u w=76.465u l=1u
X9004 DVDD GATE BAT DVDD pfet_06v0 ad=35.511p pd=48.245u as=35.511p ps=48.245u w=46.725u l=1u
X9005 BAT GATE DVDD DVDD pfet_06v0 ad=47.6862p pd=64.265u as=47.6862p ps=64.265u w=62.745u l=1u
X9006 DVDD GATE BAT DVDD pfet_06v0 ad=58.0754p pd=77.935u as=58.0754p ps=77.935u w=76.41499u l=1u
X9007 BAT GATE DVDD DVDD pfet_06v0 ad=35.511p pd=48.245u as=43.9215p ps=95.32999u w=46.725u l=1u
X9008 BAT GATE DVDD DVDD pfet_06v0 ad=35.511p pd=48.245u as=43.9215p ps=95.32999u w=46.725u l=1u
X9009 BAT GATE DVDD DVDD pfet_06v0 ad=35.511p pd=48.245u as=35.511p ps=48.245u w=46.725u l=1u
X9010 DVDD GATE BAT DVDD pfet_06v0 ad=35.5072p pd=48.24u as=35.5072p ps=48.24u w=46.72u l=1u
X9011 BAT GATE DVDD DVDD pfet_06v0 ad=35.511p pd=48.245u as=35.511p ps=48.245u w=46.725u l=1u
X9012 DVDD GATE BAT DVDD pfet_06v0 ad=47.6862p pd=64.265u as=47.6862p ps=64.265u w=62.745u l=1u
X9013 BAT GATE DVDD DVDD pfet_06v0 ad=58.1134p pd=77.985u as=58.1134p ps=77.985u w=76.465u l=1u
X9014 DVDD GATE BAT DVDD pfet_06v0 ad=43.9215p pd=95.32999u as=35.511p ps=48.245u w=46.725u l=1u
X9015 DVDD GATE BAT DVDD pfet_06v0 ad=71.8301p pd=0.15471m as=58.0754p ps=77.935u w=76.41499u l=1u
X9016 BAT GATE DVDD DVDD pfet_06v0 ad=35.511p pd=48.245u as=35.511p ps=48.245u w=46.725u l=1u
X9017 BAT GATE DVDD DVDD pfet_06v0 ad=47.6862p pd=64.265u as=47.6862p ps=64.265u w=62.745u l=1u
X9018 DVDD GATE BAT DVDD pfet_06v0 ad=35.511p pd=48.245u as=35.511p ps=48.245u w=46.725u l=1u
X9019 BAT GATE DVDD DVDD pfet_06v0 ad=35.511p pd=48.245u as=35.511p ps=48.245u w=46.725u l=1u
X9020 DVDD GATE BAT DVDD pfet_06v0 ad=35.511p pd=48.245u as=35.511p ps=48.245u w=46.725u l=1u
X9021 BAT GATE DVDD DVDD pfet_06v0 ad=58.1134p pd=77.985u as=58.1134p ps=77.985u w=76.465u l=1u
X9022 DVDD GATE BAT DVDD pfet_06v0 ad=35.511p pd=48.245u as=35.511p ps=48.245u w=46.725u l=1u
X9023 DVDD GATE BAT DVDD pfet_06v0 ad=47.6862p pd=64.265u as=47.6862p ps=64.265u w=62.745u l=1u
X9024 BAT GATE DVDD DVDD pfet_06v0 ad=58.0754p pd=77.935u as=71.8301p ps=0.15471m w=76.41499u l=1u
X9025 BAT GATE DVDD DVDD pfet_06v0 ad=49.3848p pd=66.5u as=61.0812p ps=0.13184m w=64.98u l=1u
X9026 DVDD GATE BAT DVDD pfet_06v0 ad=58.1172p pd=77.99u as=58.1172p ps=77.99u w=76.47u l=1u
X9027 BAT GATE DVDD DVDD pfet_06v0 ad=58.1134p pd=77.985u as=58.1134p ps=77.985u w=76.465u l=1u
X9028 DVDD GATE BAT DVDD pfet_06v0 ad=35.511p pd=48.245u as=35.511p ps=48.245u w=46.725u l=1u
X9029 BAT GATE DVDD DVDD pfet_06v0 ad=58.1096p pd=77.98u as=58.1096p ps=77.98u w=76.46u l=1u
X9030 BAT GATE DVDD DVDD pfet_06v0 ad=58.1552p pd=78.04u as=58.1552p ps=78.04u w=76.52u l=1u
X9031 DVDD GATE BAT DVDD pfet_06v0 ad=47.6862p pd=64.265u as=47.6862p ps=64.265u w=62.745u l=1u
X9032 BAT GATE DVDD DVDD pfet_06v0 ad=35.5072p pd=48.24u as=35.5072p ps=48.24u w=46.72u l=1u
X9033 DVDD GATE BAT DVDD pfet_06v0 ad=35.511p pd=48.245u as=35.511p ps=48.245u w=46.725u l=1u
X9034 DVDD GATE BAT DVDD pfet_06v0 ad=35.511p pd=48.245u as=35.511p ps=48.245u w=46.725u l=1u
X9035 BAT GATE DVDD DVDD pfet_06v0 ad=35.511p pd=48.245u as=43.9215p ps=95.32999u w=46.725u l=1u
X9036 BAT GATE DVDD DVDD pfet_06v0 ad=58.1134p pd=77.985u as=58.1134p ps=77.985u w=76.465u l=1u
X9037 BAT GATE DVDD DVDD pfet_06v0 ad=58.1134p pd=77.985u as=58.1134p ps=77.985u w=76.465u l=1u
X9038 DVDD GATE BAT DVDD pfet_06v0 ad=58.1134p pd=77.985u as=58.1134p ps=77.985u w=76.465u l=1u
X9039 BAT GATE DVDD DVDD pfet_06v0 ad=35.511p pd=48.245u as=35.511p ps=48.245u w=46.725u l=1u
X9040 DVDD GATE BAT DVDD pfet_06v0 ad=35.511p pd=48.245u as=35.511p ps=48.245u w=46.725u l=1u
X9041 DVDD GATE BAT DVDD pfet_06v0 ad=58.1134p pd=77.985u as=58.1134p ps=77.985u w=76.465u l=1u
X9042 BAT GATE DVDD DVDD pfet_06v0 ad=58.0754p pd=77.935u as=71.8301p ps=0.15471m w=76.41499u l=1u
X9043 BAT GATE DVDD DVDD pfet_06v0 ad=35.511p pd=48.245u as=35.511p ps=48.245u w=46.725u l=1u
X9044 BAT GATE DVDD DVDD pfet_06v0 ad=58.0754p pd=77.935u as=58.0754p ps=77.935u w=76.41499u l=1u
X9045 DVDD GATE BAT DVDD pfet_06v0 ad=35.511p pd=48.245u as=35.511p ps=48.245u w=46.725u l=1u
X9046 DVDD GATE BAT DVDD pfet_06v0 ad=43.9215p pd=95.32999u as=35.511p ps=48.245u w=46.725u l=1u
X9047 BAT GATE DVDD DVDD pfet_06v0 ad=35.511p pd=48.245u as=43.9215p ps=95.32999u w=46.725u l=1u
X9048 BAT GATE DVDD DVDD pfet_06v0 ad=58.1172p pd=77.99u as=58.1172p ps=77.99u w=76.47u l=1u
X9049 BAT GATE DVDD DVDD pfet_06v0 ad=58.1172p pd=77.99u as=58.1172p ps=77.99u w=76.47u l=1u
X9050 DVDD GATE BAT DVDD pfet_06v0 ad=58.0754p pd=77.935u as=58.0754p ps=77.935u w=76.41499u l=1u
X9051 DVDD GATE BAT DVDD pfet_06v0 ad=35.511p pd=48.245u as=35.511p ps=48.245u w=46.725u l=1u
X9052 BAT GATE DVDD DVDD pfet_06v0 ad=35.511p pd=48.245u as=35.511p ps=48.245u w=46.725u l=1u
X9053 BAT GATE DVDD DVDD pfet_06v0 ad=35.511p pd=48.245u as=35.511p ps=48.245u w=46.725u l=1u
X9054 DVDD GATE BAT DVDD pfet_06v0 ad=47.6862p pd=64.265u as=47.6862p ps=64.265u w=62.745u l=1u
X9055 BAT GATE DVDD DVDD pfet_06v0 ad=58.1134p pd=77.985u as=58.1134p ps=77.985u w=76.465u l=1u
X9056 BAT GATE DVDD DVDD pfet_06v0 ad=58.1134p pd=77.985u as=58.1134p ps=77.985u w=76.465u l=1u
X9057 BAT GATE DVDD DVDD pfet_06v0 ad=47.6862p pd=64.265u as=58.9803p ps=0.12737m w=62.745u l=1u
X9058 BAT GATE DVDD DVDD pfet_06v0 ad=58.1134p pd=77.985u as=58.1134p ps=77.985u w=76.465u l=1u
X9059 DVDD GATE BAT DVDD pfet_06v0 ad=58.1172p pd=77.99u as=58.1172p ps=77.99u w=76.47u l=1u
X9060 DVDD GATE BAT DVDD pfet_06v0 ad=49.3848p pd=66.5u as=49.3848p ps=66.5u w=64.98u l=1u
X9061 BAT GATE DVDD DVDD pfet_06v0 ad=35.5072p pd=48.24u as=43.9168p ps=95.32u w=46.72u l=1u
X9062 BAT GATE DVDD DVDD pfet_06v0 ad=58.1134p pd=77.985u as=71.8771p ps=0.15481m w=76.465u l=1u
X9063 DVDD GATE BAT DVDD pfet_06v0 ad=58.1134p pd=77.985u as=58.1134p ps=77.985u w=76.465u l=1u
X9064 BAT GATE DVDD DVDD pfet_06v0 ad=58.1552p pd=78.04u as=58.1552p ps=78.04u w=76.52u l=1u
X9065 BAT GATE DVDD DVDD pfet_06v0 ad=58.1134p pd=77.985u as=58.1134p ps=77.985u w=76.465u l=1u
X9066 BAT GATE DVDD DVDD pfet_06v0 ad=58.1096p pd=77.98u as=71.8724p ps=0.1548m w=76.46u l=1u
X9067 BAT GATE DVDD DVDD pfet_06v0 ad=58.1134p pd=77.985u as=58.1134p ps=77.985u w=76.465u l=1u
X9068 BAT GATE DVDD DVDD pfet_06v0 ad=35.511p pd=48.245u as=35.511p ps=48.245u w=46.725u l=1u
X9069 BAT GATE DVDD DVDD pfet_06v0 ad=35.511p pd=48.245u as=43.9215p ps=95.32999u w=46.725u l=1u
X9070 DVDD GATE BAT DVDD pfet_06v0 ad=43.9215p pd=95.32999u as=35.511p ps=48.245u w=46.725u l=1u
X9071 BAT GATE DVDD DVDD pfet_06v0 ad=35.511p pd=48.245u as=35.511p ps=48.245u w=46.725u l=1u
X9072 DVDD GATE BAT DVDD pfet_06v0 ad=35.5072p pd=48.24u as=35.5072p ps=48.24u w=46.72u l=1u
X9073 BAT GATE DVDD DVDD pfet_06v0 ad=58.1552p pd=78.04u as=58.1552p ps=78.04u w=76.52u l=1u
X9074 BAT GATE DVDD DVDD pfet_06v0 ad=35.511p pd=48.245u as=35.511p ps=48.245u w=46.725u l=1u
X9075 BAT GATE DVDD DVDD pfet_06v0 ad=58.1134p pd=77.985u as=58.1134p ps=77.985u w=76.465u l=1u
X9076 DVDD GATE BAT DVDD pfet_06v0 ad=35.511p pd=48.245u as=35.511p ps=48.245u w=46.725u l=1u
X9077 BAT GATE DVDD DVDD pfet_06v0 ad=58.0754p pd=77.935u as=58.0754p ps=77.935u w=76.41499u l=1u
X9078 DVDD GATE BAT DVDD pfet_06v0 ad=43.9215p pd=95.32999u as=35.511p ps=48.245u w=46.725u l=1u
X9079 DVDD GATE BAT DVDD pfet_06v0 ad=35.511p pd=48.245u as=35.511p ps=48.245u w=46.725u l=1u
X9080 DVDD GATE BAT DVDD pfet_06v0 ad=58.1552p pd=78.04u as=58.1552p ps=78.04u w=76.52u l=1u
X9081 BAT GATE DVDD DVDD pfet_06v0 ad=35.5072p pd=48.24u as=43.9168p ps=95.32u w=46.72u l=1u
X9082 BAT GATE DVDD DVDD pfet_06v0 ad=58.1134p pd=77.985u as=58.1134p ps=77.985u w=76.465u l=1u
X9083 DVDD GATE BAT DVDD pfet_06v0 ad=71.8771p pd=0.15481m as=58.1134p ps=77.985u w=76.465u l=1u
X9084 BAT GATE DVDD DVDD pfet_06v0 ad=58.1134p pd=77.985u as=58.1134p ps=77.985u w=76.465u l=1u
X9085 BAT GATE DVDD DVDD pfet_06v0 ad=35.511p pd=48.245u as=43.9215p ps=95.32999u w=46.725u l=1u
X9086 BAT GATE DVDD DVDD pfet_06v0 ad=35.511p pd=48.245u as=35.511p ps=48.245u w=46.725u l=1u
X9087 DVDD GATE BAT DVDD pfet_06v0 ad=71.8771p pd=0.15481m as=58.1134p ps=77.985u w=76.465u l=1u
X9088 DVDD GATE BAT DVDD pfet_06v0 ad=58.1134p pd=77.985u as=58.1134p ps=77.985u w=76.465u l=1u
X9089 DVDD GATE BAT DVDD pfet_06v0 ad=71.8771p pd=0.15481m as=58.1134p ps=77.985u w=76.465u l=1u
X9090 BAT GATE DVDD DVDD pfet_06v0 ad=35.511p pd=48.245u as=35.511p ps=48.245u w=46.725u l=1u
X9091 DVDD GATE BAT DVDD pfet_06v0 ad=71.8771p pd=0.15481m as=58.1134p ps=77.985u w=76.465u l=1u
X9092 DVDD GATE BAT DVDD pfet_06v0 ad=58.1134p pd=77.985u as=58.1134p ps=77.985u w=76.465u l=1u
X9093 DVDD GATE BAT DVDD pfet_06v0 ad=71.8771p pd=0.15481m as=58.1134p ps=77.985u w=76.465u l=1u
X9094 BAT GATE DVDD DVDD pfet_06v0 ad=58.1134p pd=77.985u as=58.1134p ps=77.985u w=76.465u l=1u
X9095 DVDD GATE BAT DVDD pfet_06v0 ad=49.3848p pd=66.5u as=49.3848p ps=66.5u w=64.98u l=1u
X9096 DVDD GATE BAT DVDD pfet_06v0 ad=35.511p pd=48.245u as=35.511p ps=48.245u w=46.725u l=1u
X9097 DVDD GATE BAT DVDD pfet_06v0 ad=58.0754p pd=77.935u as=58.0754p ps=77.935u w=76.41499u l=1u
X9098 DVDD GATE BAT DVDD pfet_06v0 ad=58.1134p pd=77.985u as=58.1134p ps=77.985u w=76.465u l=1u
X9099 DVDD GATE BAT DVDD pfet_06v0 ad=43.9215p pd=95.32999u as=35.511p ps=48.245u w=46.725u l=1u
X9100 BAT GATE DVDD DVDD pfet_06v0 ad=58.1134p pd=77.985u as=58.1134p ps=77.985u w=76.465u l=1u
X9101 DVDD GATE BAT DVDD pfet_06v0 ad=35.5072p pd=48.24u as=35.5072p ps=48.24u w=46.72u l=1u
X9102 DVDD GATE BAT DVDD pfet_06v0 ad=61.0812p pd=0.13184m as=49.3848p ps=66.5u w=64.98u l=1u
X9103 BAT GATE DVDD DVDD pfet_06v0 ad=58.1096p pd=77.98u as=58.1096p ps=77.98u w=76.46u l=1u
X9104 BAT GATE DVDD DVDD pfet_06v0 ad=58.1096p pd=77.98u as=71.8724p ps=0.1548m w=76.46u l=1u
X9105 BAT GATE DVDD DVDD pfet_06v0 ad=35.511p pd=48.245u as=35.511p ps=48.245u w=46.725u l=1u
X9106 DVDD GATE BAT DVDD pfet_06v0 ad=35.511p pd=48.245u as=35.511p ps=48.245u w=46.725u l=1u
X9107 DVDD GATE BAT DVDD pfet_06v0 ad=49.3848p pd=66.5u as=49.3848p ps=66.5u w=64.98u l=1u
X9108 BAT GATE DVDD DVDD pfet_06v0 ad=58.1134p pd=77.985u as=58.1134p ps=77.985u w=76.465u l=1u
X9109 DVDD GATE BAT DVDD pfet_06v0 ad=35.511p pd=48.245u as=35.511p ps=48.245u w=46.725u l=1u
X9110 BAT GATE DVDD DVDD pfet_06v0 ad=49.3848p pd=66.5u as=49.3848p ps=66.5u w=64.98u l=1u
X9111 DVDD GATE BAT DVDD pfet_06v0 ad=43.9215p pd=95.32999u as=35.511p ps=48.245u w=46.725u l=1u
X9112 BAT GATE DVDD DVDD pfet_06v0 ad=35.511p pd=48.245u as=43.9215p ps=95.32999u w=46.725u l=1u
X9113 DVDD GATE BAT DVDD pfet_06v0 ad=35.5072p pd=48.24u as=35.5072p ps=48.24u w=46.72u l=1u
X9114 DVDD GATE BAT DVDD pfet_06v0 ad=35.511p pd=48.245u as=35.511p ps=48.245u w=46.725u l=1u
X9115 BAT GATE DVDD DVDD pfet_06v0 ad=58.1552p pd=78.04u as=71.92879p ps=0.15492m w=76.52u l=1u
X9116 BAT GATE DVDD DVDD pfet_06v0 ad=35.511p pd=48.245u as=43.9215p ps=95.32999u w=46.725u l=1u
X9117 DVDD GATE BAT DVDD pfet_06v0 ad=47.6862p pd=64.265u as=47.6862p ps=64.265u w=62.745u l=1u
X9118 DVDD GATE BAT DVDD pfet_06v0 ad=58.1134p pd=77.985u as=58.1134p ps=77.985u w=76.465u l=1u
X9119 BAT GATE DVDD DVDD pfet_06v0 ad=35.511p pd=48.245u as=35.511p ps=48.245u w=46.725u l=1u
X9120 BAT GATE DVDD DVDD pfet_06v0 ad=47.6862p pd=64.265u as=47.6862p ps=64.265u w=62.745u l=1u
X9121 DVDD GATE BAT DVDD pfet_06v0 ad=35.511p pd=48.245u as=35.511p ps=48.245u w=46.725u l=1u
X9122 BAT GATE DVDD DVDD pfet_06v0 ad=35.511p pd=48.245u as=43.9215p ps=95.32999u w=46.725u l=1u
X9123 BAT GATE DVDD DVDD pfet_06v0 ad=35.5072p pd=48.24u as=43.9168p ps=95.32u w=46.72u l=1u
X9124 DVDD GATE BAT DVDD pfet_06v0 ad=58.1134p pd=77.985u as=58.1134p ps=77.985u w=76.465u l=1u
X9125 BAT GATE DVDD DVDD pfet_06v0 ad=58.1134p pd=77.985u as=58.1134p ps=77.985u w=76.465u l=1u
X9126 BAT GATE DVDD DVDD pfet_06v0 ad=35.511p pd=48.245u as=35.511p ps=48.245u w=46.725u l=1u
X9127 DVDD GATE BAT DVDD pfet_06v0 ad=35.511p pd=48.245u as=35.511p ps=48.245u w=46.725u l=1u
X9128 BAT GATE DVDD DVDD pfet_06v0 ad=35.511p pd=48.245u as=35.511p ps=48.245u w=46.725u l=1u
X9129 DVDD GATE BAT DVDD pfet_06v0 ad=71.8771p pd=0.15481m as=58.1134p ps=77.985u w=76.465u l=1u
X9130 DVDD GATE BAT DVDD pfet_06v0 ad=71.8771p pd=0.15481m as=58.1134p ps=77.985u w=76.465u l=1u
X9131 BAT GATE DVDD DVDD pfet_06v0 ad=58.0754p pd=77.935u as=58.0754p ps=77.935u w=76.41499u l=1u
X9132 DVDD GATE BAT DVDD pfet_06v0 ad=35.511p pd=48.245u as=35.511p ps=48.245u w=46.725u l=1u
X9133 DVDD GATE BAT DVDD pfet_06v0 ad=43.9215p pd=95.32999u as=35.511p ps=48.245u w=46.725u l=1u
X9134 BAT GATE DVDD DVDD pfet_06v0 ad=35.511p pd=48.245u as=35.511p ps=48.245u w=46.725u l=1u
X9135 BAT GATE DVDD DVDD pfet_06v0 ad=58.1134p pd=77.985u as=58.1134p ps=77.985u w=76.465u l=1u
X9136 DVDD GATE BAT DVDD pfet_06v0 ad=47.6862p pd=64.265u as=47.6862p ps=64.265u w=62.745u l=1u
X9137 DVDD GATE BAT DVDD pfet_06v0 ad=58.1096p pd=77.98u as=58.1096p ps=77.98u w=76.46u l=1u
X9138 DVDD GATE BAT DVDD pfet_06v0 ad=47.6862p pd=64.265u as=47.6862p ps=64.265u w=62.745u l=1u
X9139 BAT GATE DVDD DVDD pfet_06v0 ad=58.1134p pd=77.985u as=58.1134p ps=77.985u w=76.465u l=1u
X9140 DVDD GATE BAT DVDD pfet_06v0 ad=35.5072p pd=48.24u as=35.5072p ps=48.24u w=46.72u l=1u
X9141 DVDD GATE BAT DVDD pfet_06v0 ad=58.1134p pd=77.985u as=58.1134p ps=77.985u w=76.465u l=1u
X9142 BAT GATE DVDD DVDD pfet_06v0 ad=58.1134p pd=77.985u as=58.1134p ps=77.985u w=76.465u l=1u
X9143 BAT GATE DVDD DVDD pfet_06v0 ad=58.1134p pd=77.985u as=58.1134p ps=77.985u w=76.465u l=1u
X9144 DVDD GATE BAT DVDD pfet_06v0 ad=58.1552p pd=78.04u as=58.1552p ps=78.04u w=76.52u l=1u
X9145 DVDD GATE BAT DVDD pfet_06v0 ad=58.1096p pd=77.98u as=58.1096p ps=77.98u w=76.46u l=1u
X9146 BAT GATE DVDD DVDD pfet_06v0 ad=35.511p pd=48.245u as=43.9215p ps=95.32999u w=46.725u l=1u
X9147 DVDD GATE BAT DVDD pfet_06v0 ad=43.9215p pd=95.32999u as=35.511p ps=48.245u w=46.725u l=1u
X9148 DVDD GATE BAT DVDD pfet_06v0 ad=35.511p pd=48.245u as=35.511p ps=48.245u w=46.725u l=1u
X9149 BAT GATE DVDD DVDD pfet_06v0 ad=47.6862p pd=64.265u as=47.6862p ps=64.265u w=62.745u l=1u
X9150 DVDD GATE BAT DVDD pfet_06v0 ad=35.511p pd=48.245u as=35.511p ps=48.245u w=46.725u l=1u
X9151 BAT GATE DVDD DVDD pfet_06v0 ad=58.1134p pd=77.985u as=58.1134p ps=77.985u w=76.465u l=1u
X9152 BAT GATE DVDD DVDD pfet_06v0 ad=58.1172p pd=77.99u as=58.1172p ps=77.99u w=76.47u l=1u
X9153 BAT GATE DVDD DVDD pfet_06v0 ad=35.511p pd=48.245u as=35.511p ps=48.245u w=46.725u l=1u
X9154 BAT GATE DVDD DVDD pfet_06v0 ad=35.511p pd=48.245u as=35.511p ps=48.245u w=46.725u l=1u
X9155 BAT GATE DVDD DVDD pfet_06v0 ad=35.511p pd=48.245u as=43.9215p ps=95.32999u w=46.725u l=1u
X9156 DVDD GATE BAT DVDD pfet_06v0 ad=35.5072p pd=48.24u as=35.5072p ps=48.24u w=46.72u l=1u
X9157 BAT GATE DVDD DVDD pfet_06v0 ad=35.511p pd=48.245u as=35.511p ps=48.245u w=46.725u l=1u
X9158 DVDD GATE BAT DVDD pfet_06v0 ad=58.1134p pd=77.985u as=58.1134p ps=77.985u w=76.465u l=1u
X9159 DVDD GATE BAT DVDD pfet_06v0 ad=71.8771p pd=0.15481m as=58.1134p ps=77.985u w=76.465u l=1u
X9160 DVDD GATE BAT DVDD pfet_06v0 ad=58.1172p pd=77.99u as=58.1172p ps=77.99u w=76.47u l=1u
X9161 BAT GATE DVDD DVDD pfet_06v0 ad=58.0754p pd=77.935u as=58.0754p ps=77.935u w=76.41499u l=1u
X9162 BAT GATE DVDD DVDD pfet_06v0 ad=58.1134p pd=77.985u as=71.8771p ps=0.15481m w=76.465u l=1u
X9163 BAT GATE DVDD DVDD pfet_06v0 ad=58.1134p pd=77.985u as=58.1134p ps=77.985u w=76.465u l=1u
X9164 BAT GATE DVDD DVDD pfet_06v0 ad=47.6862p pd=64.265u as=47.6862p ps=64.265u w=62.745u l=1u
X9165 BAT GATE DVDD DVDD pfet_06v0 ad=35.511p pd=48.245u as=35.511p ps=48.245u w=46.725u l=1u
X9166 DVDD GATE BAT DVDD pfet_06v0 ad=58.1134p pd=77.985u as=58.1134p ps=77.985u w=76.465u l=1u
X9167 BAT GATE DVDD DVDD pfet_06v0 ad=58.1134p pd=77.985u as=71.8771p ps=0.15481m w=76.465u l=1u
X9168 BAT GATE DVDD DVDD pfet_06v0 ad=58.1134p pd=77.985u as=58.1134p ps=77.985u w=76.465u l=1u
X9169 BAT GATE DVDD DVDD pfet_06v0 ad=35.511p pd=48.245u as=35.511p ps=48.245u w=46.725u l=1u
X9170 BAT GATE DVDD DVDD pfet_06v0 ad=49.3848p pd=66.5u as=49.3848p ps=66.5u w=64.98u l=1u
X9171 BAT GATE DVDD DVDD pfet_06v0 ad=58.1134p pd=77.985u as=58.1134p ps=77.985u w=76.465u l=1u
X9172 BAT GATE DVDD DVDD pfet_06v0 ad=58.1134p pd=77.985u as=58.1134p ps=77.985u w=76.465u l=1u
X9173 DVDD GATE BAT DVDD pfet_06v0 ad=35.511p pd=48.245u as=35.511p ps=48.245u w=46.725u l=1u
X9174 DVDD GATE BAT DVDD pfet_06v0 ad=61.0812p pd=0.13184m as=49.3848p ps=66.5u w=64.98u l=1u
X9175 DVDD GATE BAT DVDD pfet_06v0 ad=43.9215p pd=95.32999u as=35.511p ps=48.245u w=46.725u l=1u
X9176 DVDD GATE BAT DVDD pfet_06v0 ad=71.8771p pd=0.15481m as=58.1134p ps=77.985u w=76.465u l=1u
X9177 DVDD GATE BAT DVDD pfet_06v0 ad=58.1134p pd=77.985u as=58.1134p ps=77.985u w=76.465u l=1u
X9178 DVDD GATE BAT DVDD pfet_06v0 ad=43.9215p pd=95.32999u as=35.511p ps=48.245u w=46.725u l=1u
X9179 DVDD GATE BAT DVDD pfet_06v0 ad=58.1134p pd=77.985u as=58.1134p ps=77.985u w=76.465u l=1u
X9180 DVDD GATE BAT DVDD pfet_06v0 ad=58.1096p pd=77.98u as=58.1096p ps=77.98u w=76.46u l=1u
X9181 DVDD GATE BAT DVDD pfet_06v0 ad=49.3848p pd=66.5u as=49.3848p ps=66.5u w=64.98u l=1u
X9182 DVDD GATE BAT DVDD pfet_06v0 ad=58.1134p pd=77.985u as=58.1134p ps=77.985u w=76.465u l=1u
X9183 DVDD GATE BAT DVDD pfet_06v0 ad=35.511p pd=48.245u as=35.511p ps=48.245u w=46.725u l=1u
X9184 DVDD GATE BAT DVDD pfet_06v0 ad=35.511p pd=48.245u as=35.511p ps=48.245u w=46.725u l=1u
X9185 DVDD GATE BAT DVDD pfet_06v0 ad=35.511p pd=48.245u as=35.511p ps=48.245u w=46.725u l=1u
X9186 DVDD GATE BAT DVDD pfet_06v0 ad=58.1552p pd=78.04u as=58.1552p ps=78.04u w=76.52u l=1u
X9187 DVDD GATE BAT DVDD pfet_06v0 ad=71.92879p pd=0.15492m as=58.1552p ps=78.04u w=76.52u l=1u
X9188 BAT GATE DVDD DVDD pfet_06v0 ad=58.1172p pd=77.99u as=58.1172p ps=77.99u w=76.47u l=1u
X9189 BAT GATE DVDD DVDD pfet_06v0 ad=58.1134p pd=77.985u as=58.1134p ps=77.985u w=76.465u l=1u
X9190 BAT GATE DVDD DVDD pfet_06v0 ad=58.1134p pd=77.985u as=58.1134p ps=77.985u w=76.465u l=1u
X9191 BAT GATE DVDD DVDD pfet_06v0 ad=35.511p pd=48.245u as=43.9215p ps=95.32999u w=46.725u l=1u
X9192 BAT GATE DVDD DVDD pfet_06v0 ad=58.1552p pd=78.04u as=58.1552p ps=78.04u w=76.52u l=1u
X9193 DVDD GATE BAT DVDD pfet_06v0 ad=58.1172p pd=77.99u as=58.1172p ps=77.99u w=76.47u l=1u
X9194 DVDD GATE BAT DVDD pfet_06v0 ad=61.0812p pd=0.13184m as=49.3848p ps=66.5u w=64.98u l=1u
X9195 BAT GATE DVDD DVDD pfet_06v0 ad=35.511p pd=48.245u as=35.511p ps=48.245u w=46.725u l=1u
X9196 DVDD GATE BAT DVDD pfet_06v0 ad=35.5072p pd=48.24u as=35.5072p ps=48.24u w=46.72u l=1u
X9197 DVDD GATE BAT DVDD pfet_06v0 ad=35.511p pd=48.245u as=35.511p ps=48.245u w=46.725u l=1u
X9198 DVDD GATE BAT DVDD pfet_06v0 ad=35.511p pd=48.245u as=35.511p ps=48.245u w=46.725u l=1u
X9199 BAT GATE DVDD DVDD pfet_06v0 ad=49.3848p pd=66.5u as=49.3848p ps=66.5u w=64.98u l=1u
X9200 DVDD GATE BAT DVDD pfet_06v0 ad=58.1134p pd=77.985u as=58.1134p ps=77.985u w=76.465u l=1u
X9201 BAT GATE DVDD DVDD pfet_06v0 ad=58.1134p pd=77.985u as=58.1134p ps=77.985u w=76.465u l=1u
X9202 BAT GATE DVDD DVDD pfet_06v0 ad=35.511p pd=48.245u as=35.511p ps=48.245u w=46.725u l=1u
X9203 BAT GATE DVDD DVDD pfet_06v0 ad=58.1134p pd=77.985u as=58.1134p ps=77.985u w=76.465u l=1u
X9204 BAT GATE DVDD DVDD pfet_06v0 ad=58.1134p pd=77.985u as=58.1134p ps=77.985u w=76.465u l=1u
X9205 BAT GATE DVDD DVDD pfet_06v0 ad=35.511p pd=48.245u as=43.9215p ps=95.32999u w=46.725u l=1u
X9206 DVDD GATE BAT DVDD pfet_06v0 ad=58.1134p pd=77.985u as=58.1134p ps=77.985u w=76.465u l=1u
X9207 DVDD GATE BAT DVDD pfet_06v0 ad=58.1134p pd=77.985u as=58.1134p ps=77.985u w=76.465u l=1u
X9208 BAT GATE DVDD DVDD pfet_06v0 ad=58.0754p pd=77.935u as=71.8301p ps=0.15471m w=76.41499u l=1u
X9209 DVDD GATE BAT DVDD pfet_06v0 ad=58.1134p pd=77.985u as=58.1134p ps=77.985u w=76.465u l=1u
X9210 DVDD GATE BAT DVDD pfet_06v0 ad=58.1552p pd=78.04u as=58.1552p ps=78.04u w=76.52u l=1u
X9211 DVDD GATE BAT DVDD pfet_06v0 ad=35.511p pd=48.245u as=35.511p ps=48.245u w=46.725u l=1u
X9212 DVDD GATE BAT DVDD pfet_06v0 ad=35.511p pd=48.245u as=35.511p ps=48.245u w=46.725u l=1u
X9213 DVDD GATE BAT DVDD pfet_06v0 ad=71.8771p pd=0.15481m as=58.1134p ps=77.985u w=76.465u l=1u
X9214 BAT GATE DVDD DVDD pfet_06v0 ad=49.3848p pd=66.5u as=49.3848p ps=66.5u w=64.98u l=1u
X9215 BAT GATE DVDD DVDD pfet_06v0 ad=35.511p pd=48.245u as=35.511p ps=48.245u w=46.725u l=1u
X9216 DVDD GATE BAT DVDD pfet_06v0 ad=43.9215p pd=95.32999u as=35.511p ps=48.245u w=46.725u l=1u
X9217 BAT GATE DVDD DVDD pfet_06v0 ad=49.3848p pd=66.5u as=49.3848p ps=66.5u w=64.98u l=1u
X9218 DVDD GATE BAT DVDD pfet_06v0 ad=58.1134p pd=77.985u as=58.1134p ps=77.985u w=76.465u l=1u
X9219 DVDD GATE BAT DVDD pfet_06v0 ad=58.1134p pd=77.985u as=58.1134p ps=77.985u w=76.465u l=1u
X9220 DVDD GATE BAT DVDD pfet_06v0 ad=47.6862p pd=64.265u as=47.6862p ps=64.265u w=62.745u l=1u
X9221 BAT GATE DVDD DVDD pfet_06v0 ad=58.1134p pd=77.985u as=71.8771p ps=0.15481m w=76.465u l=1u
X9222 BAT GATE DVDD DVDD pfet_06v0 ad=47.6862p pd=64.265u as=47.6862p ps=64.265u w=62.745u l=1u
X9223 BAT GATE DVDD DVDD pfet_06v0 ad=35.511p pd=48.245u as=43.9215p ps=95.32999u w=46.725u l=1u
X9224 DVDD GATE BAT DVDD pfet_06v0 ad=58.1134p pd=77.985u as=58.1134p ps=77.985u w=76.465u l=1u
X9225 BAT GATE DVDD DVDD pfet_06v0 ad=58.1134p pd=77.985u as=71.8771p ps=0.15481m w=76.465u l=1u
X9226 BAT GATE DVDD DVDD pfet_06v0 ad=35.511p pd=48.245u as=35.511p ps=48.245u w=46.725u l=1u
X9227 DVDD GATE BAT DVDD pfet_06v0 ad=35.511p pd=48.245u as=35.511p ps=48.245u w=46.725u l=1u
X9228 BAT GATE DVDD DVDD pfet_06v0 ad=35.511p pd=48.245u as=35.511p ps=48.245u w=46.725u l=1u
X9229 BAT GATE DVDD DVDD pfet_06v0 ad=58.1134p pd=77.985u as=58.1134p ps=77.985u w=76.465u l=1u
X9230 DVDD GATE BAT DVDD pfet_06v0 ad=35.511p pd=48.245u as=35.511p ps=48.245u w=46.725u l=1u
X9231 BAT GATE DVDD DVDD pfet_06v0 ad=35.511p pd=48.245u as=35.511p ps=48.245u w=46.725u l=1u
X9232 DVDD GATE BAT DVDD pfet_06v0 ad=58.1134p pd=77.985u as=58.1134p ps=77.985u w=76.465u l=1u
X9233 BAT GATE DVDD DVDD pfet_06v0 ad=47.6862p pd=64.265u as=47.6862p ps=64.265u w=62.745u l=1u
X9234 DVDD GATE BAT DVDD pfet_06v0 ad=58.0754p pd=77.935u as=58.0754p ps=77.935u w=76.41499u l=1u
X9235 BAT GATE DVDD DVDD pfet_06v0 ad=58.1096p pd=77.98u as=58.1096p ps=77.98u w=76.46u l=1u
X9236 BAT GATE DVDD DVDD pfet_06v0 ad=58.1134p pd=77.985u as=58.1134p ps=77.985u w=76.465u l=1u
X9237 BAT GATE DVDD DVDD pfet_06v0 ad=58.0754p pd=77.935u as=71.8301p ps=0.15471m w=76.41499u l=1u
X9238 DVDD GATE BAT DVDD pfet_06v0 ad=35.511p pd=48.245u as=35.511p ps=48.245u w=46.725u l=1u
X9239 BAT GATE DVDD DVDD pfet_06v0 ad=35.511p pd=48.245u as=35.511p ps=48.245u w=46.725u l=1u
X9240 DVDD GATE BAT DVDD pfet_06v0 ad=43.9168p pd=95.32u as=35.5072p ps=48.24u w=46.72u l=1u
X9241 DVDD GATE BAT DVDD pfet_06v0 ad=71.8771p pd=0.15481m as=58.1134p ps=77.985u w=76.465u l=1u
X9242 DVDD GATE BAT DVDD pfet_06v0 ad=35.511p pd=48.245u as=35.511p ps=48.245u w=46.725u l=1u
X9243 DVDD GATE BAT DVDD pfet_06v0 ad=58.0754p pd=77.935u as=58.0754p ps=77.935u w=76.41499u l=1u
X9244 DVDD GATE BAT DVDD pfet_06v0 ad=35.511p pd=48.245u as=35.511p ps=48.245u w=46.725u l=1u
X9245 DVDD GATE BAT DVDD pfet_06v0 ad=58.1134p pd=77.985u as=58.1134p ps=77.985u w=76.465u l=1u
X9246 BAT GATE DVDD DVDD pfet_06v0 ad=35.511p pd=48.245u as=35.511p ps=48.245u w=46.725u l=1u
X9247 DVDD GATE BAT DVDD pfet_06v0 ad=35.511p pd=48.245u as=35.511p ps=48.245u w=46.725u l=1u
X9248 DVDD GATE BAT DVDD pfet_06v0 ad=35.511p pd=48.245u as=35.511p ps=48.245u w=46.725u l=1u
X9249 DVDD GATE BAT DVDD pfet_06v0 ad=58.1134p pd=77.985u as=58.1134p ps=77.985u w=76.465u l=1u
X9250 DVDD GATE BAT DVDD pfet_06v0 ad=35.511p pd=48.245u as=35.511p ps=48.245u w=46.725u l=1u
X9251 BAT GATE DVDD DVDD pfet_06v0 ad=58.1096p pd=77.98u as=71.8724p ps=0.1548m w=76.46u l=1u
X9252 DVDD GATE BAT DVDD pfet_06v0 ad=47.6862p pd=64.265u as=47.6862p ps=64.265u w=62.745u l=1u
X9253 BAT GATE DVDD DVDD pfet_06v0 ad=58.1134p pd=77.985u as=71.8771p ps=0.15481m w=76.465u l=1u
X9254 DVDD GATE BAT DVDD pfet_06v0 ad=35.5072p pd=48.24u as=35.5072p ps=48.24u w=46.72u l=1u
X9255 BAT GATE DVDD DVDD pfet_06v0 ad=35.511p pd=48.245u as=43.9215p ps=95.32999u w=46.725u l=1u
X9256 DVDD GATE BAT DVDD pfet_06v0 ad=35.511p pd=48.245u as=35.511p ps=48.245u w=46.725u l=1u
X9257 BAT GATE DVDD DVDD pfet_06v0 ad=35.511p pd=48.245u as=35.511p ps=48.245u w=46.725u l=1u
X9258 BAT GATE DVDD DVDD pfet_06v0 ad=58.1134p pd=77.985u as=58.1134p ps=77.985u w=76.465u l=1u
X9259 BAT GATE DVDD DVDD pfet_06v0 ad=35.511p pd=48.245u as=35.511p ps=48.245u w=46.725u l=1u
X9260 DVDD GATE BAT DVDD pfet_06v0 ad=58.1096p pd=77.98u as=58.1096p ps=77.98u w=76.46u l=1u
X9261 DVDD GATE BAT DVDD pfet_06v0 ad=58.1552p pd=78.04u as=58.1552p ps=78.04u w=76.52u l=1u
X9262 BAT GATE DVDD DVDD pfet_06v0 ad=35.511p pd=48.245u as=35.511p ps=48.245u w=46.725u l=1u
X9263 BAT GATE DVDD DVDD pfet_06v0 ad=58.1552p pd=78.04u as=58.1552p ps=78.04u w=76.52u l=1u
X9264 DVDD GATE BAT DVDD pfet_06v0 ad=71.92879p pd=0.15492m as=58.1552p ps=78.04u w=76.52u l=1u
X9265 DVDD GATE BAT DVDD pfet_06v0 ad=58.0754p pd=77.935u as=58.0754p ps=77.935u w=76.41499u l=1u
X9266 BAT GATE DVDD DVDD pfet_06v0 ad=35.511p pd=48.245u as=35.511p ps=48.245u w=46.725u l=1u
X9267 DVDD GATE BAT DVDD pfet_06v0 ad=58.1134p pd=77.985u as=58.1134p ps=77.985u w=76.465u l=1u
X9268 BAT GATE DVDD DVDD pfet_06v0 ad=35.511p pd=48.245u as=35.511p ps=48.245u w=46.725u l=1u
X9269 BAT GATE DVDD DVDD pfet_06v0 ad=35.511p pd=48.245u as=35.511p ps=48.245u w=46.725u l=1u
X9270 DVDD GATE BAT DVDD pfet_06v0 ad=35.511p pd=48.245u as=35.511p ps=48.245u w=46.725u l=1u
X9271 BAT GATE DVDD DVDD pfet_06v0 ad=58.1552p pd=78.04u as=58.1552p ps=78.04u w=76.52u l=1u
X9272 BAT GATE DVDD DVDD pfet_06v0 ad=58.1134p pd=77.985u as=58.1134p ps=77.985u w=76.465u l=1u
X9273 DVDD GATE BAT DVDD pfet_06v0 ad=58.1134p pd=77.985u as=58.1134p ps=77.985u w=76.465u l=1u
X9274 BAT GATE DVDD DVDD pfet_06v0 ad=58.1134p pd=77.985u as=58.1134p ps=77.985u w=76.465u l=1u
X9275 BAT GATE DVDD DVDD pfet_06v0 ad=49.3848p pd=66.5u as=49.3848p ps=66.5u w=64.98u l=1u
X9276 DVDD GATE BAT DVDD pfet_06v0 ad=43.9215p pd=95.32999u as=35.511p ps=48.245u w=46.725u l=1u
X9277 BAT GATE DVDD DVDD pfet_06v0 ad=35.511p pd=48.245u as=35.511p ps=48.245u w=46.725u l=1u
X9278 DVDD GATE BAT DVDD pfet_06v0 ad=43.9215p pd=95.32999u as=35.511p ps=48.245u w=46.725u l=1u
X9279 DVDD GATE BAT DVDD pfet_06v0 ad=58.1134p pd=77.985u as=58.1134p ps=77.985u w=76.465u l=1u
X9280 DVDD GATE BAT DVDD pfet_06v0 ad=58.1134p pd=77.985u as=58.1134p ps=77.985u w=76.465u l=1u
X9281 DVDD GATE BAT DVDD pfet_06v0 ad=58.1134p pd=77.985u as=58.1134p ps=77.985u w=76.465u l=1u
X9282 BAT GATE DVDD DVDD pfet_06v0 ad=35.511p pd=48.245u as=35.511p ps=48.245u w=46.725u l=1u
X9283 DVDD GATE BAT DVDD pfet_06v0 ad=58.1134p pd=77.985u as=58.1134p ps=77.985u w=76.465u l=1u
X9284 BAT GATE DVDD DVDD pfet_06v0 ad=49.3848p pd=66.5u as=61.0812p ps=0.13184m w=64.98u l=1u
X9285 DVDD GATE BAT DVDD pfet_06v0 ad=58.1172p pd=77.99u as=58.1172p ps=77.99u w=76.47u l=1u
X9286 BAT GATE DVDD DVDD pfet_06v0 ad=35.511p pd=48.245u as=35.511p ps=48.245u w=46.725u l=1u
X9287 DVDD GATE BAT DVDD pfet_06v0 ad=58.1134p pd=77.985u as=58.1134p ps=77.985u w=76.465u l=1u
X9288 BAT GATE DVDD DVDD pfet_06v0 ad=58.1172p pd=77.99u as=71.8818p ps=0.15482m w=76.47u l=1u
X9289 DVDD GATE BAT DVDD pfet_06v0 ad=35.511p pd=48.245u as=35.511p ps=48.245u w=46.725u l=1u
X9290 BAT GATE DVDD DVDD pfet_06v0 ad=35.511p pd=48.245u as=43.9215p ps=95.32999u w=46.725u l=1u
X9291 DVDD GATE BAT DVDD pfet_06v0 ad=71.8771p pd=0.15481m as=58.1134p ps=77.985u w=76.465u l=1u
X9292 BAT GATE DVDD DVDD pfet_06v0 ad=35.511p pd=48.245u as=43.9215p ps=95.32999u w=46.725u l=1u
X9293 DVDD GATE BAT DVDD pfet_06v0 ad=58.1134p pd=77.985u as=58.1134p ps=77.985u w=76.465u l=1u
X9294 BAT GATE DVDD DVDD pfet_06v0 ad=35.511p pd=48.245u as=35.511p ps=48.245u w=46.725u l=1u
X9295 DVDD GATE BAT DVDD pfet_06v0 ad=58.1552p pd=78.04u as=58.1552p ps=78.04u w=76.52u l=1u
X9296 BAT GATE DVDD DVDD pfet_06v0 ad=58.1134p pd=77.985u as=58.1134p ps=77.985u w=76.465u l=1u
X9297 DVDD GATE BAT DVDD pfet_06v0 ad=58.1134p pd=77.985u as=58.1134p ps=77.985u w=76.465u l=1u
X9298 DVDD GATE BAT DVDD pfet_06v0 ad=35.511p pd=48.245u as=35.511p ps=48.245u w=46.725u l=1u
X9299 BAT GATE DVDD DVDD pfet_06v0 ad=58.1134p pd=77.985u as=58.1134p ps=77.985u w=76.465u l=1u
X9300 BAT GATE DVDD DVDD pfet_06v0 ad=35.511p pd=48.245u as=35.511p ps=48.245u w=46.725u l=1u
X9301 BAT GATE DVDD DVDD pfet_06v0 ad=35.511p pd=48.245u as=35.511p ps=48.245u w=46.725u l=1u
X9302 BAT GATE DVDD DVDD pfet_06v0 ad=58.1134p pd=77.985u as=71.8771p ps=0.15481m w=76.465u l=1u
X9303 BAT GATE DVDD DVDD pfet_06v0 ad=35.5072p pd=48.24u as=35.5072p ps=48.24u w=46.72u l=1u
X9304 BAT GATE DVDD DVDD pfet_06v0 ad=49.3848p pd=66.5u as=49.3848p ps=66.5u w=64.98u l=1u
X9305 DVDD GATE BAT DVDD pfet_06v0 ad=58.1096p pd=77.98u as=58.1096p ps=77.98u w=76.46u l=1u
X9306 BAT GATE DVDD DVDD pfet_06v0 ad=58.1134p pd=77.985u as=71.8771p ps=0.15481m w=76.465u l=1u
X9307 DVDD GATE BAT DVDD pfet_06v0 ad=58.0754p pd=77.935u as=58.0754p ps=77.935u w=76.41499u l=1u
X9308 BAT GATE DVDD DVDD pfet_06v0 ad=35.511p pd=48.245u as=35.511p ps=48.245u w=46.725u l=1u
X9309 BAT GATE DVDD DVDD pfet_06v0 ad=58.1552p pd=78.04u as=58.1552p ps=78.04u w=76.52u l=1u
X9310 BAT GATE DVDD DVDD pfet_06v0 ad=35.511p pd=48.245u as=35.511p ps=48.245u w=46.725u l=1u
X9311 BAT GATE DVDD DVDD pfet_06v0 ad=58.1134p pd=77.985u as=58.1134p ps=77.985u w=76.465u l=1u
X9312 DVDD GATE BAT DVDD pfet_06v0 ad=43.9168p pd=95.32u as=35.5072p ps=48.24u w=46.72u l=1u
X9313 BAT GATE DVDD DVDD pfet_06v0 ad=35.511p pd=48.245u as=35.511p ps=48.245u w=46.725u l=1u
X9314 BAT GATE DVDD DVDD pfet_06v0 ad=35.511p pd=48.245u as=35.511p ps=48.245u w=46.725u l=1u
X9315 BAT GATE DVDD DVDD pfet_06v0 ad=58.1134p pd=77.985u as=58.1134p ps=77.985u w=76.465u l=1u
X9316 BAT GATE DVDD DVDD pfet_06v0 ad=58.1134p pd=77.985u as=58.1134p ps=77.985u w=76.465u l=1u
X9317 BAT GATE DVDD DVDD pfet_06v0 ad=58.1134p pd=77.985u as=58.1134p ps=77.985u w=76.465u l=1u
X9318 BAT GATE DVDD DVDD pfet_06v0 ad=58.1552p pd=78.04u as=58.1552p ps=78.04u w=76.52u l=1u
X9319 DVDD GATE BAT DVDD pfet_06v0 ad=43.9215p pd=95.32999u as=35.511p ps=48.245u w=46.725u l=1u
X9320 BAT GATE DVDD DVDD pfet_06v0 ad=49.3848p pd=66.5u as=61.0812p ps=0.13184m w=64.98u l=1u
X9321 DVDD GATE BAT DVDD pfet_06v0 ad=35.511p pd=48.245u as=35.511p ps=48.245u w=46.725u l=1u
X9322 BAT GATE DVDD DVDD pfet_06v0 ad=35.511p pd=48.245u as=43.9215p ps=95.32999u w=46.725u l=1u
X9323 BAT GATE DVDD DVDD pfet_06v0 ad=35.511p pd=48.245u as=35.511p ps=48.245u w=46.725u l=1u
X9324 DVDD GATE BAT DVDD pfet_06v0 ad=58.1134p pd=77.985u as=58.1134p ps=77.985u w=76.465u l=1u
X9325 DVDD GATE BAT DVDD pfet_06v0 ad=58.1096p pd=77.98u as=58.1096p ps=77.98u w=76.46u l=1u
X9326 DVDD GATE BAT DVDD pfet_06v0 ad=58.1134p pd=77.985u as=58.1134p ps=77.985u w=76.465u l=1u
X9327 DVDD GATE BAT DVDD pfet_06v0 ad=58.1134p pd=77.985u as=58.1134p ps=77.985u w=76.465u l=1u
X9328 BAT GATE DVDD DVDD pfet_06v0 ad=35.511p pd=48.245u as=35.511p ps=48.245u w=46.725u l=1u
X9329 DVDD GATE BAT DVDD pfet_06v0 ad=35.511p pd=48.245u as=35.511p ps=48.245u w=46.725u l=1u
X9330 BAT GATE DVDD DVDD pfet_06v0 ad=35.511p pd=48.245u as=35.511p ps=48.245u w=46.725u l=1u
X9331 BAT GATE DVDD DVDD pfet_06v0 ad=35.5072p pd=48.24u as=35.5072p ps=48.24u w=46.72u l=1u
X9332 BAT GATE DVDD DVDD pfet_06v0 ad=58.0754p pd=77.935u as=58.0754p ps=77.935u w=76.41499u l=1u
X9333 BAT GATE DVDD DVDD pfet_06v0 ad=58.0754p pd=77.935u as=58.0754p ps=77.935u w=76.41499u l=1u
X9334 DVDD GATE BAT DVDD pfet_06v0 ad=58.1134p pd=77.985u as=58.1134p ps=77.985u w=76.465u l=1u
X9335 DVDD GATE BAT DVDD pfet_06v0 ad=43.9215p pd=95.32999u as=35.511p ps=48.245u w=46.725u l=1u
X9336 BAT GATE DVDD DVDD pfet_06v0 ad=58.0754p pd=77.935u as=58.0754p ps=77.935u w=76.41499u l=1u
X9337 BAT GATE DVDD DVDD pfet_06v0 ad=35.511p pd=48.245u as=35.511p ps=48.245u w=46.725u l=1u
X9338 DVDD GATE BAT DVDD pfet_06v0 ad=35.511p pd=48.245u as=35.511p ps=48.245u w=46.725u l=1u
X9339 DVDD GATE BAT DVDD pfet_06v0 ad=47.6862p pd=64.265u as=47.6862p ps=64.265u w=62.745u l=1u
X9340 BAT GATE DVDD DVDD pfet_06v0 ad=58.1134p pd=77.985u as=58.1134p ps=77.985u w=76.465u l=1u
X9341 DVDD GATE BAT DVDD pfet_06v0 ad=58.0754p pd=77.935u as=58.0754p ps=77.935u w=76.41499u l=1u
X9342 BAT GATE DVDD DVDD pfet_06v0 ad=35.511p pd=48.245u as=35.511p ps=48.245u w=46.725u l=1u
X9343 BAT GATE DVDD DVDD pfet_06v0 ad=35.511p pd=48.245u as=35.511p ps=48.245u w=46.725u l=1u
X9344 BAT GATE DVDD DVDD pfet_06v0 ad=58.1134p pd=77.985u as=58.1134p ps=77.985u w=76.465u l=1u
X9345 DVDD GATE BAT DVDD pfet_06v0 ad=35.511p pd=48.245u as=35.511p ps=48.245u w=46.725u l=1u
X9346 DVDD GATE BAT DVDD pfet_06v0 ad=49.3848p pd=66.5u as=49.3848p ps=66.5u w=64.98u l=1u
X9347 BAT GATE DVDD DVDD pfet_06v0 ad=35.511p pd=48.245u as=35.511p ps=48.245u w=46.725u l=1u
X9348 BAT GATE DVDD DVDD pfet_06v0 ad=35.511p pd=48.245u as=35.511p ps=48.245u w=46.725u l=1u
X9349 DVDD GATE BAT DVDD pfet_06v0 ad=58.1134p pd=77.985u as=58.1134p ps=77.985u w=76.465u l=1u
X9350 BAT GATE DVDD DVDD pfet_06v0 ad=35.511p pd=48.245u as=35.511p ps=48.245u w=46.725u l=1u
X9351 DVDD GATE BAT DVDD pfet_06v0 ad=58.1172p pd=77.99u as=58.1172p ps=77.99u w=76.47u l=1u
X9352 BAT GATE DVDD DVDD pfet_06v0 ad=58.1134p pd=77.985u as=58.1134p ps=77.985u w=76.465u l=1u
X9353 BAT GATE DVDD DVDD pfet_06v0 ad=35.511p pd=48.245u as=35.511p ps=48.245u w=46.725u l=1u
X9354 DVDD GATE BAT DVDD pfet_06v0 ad=43.9215p pd=95.32999u as=35.511p ps=48.245u w=46.725u l=1u
X9355 DVDD GATE BAT DVDD pfet_06v0 ad=58.1552p pd=78.04u as=58.1552p ps=78.04u w=76.52u l=1u
X9356 DVDD GATE BAT DVDD pfet_06v0 ad=35.5072p pd=48.24u as=35.5072p ps=48.24u w=46.72u l=1u
X9357 DVDD GATE BAT DVDD pfet_06v0 ad=43.9215p pd=95.32999u as=35.511p ps=48.245u w=46.725u l=1u
X9358 BAT GATE DVDD DVDD pfet_06v0 ad=58.1552p pd=78.04u as=58.1552p ps=78.04u w=76.52u l=1u
X9359 BAT GATE DVDD DVDD pfet_06v0 ad=58.1096p pd=77.98u as=58.1096p ps=77.98u w=76.46u l=1u
X9360 DVDD GATE BAT DVDD pfet_06v0 ad=47.6862p pd=64.265u as=47.6862p ps=64.265u w=62.745u l=1u
X9361 BAT GATE DVDD DVDD pfet_06v0 ad=35.5072p pd=48.24u as=43.9168p ps=95.32u w=46.72u l=1u
X9362 DVDD GATE BAT DVDD pfet_06v0 ad=35.511p pd=48.245u as=35.511p ps=48.245u w=46.725u l=1u
X9363 BAT GATE DVDD DVDD pfet_06v0 ad=58.1134p pd=77.985u as=58.1134p ps=77.985u w=76.465u l=1u
X9364 DVDD GATE BAT DVDD pfet_06v0 ad=58.1134p pd=77.985u as=58.1134p ps=77.985u w=76.465u l=1u
X9365 BAT GATE DVDD DVDD pfet_06v0 ad=58.1134p pd=77.985u as=58.1134p ps=77.985u w=76.465u l=1u
X9366 BAT GATE DVDD DVDD pfet_06v0 ad=58.1552p pd=78.04u as=58.1552p ps=78.04u w=76.52u l=1u
X9367 BAT GATE DVDD DVDD pfet_06v0 ad=35.511p pd=48.245u as=35.511p ps=48.245u w=46.725u l=1u
X9368 DVDD GATE BAT DVDD pfet_06v0 ad=35.511p pd=48.245u as=35.511p ps=48.245u w=46.725u l=1u
X9369 BAT GATE DVDD DVDD pfet_06v0 ad=35.5072p pd=48.24u as=35.5072p ps=48.24u w=46.72u l=1u
X9370 DVDD GATE BAT DVDD pfet_06v0 ad=58.1134p pd=77.985u as=58.1134p ps=77.985u w=76.465u l=1u
X9371 BAT GATE DVDD DVDD pfet_06v0 ad=58.1552p pd=78.04u as=58.1552p ps=78.04u w=76.52u l=1u
X9372 BAT GATE DVDD DVDD pfet_06v0 ad=58.0754p pd=77.935u as=58.0754p ps=77.935u w=76.41499u l=1u
X9373 DVDD GATE BAT DVDD pfet_06v0 ad=35.511p pd=48.245u as=35.511p ps=48.245u w=46.725u l=1u
X9374 DVDD GATE BAT DVDD pfet_06v0 ad=58.1552p pd=78.04u as=58.1552p ps=78.04u w=76.52u l=1u
X9375 BAT GATE DVDD DVDD pfet_06v0 ad=35.5072p pd=48.24u as=35.5072p ps=48.24u w=46.72u l=1u
X9376 BAT GATE DVDD DVDD pfet_06v0 ad=58.1172p pd=77.99u as=71.8818p ps=0.15482m w=76.47u l=1u
X9377 BAT GATE DVDD DVDD pfet_06v0 ad=58.1134p pd=77.985u as=58.1134p ps=77.985u w=76.465u l=1u
X9378 BAT GATE DVDD DVDD pfet_06v0 ad=35.511p pd=48.245u as=35.511p ps=48.245u w=46.725u l=1u
X9379 DVDD GATE BAT DVDD pfet_06v0 ad=47.6862p pd=64.265u as=47.6862p ps=64.265u w=62.745u l=1u
X9380 BAT GATE DVDD DVDD pfet_06v0 ad=58.1134p pd=77.985u as=58.1134p ps=77.985u w=76.465u l=1u
X9381 DVDD GATE BAT DVDD pfet_06v0 ad=58.1134p pd=77.985u as=58.1134p ps=77.985u w=76.465u l=1u
X9382 DVDD GATE BAT DVDD pfet_06v0 ad=47.6862p pd=64.265u as=47.6862p ps=64.265u w=62.745u l=1u
X9383 BAT GATE DVDD DVDD pfet_06v0 ad=58.1134p pd=77.985u as=71.8771p ps=0.15481m w=76.465u l=1u
X9384 BAT GATE DVDD DVDD pfet_06v0 ad=58.1134p pd=77.985u as=58.1134p ps=77.985u w=76.465u l=1u
X9385 DVDD GATE BAT DVDD pfet_06v0 ad=71.92879p pd=0.15492m as=58.1552p ps=78.04u w=76.52u l=1u
X9386 DVDD GATE BAT DVDD pfet_06v0 ad=58.1134p pd=77.985u as=58.1134p ps=77.985u w=76.465u l=1u
X9387 DVDD GATE BAT DVDD pfet_06v0 ad=58.1172p pd=77.99u as=58.1172p ps=77.99u w=76.47u l=1u
X9388 DVDD GATE BAT DVDD pfet_06v0 ad=43.9215p pd=95.32999u as=35.511p ps=48.245u w=46.725u l=1u
X9389 BAT GATE DVDD DVDD pfet_06v0 ad=58.1134p pd=77.985u as=58.1134p ps=77.985u w=76.465u l=1u
X9390 DVDD GATE BAT DVDD pfet_06v0 ad=49.3848p pd=66.5u as=49.3848p ps=66.5u w=64.98u l=1u
X9391 BAT GATE DVDD DVDD pfet_06v0 ad=58.1134p pd=77.985u as=71.8771p ps=0.15481m w=76.465u l=1u
X9392 DVDD GATE BAT DVDD pfet_06v0 ad=58.1134p pd=77.985u as=58.1134p ps=77.985u w=76.465u l=1u
X9393 BAT GATE DVDD DVDD pfet_06v0 ad=58.1134p pd=77.985u as=58.1134p ps=77.985u w=76.465u l=1u
X9394 DVDD GATE BAT DVDD pfet_06v0 ad=43.9215p pd=95.32999u as=35.511p ps=48.245u w=46.725u l=1u
X9395 DVDD GATE BAT DVDD pfet_06v0 ad=58.1134p pd=77.985u as=58.1134p ps=77.985u w=76.465u l=1u
X9396 BAT GATE DVDD DVDD pfet_06v0 ad=58.1134p pd=77.985u as=71.8771p ps=0.15481m w=76.465u l=1u
X9397 DVDD GATE BAT DVDD pfet_06v0 ad=35.511p pd=48.245u as=35.511p ps=48.245u w=46.725u l=1u
X9398 BAT GATE DVDD DVDD pfet_06v0 ad=58.1134p pd=77.985u as=71.8771p ps=0.15481m w=76.465u l=1u
X9399 BAT GATE DVDD DVDD pfet_06v0 ad=58.1552p pd=78.04u as=71.92879p ps=0.15492m w=76.52u l=1u
X9400 BAT GATE DVDD DVDD pfet_06v0 ad=58.1134p pd=77.985u as=58.1134p ps=77.985u w=76.465u l=1u
X9401 DVDD GATE BAT DVDD pfet_06v0 ad=43.9215p pd=95.32999u as=35.511p ps=48.245u w=46.725u l=1u
X9402 BAT GATE DVDD DVDD pfet_06v0 ad=58.1096p pd=77.98u as=58.1096p ps=77.98u w=76.46u l=1u
X9403 BAT GATE DVDD DVDD pfet_06v0 ad=35.511p pd=48.245u as=35.511p ps=48.245u w=46.725u l=1u
X9404 BAT GATE DVDD DVDD pfet_06v0 ad=35.511p pd=48.245u as=35.511p ps=48.245u w=46.725u l=1u
X9405 BAT GATE DVDD DVDD pfet_06v0 ad=35.511p pd=48.245u as=35.511p ps=48.245u w=46.725u l=1u
X9406 BAT GATE DVDD DVDD pfet_06v0 ad=58.1552p pd=78.04u as=58.1552p ps=78.04u w=76.52u l=1u
X9407 BAT GATE DVDD DVDD pfet_06v0 ad=58.0754p pd=77.935u as=58.0754p ps=77.935u w=76.41499u l=1u
X9408 DVDD GATE BAT DVDD pfet_06v0 ad=58.9803p pd=0.12737m as=47.6862p ps=64.265u w=62.745u l=1u
X9409 DVDD GATE BAT DVDD pfet_06v0 ad=35.511p pd=48.245u as=35.511p ps=48.245u w=46.725u l=1u
X9410 DVDD GATE BAT DVDD pfet_06v0 ad=35.511p pd=48.245u as=35.511p ps=48.245u w=46.725u l=1u
X9411 DVDD GATE BAT DVDD pfet_06v0 ad=35.511p pd=48.245u as=35.511p ps=48.245u w=46.725u l=1u
X9412 DVDD GATE BAT DVDD pfet_06v0 ad=58.1552p pd=78.04u as=58.1552p ps=78.04u w=76.52u l=1u
X9413 BAT GATE DVDD DVDD pfet_06v0 ad=49.3848p pd=66.5u as=49.3848p ps=66.5u w=64.98u l=1u
X9414 DVDD GATE BAT DVDD pfet_06v0 ad=35.511p pd=48.245u as=35.511p ps=48.245u w=46.725u l=1u
X9415 BAT GATE DVDD DVDD pfet_06v0 ad=35.5072p pd=48.24u as=35.5072p ps=48.24u w=46.72u l=1u
X9416 DVDD GATE BAT DVDD pfet_06v0 ad=43.9215p pd=95.32999u as=35.511p ps=48.245u w=46.725u l=1u
X9417 DVDD GATE BAT DVDD pfet_06v0 ad=58.1134p pd=77.985u as=58.1134p ps=77.985u w=76.465u l=1u
X9418 DVDD GATE BAT DVDD pfet_06v0 ad=58.1134p pd=77.985u as=58.1134p ps=77.985u w=76.465u l=1u
X9419 DVDD GATE BAT DVDD pfet_06v0 ad=58.1134p pd=77.985u as=58.1134p ps=77.985u w=76.465u l=1u
X9420 DVDD GATE BAT DVDD pfet_06v0 ad=58.1134p pd=77.985u as=58.1134p ps=77.985u w=76.465u l=1u
X9421 DVDD GATE BAT DVDD pfet_06v0 ad=58.1134p pd=77.985u as=58.1134p ps=77.985u w=76.465u l=1u
X9422 BAT GATE DVDD DVDD pfet_06v0 ad=35.511p pd=48.245u as=35.511p ps=48.245u w=46.725u l=1u
X9423 DVDD GATE BAT DVDD pfet_06v0 ad=35.511p pd=48.245u as=35.511p ps=48.245u w=46.725u l=1u
X9424 DVDD GATE BAT DVDD pfet_06v0 ad=58.1134p pd=77.985u as=58.1134p ps=77.985u w=76.465u l=1u
X9425 DVDD GATE BAT DVDD pfet_06v0 ad=35.511p pd=48.245u as=35.511p ps=48.245u w=46.725u l=1u
X9426 DVDD GATE BAT DVDD pfet_06v0 ad=58.0754p pd=77.935u as=58.0754p ps=77.935u w=76.41499u l=1u
X9427 BAT GATE DVDD DVDD pfet_06v0 ad=58.1134p pd=77.985u as=58.1134p ps=77.985u w=76.465u l=1u
X9428 DVDD GATE BAT DVDD pfet_06v0 ad=71.8771p pd=0.15481m as=58.1134p ps=77.985u w=76.465u l=1u
X9429 DVDD GATE BAT DVDD pfet_06v0 ad=49.3848p pd=66.5u as=49.3848p ps=66.5u w=64.98u l=1u
X9430 DVDD GATE BAT DVDD pfet_06v0 ad=49.3848p pd=66.5u as=49.3848p ps=66.5u w=64.98u l=1u
X9431 DVDD GATE BAT DVDD pfet_06v0 ad=43.9215p pd=95.32999u as=35.511p ps=48.245u w=46.725u l=1u
X9432 DVDD GATE BAT DVDD pfet_06v0 ad=35.5072p pd=48.24u as=35.5072p ps=48.24u w=46.72u l=1u
X9433 DVDD GATE BAT DVDD pfet_06v0 ad=35.511p pd=48.245u as=35.511p ps=48.245u w=46.725u l=1u
X9434 DVDD GATE BAT DVDD pfet_06v0 ad=71.8724p pd=0.1548m as=58.1096p ps=77.98u w=76.46u l=1u
X9435 DVDD GATE BAT DVDD pfet_06v0 ad=49.3848p pd=66.5u as=49.3848p ps=66.5u w=64.98u l=1u
X9436 BAT GATE DVDD DVDD pfet_06v0 ad=58.1134p pd=77.985u as=58.1134p ps=77.985u w=76.465u l=1u
X9437 DVDD GATE BAT DVDD pfet_06v0 ad=35.511p pd=48.245u as=35.511p ps=48.245u w=46.725u l=1u
X9438 DVDD GATE BAT DVDD pfet_06v0 ad=35.511p pd=48.245u as=35.511p ps=48.245u w=46.725u l=1u
X9439 DVDD GATE BAT DVDD pfet_06v0 ad=35.5072p pd=48.24u as=35.5072p ps=48.24u w=46.72u l=1u
X9440 DVDD GATE BAT DVDD pfet_06v0 ad=35.511p pd=48.245u as=35.511p ps=48.245u w=46.725u l=1u
X9441 DVDD GATE BAT DVDD pfet_06v0 ad=58.1134p pd=77.985u as=58.1134p ps=77.985u w=76.465u l=1u
X9442 BAT GATE DVDD DVDD pfet_06v0 ad=47.6862p pd=64.265u as=47.6862p ps=64.265u w=62.745u l=1u
X9443 DVDD GATE BAT DVDD pfet_06v0 ad=35.511p pd=48.245u as=35.511p ps=48.245u w=46.725u l=1u
X9444 BAT GATE DVDD DVDD pfet_06v0 ad=35.511p pd=48.245u as=35.511p ps=48.245u w=46.725u l=1u
X9445 DVDD GATE BAT DVDD pfet_06v0 ad=43.9215p pd=95.32999u as=35.511p ps=48.245u w=46.725u l=1u
X9446 BAT GATE DVDD DVDD pfet_06v0 ad=58.1134p pd=77.985u as=71.8771p ps=0.15481m w=76.465u l=1u
X9447 DVDD GATE BAT DVDD pfet_06v0 ad=58.0754p pd=77.935u as=58.0754p ps=77.935u w=76.41499u l=1u
X9448 DVDD GATE BAT DVDD pfet_06v0 ad=35.511p pd=48.245u as=35.511p ps=48.245u w=46.725u l=1u
X9449 BAT GATE DVDD DVDD pfet_06v0 ad=47.6862p pd=64.265u as=47.6862p ps=64.265u w=62.745u l=1u
X9450 DVDD GATE BAT DVDD pfet_06v0 ad=43.9215p pd=95.32999u as=35.511p ps=48.245u w=46.725u l=1u
X9451 DVDD GATE BAT DVDD pfet_06v0 ad=58.1134p pd=77.985u as=58.1134p ps=77.985u w=76.465u l=1u
X9452 BAT GATE DVDD DVDD pfet_06v0 ad=58.1134p pd=77.985u as=58.1134p ps=77.985u w=76.465u l=1u
X9453 DVDD GATE BAT DVDD pfet_06v0 ad=35.511p pd=48.245u as=35.511p ps=48.245u w=46.725u l=1u
X9454 BAT GATE DVDD DVDD pfet_06v0 ad=35.511p pd=48.245u as=35.511p ps=48.245u w=46.725u l=1u
X9455 DVDD GATE BAT DVDD pfet_06v0 ad=58.1134p pd=77.985u as=58.1134p ps=77.985u w=76.465u l=1u
X9456 DVDD GATE BAT DVDD pfet_06v0 ad=58.1134p pd=77.985u as=58.1134p ps=77.985u w=76.465u l=1u
X9457 BAT GATE DVDD DVDD pfet_06v0 ad=58.0754p pd=77.935u as=58.0754p ps=77.935u w=76.41499u l=1u
X9458 DVDD GATE BAT DVDD pfet_06v0 ad=35.511p pd=48.245u as=35.511p ps=48.245u w=46.725u l=1u
X9459 BAT GATE DVDD DVDD pfet_06v0 ad=35.511p pd=48.245u as=35.511p ps=48.245u w=46.725u l=1u
X9460 BAT GATE DVDD DVDD pfet_06v0 ad=58.1134p pd=77.985u as=58.1134p ps=77.985u w=76.465u l=1u
X9461 DVDD GATE BAT DVDD pfet_06v0 ad=43.9215p pd=95.32999u as=35.511p ps=48.245u w=46.725u l=1u
X9462 DVDD GATE BAT DVDD pfet_06v0 ad=58.1134p pd=77.985u as=58.1134p ps=77.985u w=76.465u l=1u
X9463 BAT GATE DVDD DVDD pfet_06v0 ad=35.5072p pd=48.24u as=43.9168p ps=95.32u w=46.72u l=1u
X9464 DVDD GATE BAT DVDD pfet_06v0 ad=58.1096p pd=77.98u as=58.1096p ps=77.98u w=76.46u l=1u
X9465 DVDD GATE BAT DVDD pfet_06v0 ad=47.6862p pd=64.265u as=47.6862p ps=64.265u w=62.745u l=1u
X9466 DVDD GATE BAT DVDD pfet_06v0 ad=71.8771p pd=0.15481m as=58.1134p ps=77.985u w=76.465u l=1u
X9467 BAT GATE DVDD DVDD pfet_06v0 ad=58.1134p pd=77.985u as=71.8771p ps=0.15481m w=76.465u l=1u
X9468 DVDD GATE BAT DVDD pfet_06v0 ad=58.1134p pd=77.985u as=58.1134p ps=77.985u w=76.465u l=1u
X9469 DVDD GATE BAT DVDD pfet_06v0 ad=35.511p pd=48.245u as=35.511p ps=48.245u w=46.725u l=1u
X9470 DVDD GATE BAT DVDD pfet_06v0 ad=35.5072p pd=48.24u as=35.5072p ps=48.24u w=46.72u l=1u
X9471 DVDD GATE BAT DVDD pfet_06v0 ad=58.1134p pd=77.985u as=58.1134p ps=77.985u w=76.465u l=1u
X9472 BAT GATE DVDD DVDD pfet_06v0 ad=58.1134p pd=77.985u as=58.1134p ps=77.985u w=76.465u l=1u
X9473 BAT GATE DVDD DVDD pfet_06v0 ad=58.1134p pd=77.985u as=58.1134p ps=77.985u w=76.465u l=1u
X9474 BAT GATE DVDD DVDD pfet_06v0 ad=35.511p pd=48.245u as=35.511p ps=48.245u w=46.725u l=1u
X9475 BAT GATE DVDD DVDD pfet_06v0 ad=35.511p pd=48.245u as=43.9215p ps=95.32999u w=46.725u l=1u
X9476 DVDD GATE BAT DVDD pfet_06v0 ad=58.1552p pd=78.04u as=58.1552p ps=78.04u w=76.52u l=1u
X9477 DVDD GATE BAT DVDD pfet_06v0 ad=58.1096p pd=77.98u as=58.1096p ps=77.98u w=76.46u l=1u
X9478 BAT GATE DVDD DVDD pfet_06v0 ad=58.1134p pd=77.985u as=71.8771p ps=0.15481m w=76.465u l=1u
X9479 DVDD GATE BAT DVDD pfet_06v0 ad=58.1134p pd=77.985u as=58.1134p ps=77.985u w=76.465u l=1u
X9480 DVDD GATE BAT DVDD pfet_06v0 ad=35.511p pd=48.245u as=35.511p ps=48.245u w=46.725u l=1u
X9481 BAT GATE DVDD DVDD pfet_06v0 ad=47.6862p pd=64.265u as=58.9803p ps=0.12737m w=62.745u l=1u
X9482 BAT GATE DVDD DVDD pfet_06v0 ad=58.1134p pd=77.985u as=58.1134p ps=77.985u w=76.465u l=1u
X9483 DVDD GATE BAT DVDD pfet_06v0 ad=35.511p pd=48.245u as=35.511p ps=48.245u w=46.725u l=1u
X9484 DVDD GATE BAT DVDD pfet_06v0 ad=61.0812p pd=0.13184m as=49.3848p ps=66.5u w=64.98u l=1u
X9485 DVDD GATE BAT DVDD pfet_06v0 ad=43.9215p pd=95.32999u as=35.511p ps=48.245u w=46.725u l=1u
X9486 BAT GATE DVDD DVDD pfet_06v0 ad=58.1134p pd=77.985u as=71.8771p ps=0.15481m w=76.465u l=1u
X9487 BAT GATE DVDD DVDD pfet_06v0 ad=35.511p pd=48.245u as=35.511p ps=48.245u w=46.725u l=1u
X9488 DVDD GATE BAT DVDD pfet_06v0 ad=71.8301p pd=0.15471m as=58.0754p ps=77.935u w=76.41499u l=1u
X9489 BAT GATE DVDD DVDD pfet_06v0 ad=35.511p pd=48.245u as=35.511p ps=48.245u w=46.725u l=1u
X9490 BAT GATE DVDD DVDD pfet_06v0 ad=35.511p pd=48.245u as=35.511p ps=48.245u w=46.725u l=1u
X9491 DVDD GATE BAT DVDD pfet_06v0 ad=58.1134p pd=77.985u as=58.1134p ps=77.985u w=76.465u l=1u
X9492 DVDD GATE BAT DVDD pfet_06v0 ad=35.5072p pd=48.24u as=35.5072p ps=48.24u w=46.72u l=1u
X9493 DVDD GATE BAT DVDD pfet_06v0 ad=58.1134p pd=77.985u as=58.1134p ps=77.985u w=76.465u l=1u
X9494 BAT GATE DVDD DVDD pfet_06v0 ad=58.0754p pd=77.935u as=58.0754p ps=77.935u w=76.41499u l=1u
X9495 BAT GATE DVDD DVDD pfet_06v0 ad=58.1134p pd=77.985u as=58.1134p ps=77.985u w=76.465u l=1u
X9496 BAT GATE DVDD DVDD pfet_06v0 ad=58.1134p pd=77.985u as=58.1134p ps=77.985u w=76.465u l=1u
X9497 BAT GATE DVDD DVDD pfet_06v0 ad=35.511p pd=48.245u as=35.511p ps=48.245u w=46.725u l=1u
X9498 BAT GATE DVDD DVDD pfet_06v0 ad=49.3848p pd=66.5u as=49.3848p ps=66.5u w=64.98u l=1u
X9499 BAT GATE DVDD DVDD pfet_06v0 ad=58.0754p pd=77.935u as=58.0754p ps=77.935u w=76.41499u l=1u
X9500 DVDD GATE BAT DVDD pfet_06v0 ad=71.8771p pd=0.15481m as=58.1134p ps=77.985u w=76.465u l=1u
X9501 BAT GATE DVDD DVDD pfet_06v0 ad=58.1096p pd=77.98u as=58.1096p ps=77.98u w=76.46u l=1u
X9502 BAT GATE DVDD DVDD pfet_06v0 ad=58.1134p pd=77.985u as=71.8771p ps=0.15481m w=76.465u l=1u
X9503 DVDD GATE BAT DVDD pfet_06v0 ad=35.511p pd=48.245u as=35.511p ps=48.245u w=46.725u l=1u
X9504 BAT GATE DVDD DVDD pfet_06v0 ad=58.1134p pd=77.985u as=58.1134p ps=77.985u w=76.465u l=1u
X9505 DVDD GATE BAT DVDD pfet_06v0 ad=35.511p pd=48.245u as=35.511p ps=48.245u w=46.725u l=1u
X9506 DVDD GATE BAT DVDD pfet_06v0 ad=71.8724p pd=0.1548m as=58.1096p ps=77.98u w=76.46u l=1u
X9507 DVDD GATE BAT DVDD pfet_06v0 ad=58.1096p pd=77.98u as=58.1096p ps=77.98u w=76.46u l=1u
X9508 BAT GATE DVDD DVDD pfet_06v0 ad=35.511p pd=48.245u as=35.511p ps=48.245u w=46.725u l=1u
X9509 DVDD GATE BAT DVDD pfet_06v0 ad=58.1134p pd=77.985u as=58.1134p ps=77.985u w=76.465u l=1u
X9510 DVDD GATE BAT DVDD pfet_06v0 ad=49.3848p pd=66.5u as=49.3848p ps=66.5u w=64.98u l=1u
X9511 DVDD GATE BAT DVDD pfet_06v0 ad=35.511p pd=48.245u as=35.511p ps=48.245u w=46.725u l=1u
X9512 DVDD GATE BAT DVDD pfet_06v0 ad=35.511p pd=48.245u as=35.511p ps=48.245u w=46.725u l=1u
X9513 BAT GATE DVDD DVDD pfet_06v0 ad=35.511p pd=48.245u as=35.511p ps=48.245u w=46.725u l=1u
X9514 DVDD GATE BAT DVDD pfet_06v0 ad=58.1552p pd=78.04u as=58.1552p ps=78.04u w=76.52u l=1u
X9515 BAT GATE DVDD DVDD pfet_06v0 ad=58.1134p pd=77.985u as=58.1134p ps=77.985u w=76.465u l=1u
X9516 DVDD GATE BAT DVDD pfet_06v0 ad=71.8771p pd=0.15481m as=58.1134p ps=77.985u w=76.465u l=1u
X9517 DVDD GATE BAT DVDD pfet_06v0 ad=35.511p pd=48.245u as=35.511p ps=48.245u w=46.725u l=1u
X9518 BAT GATE DVDD DVDD pfet_06v0 ad=58.1172p pd=77.99u as=58.1172p ps=77.99u w=76.47u l=1u
X9519 BAT GATE DVDD DVDD pfet_06v0 ad=58.1134p pd=77.985u as=58.1134p ps=77.985u w=76.465u l=1u
X9520 DVDD GATE BAT DVDD pfet_06v0 ad=35.511p pd=48.245u as=35.511p ps=48.245u w=46.725u l=1u
X9521 BAT GATE DVDD DVDD pfet_06v0 ad=35.511p pd=48.245u as=35.511p ps=48.245u w=46.725u l=1u
X9522 DVDD GATE BAT DVDD pfet_06v0 ad=35.511p pd=48.245u as=35.511p ps=48.245u w=46.725u l=1u
X9523 DVDD GATE BAT DVDD pfet_06v0 ad=35.5072p pd=48.24u as=35.5072p ps=48.24u w=46.72u l=1u
X9524 DVDD GATE BAT DVDD pfet_06v0 ad=58.1172p pd=77.99u as=58.1172p ps=77.99u w=76.47u l=1u
X9525 BAT GATE DVDD DVDD pfet_06v0 ad=58.1134p pd=77.985u as=58.1134p ps=77.985u w=76.465u l=1u
X9526 BAT GATE DVDD DVDD pfet_06v0 ad=35.511p pd=48.245u as=35.511p ps=48.245u w=46.725u l=1u
X9527 BAT GATE DVDD DVDD pfet_06v0 ad=49.3848p pd=66.5u as=49.3848p ps=66.5u w=64.98u l=1u
X9528 BAT GATE DVDD DVDD pfet_06v0 ad=58.1134p pd=77.985u as=58.1134p ps=77.985u w=76.465u l=1u
X9529 BAT GATE DVDD DVDD pfet_06v0 ad=58.1134p pd=77.985u as=58.1134p ps=77.985u w=76.465u l=1u
X9530 DVDD GATE BAT DVDD pfet_06v0 ad=49.3848p pd=66.5u as=49.3848p ps=66.5u w=64.98u l=1u
X9531 BAT GATE DVDD DVDD pfet_06v0 ad=47.6862p pd=64.265u as=47.6862p ps=64.265u w=62.745u l=1u
X9532 BAT GATE DVDD DVDD pfet_06v0 ad=58.1096p pd=77.98u as=58.1096p ps=77.98u w=76.46u l=1u
X9533 DVDD GATE BAT DVDD pfet_06v0 ad=58.1134p pd=77.985u as=58.1134p ps=77.985u w=76.465u l=1u
X9534 DVDD GATE BAT DVDD pfet_06v0 ad=58.1552p pd=78.04u as=58.1552p ps=78.04u w=76.52u l=1u
X9535 BAT GATE DVDD DVDD pfet_06v0 ad=35.5072p pd=48.24u as=35.5072p ps=48.24u w=46.72u l=1u
X9536 BAT GATE DVDD DVDD pfet_06v0 ad=58.1134p pd=77.985u as=58.1134p ps=77.985u w=76.465u l=1u
X9537 DVDD GATE BAT DVDD pfet_06v0 ad=58.1134p pd=77.985u as=58.1134p ps=77.985u w=76.465u l=1u
X9538 BAT GATE DVDD DVDD pfet_06v0 ad=49.3848p pd=66.5u as=49.3848p ps=66.5u w=64.98u l=1u
X9539 BAT GATE DVDD DVDD pfet_06v0 ad=49.3848p pd=66.5u as=49.3848p ps=66.5u w=64.98u l=1u
X9540 BAT GATE DVDD DVDD pfet_06v0 ad=35.511p pd=48.245u as=43.9215p ps=95.32999u w=46.725u l=1u
X9541 DVDD GATE BAT DVDD pfet_06v0 ad=35.511p pd=48.245u as=35.511p ps=48.245u w=46.725u l=1u
X9542 BAT GATE DVDD DVDD pfet_06v0 ad=35.511p pd=48.245u as=43.9215p ps=95.32999u w=46.725u l=1u
X9543 BAT GATE DVDD DVDD pfet_06v0 ad=58.0754p pd=77.935u as=71.8301p ps=0.15471m w=76.41499u l=1u
X9544 BAT GATE DVDD DVDD pfet_06v0 ad=35.511p pd=48.245u as=35.511p ps=48.245u w=46.725u l=1u
X9545 DVDD GATE BAT DVDD pfet_06v0 ad=58.1134p pd=77.985u as=58.1134p ps=77.985u w=76.465u l=1u
X9546 DVDD GATE BAT DVDD pfet_06v0 ad=58.1134p pd=77.985u as=58.1134p ps=77.985u w=76.465u l=1u
X9547 BAT GATE DVDD DVDD pfet_06v0 ad=35.511p pd=48.245u as=35.511p ps=48.245u w=46.725u l=1u
X9548 DVDD GATE BAT DVDD pfet_06v0 ad=35.511p pd=48.245u as=35.511p ps=48.245u w=46.725u l=1u
X9549 DVDD GATE BAT DVDD pfet_06v0 ad=35.511p pd=48.245u as=35.511p ps=48.245u w=46.725u l=1u
X9550 BAT GATE DVDD DVDD pfet_06v0 ad=35.511p pd=48.245u as=43.9215p ps=95.32999u w=46.725u l=1u
X9551 DVDD GATE BAT DVDD pfet_06v0 ad=58.1134p pd=77.985u as=58.1134p ps=77.985u w=76.465u l=1u
X9552 DVDD GATE BAT DVDD pfet_06v0 ad=43.9215p pd=95.32999u as=35.511p ps=48.245u w=46.725u l=1u
X9553 DVDD GATE BAT DVDD pfet_06v0 ad=35.511p pd=48.245u as=35.511p ps=48.245u w=46.725u l=1u
X9554 BAT GATE DVDD DVDD pfet_06v0 ad=58.1134p pd=77.985u as=58.1134p ps=77.985u w=76.465u l=1u
X9555 BAT GATE DVDD DVDD pfet_06v0 ad=35.511p pd=48.245u as=35.511p ps=48.245u w=46.725u l=1u
X9556 BAT GATE DVDD DVDD pfet_06v0 ad=58.1134p pd=77.985u as=58.1134p ps=77.985u w=76.465u l=1u
X9557 BAT GATE DVDD DVDD pfet_06v0 ad=35.511p pd=48.245u as=35.511p ps=48.245u w=46.725u l=1u
X9558 DVDD GATE BAT DVDD pfet_06v0 ad=58.1096p pd=77.98u as=58.1096p ps=77.98u w=76.46u l=1u
X9559 DVDD GATE BAT DVDD pfet_06v0 ad=58.9803p pd=0.12737m as=47.6862p ps=64.265u w=62.745u l=1u
X9560 BAT GATE DVDD DVDD pfet_06v0 ad=58.1172p pd=77.99u as=58.1172p ps=77.99u w=76.47u l=1u
X9561 DVDD GATE BAT DVDD pfet_06v0 ad=43.9215p pd=95.32999u as=35.511p ps=48.245u w=46.725u l=1u
X9562 BAT GATE DVDD DVDD pfet_06v0 ad=58.1096p pd=77.98u as=71.8724p ps=0.1548m w=76.46u l=1u
X9563 BAT GATE DVDD DVDD pfet_06v0 ad=35.511p pd=48.245u as=35.511p ps=48.245u w=46.725u l=1u
X9564 DVDD GATE BAT DVDD pfet_06v0 ad=61.0812p pd=0.13184m as=49.3848p ps=66.5u w=64.98u l=1u
X9565 DVDD GATE BAT DVDD pfet_06v0 ad=58.1134p pd=77.985u as=58.1134p ps=77.985u w=76.465u l=1u
X9566 DVDD GATE BAT DVDD pfet_06v0 ad=35.511p pd=48.245u as=35.511p ps=48.245u w=46.725u l=1u
X9567 BAT GATE DVDD DVDD pfet_06v0 ad=58.1096p pd=77.98u as=58.1096p ps=77.98u w=76.46u l=1u
X9568 BAT GATE DVDD DVDD pfet_06v0 ad=35.511p pd=48.245u as=35.511p ps=48.245u w=46.725u l=1u
X9569 DVDD GATE BAT DVDD pfet_06v0 ad=43.9215p pd=95.32999u as=35.511p ps=48.245u w=46.725u l=1u
X9570 BAT GATE DVDD DVDD pfet_06v0 ad=58.1134p pd=77.985u as=58.1134p ps=77.985u w=76.465u l=1u
X9571 DVDD GATE BAT DVDD pfet_06v0 ad=35.511p pd=48.245u as=35.511p ps=48.245u w=46.725u l=1u
X9572 BAT GATE DVDD DVDD pfet_06v0 ad=58.1096p pd=77.98u as=58.1096p ps=77.98u w=76.46u l=1u
X9573 DVDD GATE BAT DVDD pfet_06v0 ad=58.1134p pd=77.985u as=58.1134p ps=77.985u w=76.465u l=1u
X9574 DVDD GATE BAT DVDD pfet_06v0 ad=58.0754p pd=77.935u as=58.0754p ps=77.935u w=76.41499u l=1u
X9575 BAT GATE DVDD DVDD pfet_06v0 ad=35.511p pd=48.245u as=35.511p ps=48.245u w=46.725u l=1u
X9576 BAT GATE DVDD DVDD pfet_06v0 ad=35.511p pd=48.245u as=43.9215p ps=95.32999u w=46.725u l=1u
X9577 DVDD GATE BAT DVDD pfet_06v0 ad=71.8771p pd=0.15481m as=58.1134p ps=77.985u w=76.465u l=1u
X9578 DVDD GATE BAT DVDD pfet_06v0 ad=35.511p pd=48.245u as=35.511p ps=48.245u w=46.725u l=1u
X9579 DVDD GATE BAT DVDD pfet_06v0 ad=58.1172p pd=77.99u as=58.1172p ps=77.99u w=76.47u l=1u
X9580 DVDD GATE BAT DVDD pfet_06v0 ad=35.511p pd=48.245u as=35.511p ps=48.245u w=46.725u l=1u
X9581 BAT GATE DVDD DVDD pfet_06v0 ad=58.1172p pd=77.99u as=58.1172p ps=77.99u w=76.47u l=1u
X9582 DVDD GATE BAT DVDD pfet_06v0 ad=35.511p pd=48.245u as=35.511p ps=48.245u w=46.725u l=1u
X9583 BAT GATE DVDD DVDD pfet_06v0 ad=35.511p pd=48.245u as=35.511p ps=48.245u w=46.725u l=1u
X9584 DVDD GATE BAT DVDD pfet_06v0 ad=58.1134p pd=77.985u as=58.1134p ps=77.985u w=76.465u l=1u
X9585 BAT GATE DVDD DVDD pfet_06v0 ad=35.5072p pd=48.24u as=35.5072p ps=48.24u w=46.72u l=1u
X9586 BAT GATE DVDD DVDD pfet_06v0 ad=58.1134p pd=77.985u as=58.1134p ps=77.985u w=76.465u l=1u
X9587 BAT GATE DVDD DVDD pfet_06v0 ad=35.5072p pd=48.24u as=35.5072p ps=48.24u w=46.72u l=1u
X9588 DVDD GATE BAT DVDD pfet_06v0 ad=47.6862p pd=64.265u as=47.6862p ps=64.265u w=62.745u l=1u
X9589 DVDD GATE BAT DVDD pfet_06v0 ad=35.511p pd=48.245u as=35.511p ps=48.245u w=46.725u l=1u
X9590 DVDD GATE BAT DVDD pfet_06v0 ad=58.9803p pd=0.12737m as=47.6862p ps=64.265u w=62.745u l=1u
X9591 DVDD GATE BAT DVDD pfet_06v0 ad=35.511p pd=48.245u as=35.511p ps=48.245u w=46.725u l=1u
X9592 BAT GATE DVDD DVDD pfet_06v0 ad=58.1134p pd=77.985u as=58.1134p ps=77.985u w=76.465u l=1u
X9593 DVDD GATE BAT DVDD pfet_06v0 ad=58.1552p pd=78.04u as=58.1552p ps=78.04u w=76.52u l=1u
X9594 BAT GATE DVDD DVDD pfet_06v0 ad=58.1552p pd=78.04u as=58.1552p ps=78.04u w=76.52u l=1u
X9595 DVDD GATE BAT DVDD pfet_06v0 ad=58.1552p pd=78.04u as=58.1552p ps=78.04u w=76.52u l=1u
X9596 DVDD GATE BAT DVDD pfet_06v0 ad=58.0754p pd=77.935u as=58.0754p ps=77.935u w=76.41499u l=1u
X9597 BAT GATE DVDD DVDD pfet_06v0 ad=35.511p pd=48.245u as=43.9215p ps=95.32999u w=46.725u l=1u
X9598 BAT GATE DVDD DVDD pfet_06v0 ad=35.511p pd=48.245u as=35.511p ps=48.245u w=46.725u l=1u
X9599 BAT GATE DVDD DVDD pfet_06v0 ad=35.511p pd=48.245u as=35.511p ps=48.245u w=46.725u l=1u
X9600 DVDD GATE BAT DVDD pfet_06v0 ad=35.511p pd=48.245u as=35.511p ps=48.245u w=46.725u l=1u
X9601 DVDD GATE BAT DVDD pfet_06v0 ad=58.0754p pd=77.935u as=58.0754p ps=77.935u w=76.41499u l=1u
X9602 BAT GATE DVDD DVDD pfet_06v0 ad=58.1134p pd=77.985u as=58.1134p ps=77.985u w=76.465u l=1u
X9603 DVDD GATE BAT DVDD pfet_06v0 ad=49.3848p pd=66.5u as=49.3848p ps=66.5u w=64.98u l=1u
X9604 BAT GATE DVDD DVDD pfet_06v0 ad=49.3848p pd=66.5u as=49.3848p ps=66.5u w=64.98u l=1u
X9605 DVDD GATE BAT DVDD pfet_06v0 ad=35.511p pd=48.245u as=35.511p ps=48.245u w=46.725u l=1u
X9606 DVDD GATE BAT DVDD pfet_06v0 ad=58.1134p pd=77.985u as=58.1134p ps=77.985u w=76.465u l=1u
X9607 BAT GATE DVDD DVDD pfet_06v0 ad=58.1134p pd=77.985u as=58.1134p ps=77.985u w=76.465u l=1u
X9608 BAT GATE DVDD DVDD pfet_06v0 ad=58.1552p pd=78.04u as=58.1552p ps=78.04u w=76.52u l=1u
X9609 DVDD GATE BAT DVDD pfet_06v0 ad=58.1134p pd=77.985u as=58.1134p ps=77.985u w=76.465u l=1u
X9610 BAT GATE DVDD DVDD pfet_06v0 ad=35.511p pd=48.245u as=35.511p ps=48.245u w=46.725u l=1u
X9611 DVDD GATE BAT DVDD pfet_06v0 ad=58.1134p pd=77.985u as=58.1134p ps=77.985u w=76.465u l=1u
X9612 BAT GATE DVDD DVDD pfet_06v0 ad=58.1134p pd=77.985u as=71.8771p ps=0.15481m w=76.465u l=1u
X9613 DVDD GATE BAT DVDD pfet_06v0 ad=58.1134p pd=77.985u as=58.1134p ps=77.985u w=76.465u l=1u
X9614 DVDD GATE BAT DVDD pfet_06v0 ad=35.511p pd=48.245u as=35.511p ps=48.245u w=46.725u l=1u
X9615 DVDD GATE BAT DVDD pfet_06v0 ad=58.1172p pd=77.99u as=58.1172p ps=77.99u w=76.47u l=1u
X9616 DVDD GATE BAT DVDD pfet_06v0 ad=58.1134p pd=77.985u as=58.1134p ps=77.985u w=76.465u l=1u
X9617 DVDD GATE BAT DVDD pfet_06v0 ad=35.511p pd=48.245u as=35.511p ps=48.245u w=46.725u l=1u
X9618 BAT GATE DVDD DVDD pfet_06v0 ad=35.511p pd=48.245u as=35.511p ps=48.245u w=46.725u l=1u
X9619 DVDD GATE BAT DVDD pfet_06v0 ad=35.511p pd=48.245u as=35.511p ps=48.245u w=46.725u l=1u
X9620 DVDD GATE BAT DVDD pfet_06v0 ad=58.1134p pd=77.985u as=58.1134p ps=77.985u w=76.465u l=1u
X9621 DVDD GATE BAT DVDD pfet_06v0 ad=58.1134p pd=77.985u as=58.1134p ps=77.985u w=76.465u l=1u
X9622 BAT GATE DVDD DVDD pfet_06v0 ad=49.3848p pd=66.5u as=61.0812p ps=0.13184m w=64.98u l=1u
X9623 BAT GATE DVDD DVDD pfet_06v0 ad=35.511p pd=48.245u as=35.511p ps=48.245u w=46.725u l=1u
X9624 DVDD GATE BAT DVDD pfet_06v0 ad=58.1134p pd=77.985u as=58.1134p ps=77.985u w=76.465u l=1u
X9625 BAT GATE DVDD DVDD pfet_06v0 ad=35.511p pd=48.245u as=35.511p ps=48.245u w=46.725u l=1u
X9626 DVDD GATE BAT DVDD pfet_06v0 ad=35.511p pd=48.245u as=35.511p ps=48.245u w=46.725u l=1u
X9627 BAT GATE DVDD DVDD pfet_06v0 ad=58.1134p pd=77.985u as=58.1134p ps=77.985u w=76.465u l=1u
X9628 BAT GATE DVDD DVDD pfet_06v0 ad=49.3848p pd=66.5u as=49.3848p ps=66.5u w=64.98u l=1u
X9629 DVDD GATE BAT DVDD pfet_06v0 ad=58.0754p pd=77.935u as=58.0754p ps=77.935u w=76.41499u l=1u
X9630 DVDD GATE BAT DVDD pfet_06v0 ad=58.1096p pd=77.98u as=58.1096p ps=77.98u w=76.46u l=1u
X9631 DVDD GATE BAT DVDD pfet_06v0 ad=47.6862p pd=64.265u as=47.6862p ps=64.265u w=62.745u l=1u
X9632 DVDD GATE BAT DVDD pfet_06v0 ad=71.8771p pd=0.15481m as=58.1134p ps=77.985u w=76.465u l=1u
X9633 DVDD GATE BAT DVDD pfet_06v0 ad=58.0754p pd=77.935u as=58.0754p ps=77.935u w=76.41499u l=1u
X9634 BAT GATE DVDD DVDD pfet_06v0 ad=58.1552p pd=78.04u as=58.1552p ps=78.04u w=76.52u l=1u
X9635 BAT GATE DVDD DVDD pfet_06v0 ad=35.511p pd=48.245u as=35.511p ps=48.245u w=46.725u l=1u
X9636 BAT GATE DVDD DVDD pfet_06v0 ad=58.1552p pd=78.04u as=71.92879p ps=0.15492m w=76.52u l=1u
X9637 BAT GATE DVDD DVDD pfet_06v0 ad=35.511p pd=48.245u as=35.511p ps=48.245u w=46.725u l=1u
X9638 BAT GATE DVDD DVDD pfet_06v0 ad=35.511p pd=48.245u as=35.511p ps=48.245u w=46.725u l=1u
X9639 BAT GATE DVDD DVDD pfet_06v0 ad=58.1134p pd=77.985u as=58.1134p ps=77.985u w=76.465u l=1u
X9640 BAT GATE DVDD DVDD pfet_06v0 ad=35.511p pd=48.245u as=35.511p ps=48.245u w=46.725u l=1u
X9641 DVDD GATE BAT DVDD pfet_06v0 ad=35.511p pd=48.245u as=35.511p ps=48.245u w=46.725u l=1u
X9642 DVDD GATE BAT DVDD pfet_06v0 ad=35.511p pd=48.245u as=35.511p ps=48.245u w=46.725u l=1u
X9643 BAT GATE DVDD DVDD pfet_06v0 ad=58.1552p pd=78.04u as=58.1552p ps=78.04u w=76.52u l=1u
X9644 BAT GATE DVDD DVDD pfet_06v0 ad=47.6862p pd=64.265u as=47.6862p ps=64.265u w=62.745u l=1u
X9645 DVDD GATE BAT DVDD pfet_06v0 ad=35.511p pd=48.245u as=35.511p ps=48.245u w=46.725u l=1u
X9646 BAT GATE DVDD DVDD pfet_06v0 ad=58.1134p pd=77.985u as=58.1134p ps=77.985u w=76.465u l=1u
X9647 BAT GATE DVDD DVDD pfet_06v0 ad=58.1096p pd=77.98u as=71.8724p ps=0.1548m w=76.46u l=1u
X9648 DVDD GATE BAT DVDD pfet_06v0 ad=35.511p pd=48.245u as=35.511p ps=48.245u w=46.725u l=1u
X9649 BAT GATE DVDD DVDD pfet_06v0 ad=35.511p pd=48.245u as=35.511p ps=48.245u w=46.725u l=1u
X9650 DVDD GATE BAT DVDD pfet_06v0 ad=58.1134p pd=77.985u as=58.1134p ps=77.985u w=76.465u l=1u
X9651 BAT GATE DVDD DVDD pfet_06v0 ad=35.511p pd=48.245u as=35.511p ps=48.245u w=46.725u l=1u
X9652 DVDD GATE BAT DVDD pfet_06v0 ad=35.511p pd=48.245u as=35.511p ps=48.245u w=46.725u l=1u
X9653 DVDD GATE BAT DVDD pfet_06v0 ad=35.511p pd=48.245u as=35.511p ps=48.245u w=46.725u l=1u
X9654 DVDD GATE BAT DVDD pfet_06v0 ad=58.1096p pd=77.98u as=58.1096p ps=77.98u w=76.46u l=1u
X9655 BAT GATE DVDD DVDD pfet_06v0 ad=35.511p pd=48.245u as=43.9215p ps=95.32999u w=46.725u l=1u
X9656 DVDD GATE BAT DVDD pfet_06v0 ad=43.9215p pd=95.32999u as=35.511p ps=48.245u w=46.725u l=1u
X9657 BAT GATE DVDD DVDD pfet_06v0 ad=35.511p pd=48.245u as=35.511p ps=48.245u w=46.725u l=1u
X9658 BAT GATE DVDD DVDD pfet_06v0 ad=35.5072p pd=48.24u as=35.5072p ps=48.24u w=46.72u l=1u
X9659 DVDD GATE BAT DVDD pfet_06v0 ad=58.1172p pd=77.99u as=58.1172p ps=77.99u w=76.47u l=1u
X9660 BAT GATE DVDD DVDD pfet_06v0 ad=35.511p pd=48.245u as=35.511p ps=48.245u w=46.725u l=1u
X9661 DVDD GATE BAT DVDD pfet_06v0 ad=35.511p pd=48.245u as=35.511p ps=48.245u w=46.725u l=1u
X9662 DVDD GATE BAT DVDD pfet_06v0 ad=71.8771p pd=0.15481m as=58.1134p ps=77.985u w=76.465u l=1u
X9663 DVDD GATE BAT DVDD pfet_06v0 ad=35.511p pd=48.245u as=35.511p ps=48.245u w=46.725u l=1u
X9664 BAT GATE DVDD DVDD pfet_06v0 ad=58.0754p pd=77.935u as=58.0754p ps=77.935u w=76.41499u l=1u
X9665 BAT GATE DVDD DVDD pfet_06v0 ad=58.1552p pd=78.04u as=58.1552p ps=78.04u w=76.52u l=1u
X9666 DVDD GATE BAT DVDD pfet_06v0 ad=35.511p pd=48.245u as=35.511p ps=48.245u w=46.725u l=1u
X9667 BAT GATE DVDD DVDD pfet_06v0 ad=58.0754p pd=77.935u as=58.0754p ps=77.935u w=76.41499u l=1u
X9668 DVDD GATE BAT DVDD pfet_06v0 ad=47.6862p pd=64.265u as=47.6862p ps=64.265u w=62.745u l=1u
X9669 BAT GATE DVDD DVDD pfet_06v0 ad=35.511p pd=48.245u as=35.511p ps=48.245u w=46.725u l=1u
X9670 DVDD GATE BAT DVDD pfet_06v0 ad=35.511p pd=48.245u as=35.511p ps=48.245u w=46.725u l=1u
X9671 BAT GATE DVDD DVDD pfet_06v0 ad=58.1134p pd=77.985u as=71.8771p ps=0.15481m w=76.465u l=1u
X9672 BAT GATE DVDD DVDD pfet_06v0 ad=58.1134p pd=77.985u as=58.1134p ps=77.985u w=76.465u l=1u
X9673 DVDD GATE BAT DVDD pfet_06v0 ad=71.92879p pd=0.15492m as=58.1552p ps=78.04u w=76.52u l=1u
X9674 BAT GATE DVDD DVDD pfet_06v0 ad=35.511p pd=48.245u as=43.9215p ps=95.32999u w=46.725u l=1u
X9675 DVDD GATE BAT DVDD pfet_06v0 ad=58.1134p pd=77.985u as=58.1134p ps=77.985u w=76.465u l=1u
X9676 BAT GATE DVDD DVDD pfet_06v0 ad=58.1134p pd=77.985u as=58.1134p ps=77.985u w=76.465u l=1u
X9677 BAT GATE DVDD DVDD pfet_06v0 ad=58.1134p pd=77.985u as=58.1134p ps=77.985u w=76.465u l=1u
X9678 BAT GATE DVDD DVDD pfet_06v0 ad=58.1134p pd=77.985u as=58.1134p ps=77.985u w=76.465u l=1u
X9679 BAT GATE DVDD DVDD pfet_06v0 ad=58.1134p pd=77.985u as=58.1134p ps=77.985u w=76.465u l=1u
X9680 BAT GATE DVDD DVDD pfet_06v0 ad=58.1134p pd=77.985u as=58.1134p ps=77.985u w=76.465u l=1u
X9681 DVDD GATE BAT DVDD pfet_06v0 ad=49.3848p pd=66.5u as=49.3848p ps=66.5u w=64.98u l=1u
X9682 BAT GATE DVDD DVDD pfet_06v0 ad=58.1172p pd=77.99u as=58.1172p ps=77.99u w=76.47u l=1u
X9683 BAT GATE DVDD DVDD pfet_06v0 ad=35.511p pd=48.245u as=43.9215p ps=95.32999u w=46.725u l=1u
X9684 BAT GATE DVDD DVDD pfet_06v0 ad=58.1134p pd=77.985u as=71.8771p ps=0.15481m w=76.465u l=1u
X9685 BAT GATE DVDD DVDD pfet_06v0 ad=35.511p pd=48.245u as=35.511p ps=48.245u w=46.725u l=1u
X9686 DVDD GATE BAT DVDD pfet_06v0 ad=58.1134p pd=77.985u as=58.1134p ps=77.985u w=76.465u l=1u
X9687 DVDD GATE BAT DVDD pfet_06v0 ad=58.1172p pd=77.99u as=58.1172p ps=77.99u w=76.47u l=1u
X9688 BAT GATE DVDD DVDD pfet_06v0 ad=58.1134p pd=77.985u as=58.1134p ps=77.985u w=76.465u l=1u
X9689 BAT GATE DVDD DVDD pfet_06v0 ad=35.511p pd=48.245u as=35.511p ps=48.245u w=46.725u l=1u
X9690 DVDD GATE BAT DVDD pfet_06v0 ad=71.92879p pd=0.15492m as=58.1552p ps=78.04u w=76.52u l=1u
X9691 BAT GATE DVDD DVDD pfet_06v0 ad=58.1134p pd=77.985u as=58.1134p ps=77.985u w=76.465u l=1u
X9692 DVDD GATE BAT DVDD pfet_06v0 ad=35.5072p pd=48.24u as=35.5072p ps=48.24u w=46.72u l=1u
X9693 DVDD GATE BAT DVDD pfet_06v0 ad=35.511p pd=48.245u as=35.511p ps=48.245u w=46.725u l=1u
X9694 DVDD GATE BAT DVDD pfet_06v0 ad=35.511p pd=48.245u as=35.511p ps=48.245u w=46.725u l=1u
X9695 BAT GATE DVDD DVDD pfet_06v0 ad=58.1552p pd=78.04u as=58.1552p ps=78.04u w=76.52u l=1u
X9696 BAT GATE DVDD DVDD pfet_06v0 ad=58.1096p pd=77.98u as=58.1096p ps=77.98u w=76.46u l=1u
X9697 BAT GATE DVDD DVDD pfet_06v0 ad=35.511p pd=48.245u as=43.9215p ps=95.32999u w=46.725u l=1u
X9698 DVDD GATE BAT DVDD pfet_06v0 ad=58.1172p pd=77.99u as=58.1172p ps=77.99u w=76.47u l=1u
X9699 BAT GATE DVDD DVDD pfet_06v0 ad=35.511p pd=48.245u as=35.511p ps=48.245u w=46.725u l=1u
X9700 DVDD GATE BAT DVDD pfet_06v0 ad=58.1134p pd=77.985u as=58.1134p ps=77.985u w=76.465u l=1u
X9701 DVDD GATE BAT DVDD pfet_06v0 ad=43.9168p pd=95.32u as=35.5072p ps=48.24u w=46.72u l=1u
X9702 DVDD GATE BAT DVDD pfet_06v0 ad=61.0812p pd=0.13184m as=49.3848p ps=66.5u w=64.98u l=1u
X9703 BAT GATE DVDD DVDD pfet_06v0 ad=58.1134p pd=77.985u as=58.1134p ps=77.985u w=76.465u l=1u
X9704 BAT GATE DVDD DVDD pfet_06v0 ad=49.3848p pd=66.5u as=49.3848p ps=66.5u w=64.98u l=1u
X9705 DVDD GATE BAT DVDD pfet_06v0 ad=58.1134p pd=77.985u as=58.1134p ps=77.985u w=76.465u l=1u
X9706 BAT GATE DVDD DVDD pfet_06v0 ad=58.1134p pd=77.985u as=58.1134p ps=77.985u w=76.465u l=1u
X9707 BAT GATE DVDD DVDD pfet_06v0 ad=35.511p pd=48.245u as=35.511p ps=48.245u w=46.725u l=1u
X9708 BAT GATE DVDD DVDD pfet_06v0 ad=58.0754p pd=77.935u as=58.0754p ps=77.935u w=76.41499u l=1u
X9709 DVDD GATE BAT DVDD pfet_06v0 ad=35.511p pd=48.245u as=35.511p ps=48.245u w=46.725u l=1u
X9710 DVDD GATE BAT DVDD pfet_06v0 ad=35.511p pd=48.245u as=35.511p ps=48.245u w=46.725u l=1u
X9711 DVDD GATE BAT DVDD pfet_06v0 ad=58.1552p pd=78.04u as=58.1552p ps=78.04u w=76.52u l=1u
X9712 BAT GATE DVDD DVDD pfet_06v0 ad=58.0754p pd=77.935u as=58.0754p ps=77.935u w=76.41499u l=1u
X9713 DVDD GATE BAT DVDD pfet_06v0 ad=35.511p pd=48.245u as=35.511p ps=48.245u w=46.725u l=1u
X9714 DVDD GATE BAT DVDD pfet_06v0 ad=58.1134p pd=77.985u as=58.1134p ps=77.985u w=76.465u l=1u
X9715 BAT GATE DVDD DVDD pfet_06v0 ad=35.5072p pd=48.24u as=35.5072p ps=48.24u w=46.72u l=1u
X9716 BAT GATE DVDD DVDD pfet_06v0 ad=35.511p pd=48.245u as=35.511p ps=48.245u w=46.725u l=1u
X9717 BAT GATE DVDD DVDD pfet_06v0 ad=58.1134p pd=77.985u as=71.8771p ps=0.15481m w=76.465u l=1u
X9718 DVDD GATE BAT DVDD pfet_06v0 ad=58.1134p pd=77.985u as=58.1134p ps=77.985u w=76.465u l=1u
X9719 DVDD GATE BAT DVDD pfet_06v0 ad=58.1552p pd=78.04u as=58.1552p ps=78.04u w=76.52u l=1u
X9720 DVDD GATE BAT DVDD pfet_06v0 ad=35.511p pd=48.245u as=35.511p ps=48.245u w=46.725u l=1u
X9721 BAT GATE DVDD DVDD pfet_06v0 ad=35.511p pd=48.245u as=43.9215p ps=95.32999u w=46.725u l=1u
X9722 DVDD GATE BAT DVDD pfet_06v0 ad=49.3848p pd=66.5u as=49.3848p ps=66.5u w=64.98u l=1u
X9723 DVDD GATE BAT DVDD pfet_06v0 ad=58.0754p pd=77.935u as=58.0754p ps=77.935u w=76.41499u l=1u
X9724 BAT GATE DVDD DVDD pfet_06v0 ad=35.511p pd=48.245u as=35.511p ps=48.245u w=46.725u l=1u
X9725 DVDD GATE BAT DVDD pfet_06v0 ad=35.511p pd=48.245u as=35.511p ps=48.245u w=46.725u l=1u
X9726 BAT GATE DVDD DVDD pfet_06v0 ad=58.1134p pd=77.985u as=58.1134p ps=77.985u w=76.465u l=1u
X9727 BAT GATE DVDD DVDD pfet_06v0 ad=58.1096p pd=77.98u as=58.1096p ps=77.98u w=76.46u l=1u
X9728 DVDD GATE BAT DVDD pfet_06v0 ad=35.511p pd=48.245u as=35.511p ps=48.245u w=46.725u l=1u
X9729 DVDD GATE BAT DVDD pfet_06v0 ad=35.511p pd=48.245u as=35.511p ps=48.245u w=46.725u l=1u
X9730 BAT GATE DVDD DVDD pfet_06v0 ad=58.1096p pd=77.98u as=58.1096p ps=77.98u w=76.46u l=1u
X9731 BAT GATE DVDD DVDD pfet_06v0 ad=58.1134p pd=77.985u as=71.8771p ps=0.15481m w=76.465u l=1u
X9732 BAT GATE DVDD DVDD pfet_06v0 ad=35.511p pd=48.245u as=43.9215p ps=95.32999u w=46.725u l=1u
X9733 BAT GATE DVDD DVDD pfet_06v0 ad=35.511p pd=48.245u as=35.511p ps=48.245u w=46.725u l=1u
X9734 DVDD GATE BAT DVDD pfet_06v0 ad=43.9168p pd=95.32u as=35.5072p ps=48.24u w=46.72u l=1u
X9735 BAT GATE DVDD DVDD pfet_06v0 ad=35.511p pd=48.245u as=35.511p ps=48.245u w=46.725u l=1u
X9736 BAT GATE DVDD DVDD pfet_06v0 ad=58.1134p pd=77.985u as=58.1134p ps=77.985u w=76.465u l=1u
X9737 BAT GATE DVDD DVDD pfet_06v0 ad=58.1552p pd=78.04u as=58.1552p ps=78.04u w=76.52u l=1u
X9738 DVDD GATE BAT DVDD pfet_06v0 ad=43.9215p pd=95.32999u as=35.511p ps=48.245u w=46.725u l=1u
X9739 BAT GATE DVDD DVDD pfet_06v0 ad=58.1134p pd=77.985u as=58.1134p ps=77.985u w=76.465u l=1u
X9740 BAT GATE DVDD DVDD pfet_06v0 ad=58.0754p pd=77.935u as=58.0754p ps=77.935u w=76.41499u l=1u
X9741 DVDD GATE BAT DVDD pfet_06v0 ad=35.511p pd=48.245u as=35.511p ps=48.245u w=46.725u l=1u
X9742 BAT GATE DVDD DVDD pfet_06v0 ad=58.1134p pd=77.985u as=58.1134p ps=77.985u w=76.465u l=1u
X9743 BAT GATE DVDD DVDD pfet_06v0 ad=49.3848p pd=66.5u as=49.3848p ps=66.5u w=64.98u l=1u
X9744 DVDD GATE BAT DVDD pfet_06v0 ad=35.511p pd=48.245u as=35.511p ps=48.245u w=46.725u l=1u
X9745 BAT GATE DVDD DVDD pfet_06v0 ad=35.5072p pd=48.24u as=35.5072p ps=48.24u w=46.72u l=1u
X9746 DVDD GATE BAT DVDD pfet_06v0 ad=35.511p pd=48.245u as=35.511p ps=48.245u w=46.725u l=1u
X9747 DVDD GATE BAT DVDD pfet_06v0 ad=58.1134p pd=77.985u as=58.1134p ps=77.985u w=76.465u l=1u
X9748 DVDD GATE BAT DVDD pfet_06v0 ad=58.1134p pd=77.985u as=58.1134p ps=77.985u w=76.465u l=1u
X9749 DVDD GATE BAT DVDD pfet_06v0 ad=35.511p pd=48.245u as=35.511p ps=48.245u w=46.725u l=1u
X9750 BAT GATE DVDD DVDD pfet_06v0 ad=47.6862p pd=64.265u as=47.6862p ps=64.265u w=62.745u l=1u
X9751 BAT GATE DVDD DVDD pfet_06v0 ad=35.511p pd=48.245u as=35.511p ps=48.245u w=46.725u l=1u
X9752 BAT GATE DVDD DVDD pfet_06v0 ad=58.1172p pd=77.99u as=58.1172p ps=77.99u w=76.47u l=1u
X9753 BAT GATE DVDD DVDD pfet_06v0 ad=58.1134p pd=77.985u as=58.1134p ps=77.985u w=76.465u l=1u
X9754 DVDD GATE BAT DVDD pfet_06v0 ad=35.511p pd=48.245u as=35.511p ps=48.245u w=46.725u l=1u
X9755 DVDD GATE BAT DVDD pfet_06v0 ad=58.1134p pd=77.985u as=58.1134p ps=77.985u w=76.465u l=1u
X9756 BAT GATE DVDD DVDD pfet_06v0 ad=58.1172p pd=77.99u as=58.1172p ps=77.99u w=76.47u l=1u
X9757 DVDD GATE BAT DVDD pfet_06v0 ad=49.3848p pd=66.5u as=49.3848p ps=66.5u w=64.98u l=1u
X9758 BAT GATE DVDD DVDD pfet_06v0 ad=58.1134p pd=77.985u as=58.1134p ps=77.985u w=76.465u l=1u
X9759 DVDD GATE BAT DVDD pfet_06v0 ad=58.9803p pd=0.12737m as=47.6862p ps=64.265u w=62.745u l=1u
X9760 BAT GATE DVDD DVDD pfet_06v0 ad=35.511p pd=48.245u as=35.511p ps=48.245u w=46.725u l=1u
X9761 BAT GATE DVDD DVDD pfet_06v0 ad=58.1134p pd=77.985u as=71.8771p ps=0.15481m w=76.465u l=1u
X9762 DVDD GATE BAT DVDD pfet_06v0 ad=58.1096p pd=77.98u as=58.1096p ps=77.98u w=76.46u l=1u
X9763 BAT GATE DVDD DVDD pfet_06v0 ad=58.1134p pd=77.985u as=71.8771p ps=0.15481m w=76.465u l=1u
X9764 DVDD GATE BAT DVDD pfet_06v0 ad=35.511p pd=48.245u as=35.511p ps=48.245u w=46.725u l=1u
X9765 BAT GATE DVDD DVDD pfet_06v0 ad=35.511p pd=48.245u as=35.511p ps=48.245u w=46.725u l=1u
X9766 BAT GATE DVDD DVDD pfet_06v0 ad=47.6862p pd=64.265u as=47.6862p ps=64.265u w=62.745u l=1u
X9767 DVDD GATE BAT DVDD pfet_06v0 ad=35.5072p pd=48.24u as=35.5072p ps=48.24u w=46.72u l=1u
X9768 BAT GATE DVDD DVDD pfet_06v0 ad=35.511p pd=48.245u as=35.511p ps=48.245u w=46.725u l=1u
X9769 BAT GATE DVDD DVDD pfet_06v0 ad=35.511p pd=48.245u as=35.511p ps=48.245u w=46.725u l=1u
X9770 BAT GATE DVDD DVDD pfet_06v0 ad=35.511p pd=48.245u as=35.511p ps=48.245u w=46.725u l=1u
X9771 DVDD GATE BAT DVDD pfet_06v0 ad=71.8771p pd=0.15481m as=58.1134p ps=77.985u w=76.465u l=1u
X9772 BAT GATE DVDD DVDD pfet_06v0 ad=58.1134p pd=77.985u as=58.1134p ps=77.985u w=76.465u l=1u
X9773 DVDD GATE BAT DVDD pfet_06v0 ad=58.0754p pd=77.935u as=58.0754p ps=77.935u w=76.41499u l=1u
X9774 BAT GATE DVDD DVDD pfet_06v0 ad=35.511p pd=48.245u as=35.511p ps=48.245u w=46.725u l=1u
X9775 DVDD GATE BAT DVDD pfet_06v0 ad=35.5072p pd=48.24u as=35.5072p ps=48.24u w=46.72u l=1u
X9776 BAT GATE DVDD DVDD pfet_06v0 ad=47.6862p pd=64.265u as=58.9803p ps=0.12737m w=62.745u l=1u
X9777 BAT GATE DVDD DVDD pfet_06v0 ad=58.1134p pd=77.985u as=71.8771p ps=0.15481m w=76.465u l=1u
X9778 BAT GATE DVDD DVDD pfet_06v0 ad=35.511p pd=48.245u as=35.511p ps=48.245u w=46.725u l=1u
X9779 BAT GATE DVDD DVDD pfet_06v0 ad=35.511p pd=48.245u as=35.511p ps=48.245u w=46.725u l=1u
X9780 DVDD GATE BAT DVDD pfet_06v0 ad=35.5072p pd=48.24u as=35.5072p ps=48.24u w=46.72u l=1u
X9781 BAT GATE DVDD DVDD pfet_06v0 ad=35.511p pd=48.245u as=35.511p ps=48.245u w=46.725u l=1u
X9782 BAT GATE DVDD DVDD pfet_06v0 ad=58.1134p pd=77.985u as=58.1134p ps=77.985u w=76.465u l=1u
X9783 BAT GATE DVDD DVDD pfet_06v0 ad=47.6862p pd=64.265u as=47.6862p ps=64.265u w=62.745u l=1u
X9784 BAT GATE DVDD DVDD pfet_06v0 ad=58.1096p pd=77.98u as=58.1096p ps=77.98u w=76.46u l=1u
X9785 BAT GATE DVDD DVDD pfet_06v0 ad=47.6862p pd=64.265u as=47.6862p ps=64.265u w=62.745u l=1u
X9786 DVDD GATE BAT DVDD pfet_06v0 ad=58.1134p pd=77.985u as=58.1134p ps=77.985u w=76.465u l=1u
X9787 DVDD GATE BAT DVDD pfet_06v0 ad=58.1134p pd=77.985u as=58.1134p ps=77.985u w=76.465u l=1u
X9788 DVDD GATE BAT DVDD pfet_06v0 ad=58.1134p pd=77.985u as=58.1134p ps=77.985u w=76.465u l=1u
X9789 BAT GATE DVDD DVDD pfet_06v0 ad=58.1134p pd=77.985u as=58.1134p ps=77.985u w=76.465u l=1u
X9790 BAT GATE DVDD DVDD pfet_06v0 ad=49.3848p pd=66.5u as=49.3848p ps=66.5u w=64.98u l=1u
X9791 DVDD GATE BAT DVDD pfet_06v0 ad=35.511p pd=48.245u as=35.511p ps=48.245u w=46.725u l=1u
X9792 BAT GATE DVDD DVDD pfet_06v0 ad=58.1134p pd=77.985u as=58.1134p ps=77.985u w=76.465u l=1u
X9793 DVDD GATE BAT DVDD pfet_06v0 ad=58.1134p pd=77.985u as=58.1134p ps=77.985u w=76.465u l=1u
X9794 DVDD GATE BAT DVDD pfet_06v0 ad=35.511p pd=48.245u as=35.511p ps=48.245u w=46.725u l=1u
X9795 BAT GATE DVDD DVDD pfet_06v0 ad=35.511p pd=48.245u as=35.511p ps=48.245u w=46.725u l=1u
X9796 BAT GATE DVDD DVDD pfet_06v0 ad=35.511p pd=48.245u as=35.511p ps=48.245u w=46.725u l=1u
X9797 BAT GATE DVDD DVDD pfet_06v0 ad=35.511p pd=48.245u as=35.511p ps=48.245u w=46.725u l=1u
X9798 DVDD GATE BAT DVDD pfet_06v0 ad=58.1134p pd=77.985u as=58.1134p ps=77.985u w=76.465u l=1u
X9799 BAT GATE DVDD DVDD pfet_06v0 ad=58.1134p pd=77.985u as=58.1134p ps=77.985u w=76.465u l=1u
X9800 DVDD GATE BAT DVDD pfet_06v0 ad=58.1552p pd=78.04u as=58.1552p ps=78.04u w=76.52u l=1u
X9801 DVDD GATE BAT DVDD pfet_06v0 ad=58.1096p pd=77.98u as=58.1096p ps=77.98u w=76.46u l=1u
X9802 DVDD GATE BAT DVDD pfet_06v0 ad=58.1134p pd=77.985u as=58.1134p ps=77.985u w=76.465u l=1u
X9803 BAT GATE DVDD DVDD pfet_06v0 ad=58.1134p pd=77.985u as=71.8771p ps=0.15481m w=76.465u l=1u
X9804 DVDD GATE BAT DVDD pfet_06v0 ad=35.511p pd=48.245u as=35.511p ps=48.245u w=46.725u l=1u
X9805 DVDD GATE BAT DVDD pfet_06v0 ad=35.511p pd=48.245u as=35.511p ps=48.245u w=46.725u l=1u
X9806 BAT GATE DVDD DVDD pfet_06v0 ad=58.1134p pd=77.985u as=58.1134p ps=77.985u w=76.465u l=1u
X9807 DVDD GATE BAT DVDD pfet_06v0 ad=35.511p pd=48.245u as=35.511p ps=48.245u w=46.725u l=1u
X9808 BAT GATE DVDD DVDD pfet_06v0 ad=35.511p pd=48.245u as=43.9215p ps=95.32999u w=46.725u l=1u
X9809 BAT GATE DVDD DVDD pfet_06v0 ad=58.1134p pd=77.985u as=58.1134p ps=77.985u w=76.465u l=1u
X9810 BAT GATE DVDD DVDD pfet_06v0 ad=35.511p pd=48.245u as=35.511p ps=48.245u w=46.725u l=1u
X9811 DVDD GATE BAT DVDD pfet_06v0 ad=58.0754p pd=77.935u as=58.0754p ps=77.935u w=76.41499u l=1u
X9812 BAT GATE DVDD DVDD pfet_06v0 ad=35.511p pd=48.245u as=35.511p ps=48.245u w=46.725u l=1u
X9813 BAT GATE DVDD DVDD pfet_06v0 ad=35.511p pd=48.245u as=43.9215p ps=95.32999u w=46.725u l=1u
X9814 BAT GATE DVDD DVDD pfet_06v0 ad=35.511p pd=48.245u as=43.9215p ps=95.32999u w=46.725u l=1u
X9815 DVDD GATE BAT DVDD pfet_06v0 ad=35.5072p pd=48.24u as=35.5072p ps=48.24u w=46.72u l=1u
X9816 BAT GATE DVDD DVDD pfet_06v0 ad=35.511p pd=48.245u as=35.511p ps=48.245u w=46.725u l=1u
X9817 BAT GATE DVDD DVDD pfet_06v0 ad=58.1134p pd=77.985u as=58.1134p ps=77.985u w=76.465u l=1u
X9818 DVDD GATE BAT DVDD pfet_06v0 ad=61.0812p pd=0.13184m as=49.3848p ps=66.5u w=64.98u l=1u
X9819 BAT GATE DVDD DVDD pfet_06v0 ad=47.6862p pd=64.265u as=47.6862p ps=64.265u w=62.745u l=1u
X9820 BAT GATE DVDD DVDD pfet_06v0 ad=58.1134p pd=77.985u as=58.1134p ps=77.985u w=76.465u l=1u
X9821 BAT GATE DVDD DVDD pfet_06v0 ad=58.1134p pd=77.985u as=58.1134p ps=77.985u w=76.465u l=1u
X9822 BAT GATE DVDD DVDD pfet_06v0 ad=35.511p pd=48.245u as=35.511p ps=48.245u w=46.725u l=1u
X9823 DVDD GATE BAT DVDD pfet_06v0 ad=35.511p pd=48.245u as=35.511p ps=48.245u w=46.725u l=1u
X9824 BAT GATE DVDD DVDD pfet_06v0 ad=58.0754p pd=77.935u as=71.8301p ps=0.15471m w=76.41499u l=1u
X9825 BAT GATE DVDD DVDD pfet_06v0 ad=49.3848p pd=66.5u as=49.3848p ps=66.5u w=64.98u l=1u
X9826 DVDD GATE BAT DVDD pfet_06v0 ad=43.9215p pd=95.32999u as=35.511p ps=48.245u w=46.725u l=1u
X9827 BAT GATE DVDD DVDD pfet_06v0 ad=35.511p pd=48.245u as=35.511p ps=48.245u w=46.725u l=1u
X9828 BAT GATE DVDD DVDD pfet_06v0 ad=58.1134p pd=77.985u as=58.1134p ps=77.985u w=76.465u l=1u
X9829 BAT GATE DVDD DVDD pfet_06v0 ad=49.3848p pd=66.5u as=49.3848p ps=66.5u w=64.98u l=1u
X9830 DVDD GATE BAT DVDD pfet_06v0 ad=58.1096p pd=77.98u as=58.1096p ps=77.98u w=76.46u l=1u
X9831 DVDD GATE BAT DVDD pfet_06v0 ad=58.1134p pd=77.985u as=58.1134p ps=77.985u w=76.465u l=1u
X9832 DVDD GATE BAT DVDD pfet_06v0 ad=49.3848p pd=66.5u as=49.3848p ps=66.5u w=64.98u l=1u
X9833 BAT GATE DVDD DVDD pfet_06v0 ad=35.511p pd=48.245u as=35.511p ps=48.245u w=46.725u l=1u
X9834 DVDD GATE BAT DVDD pfet_06v0 ad=35.511p pd=48.245u as=35.511p ps=48.245u w=46.725u l=1u
X9835 BAT GATE DVDD DVDD pfet_06v0 ad=35.5072p pd=48.24u as=35.5072p ps=48.24u w=46.72u l=1u
X9836 DVDD GATE BAT DVDD pfet_06v0 ad=35.511p pd=48.245u as=35.511p ps=48.245u w=46.725u l=1u
X9837 BAT GATE DVDD DVDD pfet_06v0 ad=35.511p pd=48.245u as=35.511p ps=48.245u w=46.725u l=1u
X9838 BAT GATE DVDD DVDD pfet_06v0 ad=58.1134p pd=77.985u as=58.1134p ps=77.985u w=76.465u l=1u
X9839 DVDD GATE BAT DVDD pfet_06v0 ad=58.1134p pd=77.985u as=58.1134p ps=77.985u w=76.465u l=1u
X9840 DVDD GATE BAT DVDD pfet_06v0 ad=58.1134p pd=77.985u as=58.1134p ps=77.985u w=76.465u l=1u
X9841 BAT GATE DVDD DVDD pfet_06v0 ad=35.511p pd=48.245u as=35.511p ps=48.245u w=46.725u l=1u
X9842 BAT GATE DVDD DVDD pfet_06v0 ad=58.1172p pd=77.99u as=71.8818p ps=0.15482m w=76.47u l=1u
X9843 DVDD GATE BAT DVDD pfet_06v0 ad=58.1134p pd=77.985u as=58.1134p ps=77.985u w=76.465u l=1u
X9844 BAT GATE DVDD DVDD pfet_06v0 ad=58.1134p pd=77.985u as=58.1134p ps=77.985u w=76.465u l=1u
X9845 DVDD GATE BAT DVDD pfet_06v0 ad=35.5072p pd=48.24u as=35.5072p ps=48.24u w=46.72u l=1u
X9846 DVDD GATE BAT DVDD pfet_06v0 ad=58.1172p pd=77.99u as=58.1172p ps=77.99u w=76.47u l=1u
X9847 BAT GATE DVDD DVDD pfet_06v0 ad=58.1134p pd=77.985u as=58.1134p ps=77.985u w=76.465u l=1u
X9848 DVDD GATE BAT DVDD pfet_06v0 ad=71.8771p pd=0.15481m as=58.1134p ps=77.985u w=76.465u l=1u
X9849 DVDD GATE BAT DVDD pfet_06v0 ad=71.8301p pd=0.15471m as=58.0754p ps=77.935u w=76.41499u l=1u
X9850 BAT GATE DVDD DVDD pfet_06v0 ad=58.1134p pd=77.985u as=71.8771p ps=0.15481m w=76.465u l=1u
X9851 BAT GATE DVDD DVDD pfet_06v0 ad=58.1134p pd=77.985u as=58.1134p ps=77.985u w=76.465u l=1u
X9852 BAT GATE DVDD DVDD pfet_06v0 ad=58.1134p pd=77.985u as=58.1134p ps=77.985u w=76.465u l=1u
X9853 DVDD GATE BAT DVDD pfet_06v0 ad=49.3848p pd=66.5u as=49.3848p ps=66.5u w=64.98u l=1u
X9854 BAT GATE DVDD DVDD pfet_06v0 ad=58.1096p pd=77.98u as=58.1096p ps=77.98u w=76.46u l=1u
X9855 BAT GATE DVDD DVDD pfet_06v0 ad=47.6862p pd=64.265u as=47.6862p ps=64.265u w=62.745u l=1u
X9856 BAT GATE DVDD DVDD pfet_06v0 ad=58.1134p pd=77.985u as=58.1134p ps=77.985u w=76.465u l=1u
X9857 BAT GATE DVDD DVDD pfet_06v0 ad=35.511p pd=48.245u as=35.511p ps=48.245u w=46.725u l=1u
X9858 DVDD GATE BAT DVDD pfet_06v0 ad=58.1134p pd=77.985u as=58.1134p ps=77.985u w=76.465u l=1u
X9859 BAT GATE DVDD DVDD pfet_06v0 ad=58.1134p pd=77.985u as=58.1134p ps=77.985u w=76.465u l=1u
X9860 BAT GATE DVDD DVDD pfet_06v0 ad=35.5072p pd=48.24u as=35.5072p ps=48.24u w=46.72u l=1u
X9861 BAT GATE DVDD DVDD pfet_06v0 ad=58.1134p pd=77.985u as=58.1134p ps=77.985u w=76.465u l=1u
X9862 DVDD GATE BAT DVDD pfet_06v0 ad=58.1134p pd=77.985u as=58.1134p ps=77.985u w=76.465u l=1u
X9863 BAT GATE DVDD DVDD pfet_06v0 ad=49.3848p pd=66.5u as=61.0812p ps=0.13184m w=64.98u l=1u
X9864 DVDD GATE BAT DVDD pfet_06v0 ad=35.511p pd=48.245u as=35.511p ps=48.245u w=46.725u l=1u
X9865 BAT GATE DVDD DVDD pfet_06v0 ad=35.511p pd=48.245u as=43.9215p ps=95.32999u w=46.725u l=1u
X9866 DVDD GATE BAT DVDD pfet_06v0 ad=35.511p pd=48.245u as=35.511p ps=48.245u w=46.725u l=1u
X9867 BAT GATE DVDD DVDD pfet_06v0 ad=35.511p pd=48.245u as=35.511p ps=48.245u w=46.725u l=1u
X9868 BAT GATE DVDD DVDD pfet_06v0 ad=35.511p pd=48.245u as=35.511p ps=48.245u w=46.725u l=1u
X9869 DVDD GATE BAT DVDD pfet_06v0 ad=35.511p pd=48.245u as=35.511p ps=48.245u w=46.725u l=1u
X9870 DVDD GATE BAT DVDD pfet_06v0 ad=35.511p pd=48.245u as=35.511p ps=48.245u w=46.725u l=1u
X9871 DVDD GATE BAT DVDD pfet_06v0 ad=35.511p pd=48.245u as=35.511p ps=48.245u w=46.725u l=1u
X9872 DVDD GATE BAT DVDD pfet_06v0 ad=58.1134p pd=77.985u as=58.1134p ps=77.985u w=76.465u l=1u
X9873 DVDD GATE BAT DVDD pfet_06v0 ad=35.511p pd=48.245u as=35.511p ps=48.245u w=46.725u l=1u
X9874 DVDD GATE BAT DVDD pfet_06v0 ad=43.9215p pd=95.32999u as=35.511p ps=48.245u w=46.725u l=1u
X9875 BAT GATE DVDD DVDD pfet_06v0 ad=35.511p pd=48.245u as=43.9215p ps=95.32999u w=46.725u l=1u
X9876 DVDD GATE BAT DVDD pfet_06v0 ad=35.511p pd=48.245u as=35.511p ps=48.245u w=46.725u l=1u
X9877 BAT GATE DVDD DVDD pfet_06v0 ad=58.1134p pd=77.985u as=58.1134p ps=77.985u w=76.465u l=1u
X9878 DVDD GATE BAT DVDD pfet_06v0 ad=35.511p pd=48.245u as=35.511p ps=48.245u w=46.725u l=1u
X9879 BAT GATE DVDD DVDD pfet_06v0 ad=58.1134p pd=77.985u as=58.1134p ps=77.985u w=76.465u l=1u
X9880 DVDD GATE BAT DVDD pfet_06v0 ad=43.9215p pd=95.32999u as=35.511p ps=48.245u w=46.725u l=1u
X9881 BAT GATE DVDD DVDD pfet_06v0 ad=35.511p pd=48.245u as=35.511p ps=48.245u w=46.725u l=1u
X9882 BAT GATE DVDD DVDD pfet_06v0 ad=35.511p pd=48.245u as=43.9215p ps=95.32999u w=46.725u l=1u
X9883 BAT GATE DVDD DVDD pfet_06v0 ad=35.511p pd=48.245u as=43.9215p ps=95.32999u w=46.725u l=1u
X9884 DVDD GATE BAT DVDD pfet_06v0 ad=58.1096p pd=77.98u as=58.1096p ps=77.98u w=76.46u l=1u
X9885 DVDD GATE BAT DVDD pfet_06v0 ad=71.8771p pd=0.15481m as=58.1134p ps=77.985u w=76.465u l=1u
X9886 BAT GATE DVDD DVDD pfet_06v0 ad=58.1134p pd=77.985u as=58.1134p ps=77.985u w=76.465u l=1u
X9887 BAT GATE DVDD DVDD pfet_06v0 ad=58.1172p pd=77.99u as=58.1172p ps=77.99u w=76.47u l=1u
X9888 DVDD GATE BAT DVDD pfet_06v0 ad=35.511p pd=48.245u as=35.511p ps=48.245u w=46.725u l=1u
X9889 DVDD GATE BAT DVDD pfet_06v0 ad=71.8724p pd=0.1548m as=58.1096p ps=77.98u w=76.46u l=1u
X9890 DVDD GATE BAT DVDD pfet_06v0 ad=49.3848p pd=66.5u as=49.3848p ps=66.5u w=64.98u l=1u
X9891 DVDD GATE BAT DVDD pfet_06v0 ad=58.1134p pd=77.985u as=58.1134p ps=77.985u w=76.465u l=1u
X9892 BAT GATE DVDD DVDD pfet_06v0 ad=35.511p pd=48.245u as=35.511p ps=48.245u w=46.725u l=1u
X9893 BAT GATE DVDD DVDD pfet_06v0 ad=35.511p pd=48.245u as=35.511p ps=48.245u w=46.725u l=1u
X9894 DVDD GATE BAT DVDD pfet_06v0 ad=35.511p pd=48.245u as=35.511p ps=48.245u w=46.725u l=1u
X9895 BAT GATE DVDD DVDD pfet_06v0 ad=35.511p pd=48.245u as=35.511p ps=48.245u w=46.725u l=1u
X9896 BAT GATE DVDD DVDD pfet_06v0 ad=58.1134p pd=77.985u as=58.1134p ps=77.985u w=76.465u l=1u
X9897 BAT GATE DVDD DVDD pfet_06v0 ad=58.1096p pd=77.98u as=58.1096p ps=77.98u w=76.46u l=1u
X9898 DVDD GATE BAT DVDD pfet_06v0 ad=35.511p pd=48.245u as=35.511p ps=48.245u w=46.725u l=1u
X9899 DVDD GATE BAT DVDD pfet_06v0 ad=58.0754p pd=77.935u as=58.0754p ps=77.935u w=76.41499u l=1u
X9900 BAT GATE DVDD DVDD pfet_06v0 ad=35.511p pd=48.245u as=35.511p ps=48.245u w=46.725u l=1u
X9901 DVDD GATE BAT DVDD pfet_06v0 ad=58.1134p pd=77.985u as=58.1134p ps=77.985u w=76.465u l=1u
X9902 DVDD GATE BAT DVDD pfet_06v0 ad=58.1134p pd=77.985u as=58.1134p ps=77.985u w=76.465u l=1u
X9903 DVDD GATE BAT DVDD pfet_06v0 ad=58.1172p pd=77.99u as=58.1172p ps=77.99u w=76.47u l=1u
X9904 DVDD GATE BAT DVDD pfet_06v0 ad=35.511p pd=48.245u as=35.511p ps=48.245u w=46.725u l=1u
X9905 BAT GATE DVDD DVDD pfet_06v0 ad=58.1134p pd=77.985u as=71.8771p ps=0.15481m w=76.465u l=1u
X9906 BAT GATE DVDD DVDD pfet_06v0 ad=58.1172p pd=77.99u as=58.1172p ps=77.99u w=76.47u l=1u
X9907 BAT GATE DVDD DVDD pfet_06v0 ad=35.5072p pd=48.24u as=35.5072p ps=48.24u w=46.72u l=1u
X9908 DVDD GATE BAT DVDD pfet_06v0 ad=35.511p pd=48.245u as=35.511p ps=48.245u w=46.725u l=1u
X9909 DVDD GATE BAT DVDD pfet_06v0 ad=58.1134p pd=77.985u as=58.1134p ps=77.985u w=76.465u l=1u
X9910 BAT GATE DVDD DVDD pfet_06v0 ad=58.1552p pd=78.04u as=58.1552p ps=78.04u w=76.52u l=1u
X9911 BAT GATE DVDD DVDD pfet_06v0 ad=35.511p pd=48.245u as=35.511p ps=48.245u w=46.725u l=1u
X9912 DVDD GATE BAT DVDD pfet_06v0 ad=58.1134p pd=77.985u as=58.1134p ps=77.985u w=76.465u l=1u
X9913 DVDD GATE BAT DVDD pfet_06v0 ad=47.6862p pd=64.265u as=47.6862p ps=64.265u w=62.745u l=1u
X9914 BAT GATE DVDD DVDD pfet_06v0 ad=58.1134p pd=77.985u as=71.8771p ps=0.15481m w=76.465u l=1u
X9915 BAT GATE DVDD DVDD pfet_06v0 ad=35.5072p pd=48.24u as=43.9168p ps=95.32u w=46.72u l=1u
X9916 DVDD GATE BAT DVDD pfet_06v0 ad=71.8771p pd=0.15481m as=58.1134p ps=77.985u w=76.465u l=1u
X9917 DVDD GATE BAT DVDD pfet_06v0 ad=47.6862p pd=64.265u as=47.6862p ps=64.265u w=62.745u l=1u
X9918 DVDD GATE BAT DVDD pfet_06v0 ad=58.1134p pd=77.985u as=58.1134p ps=77.985u w=76.465u l=1u
X9919 DVDD GATE BAT DVDD pfet_06v0 ad=35.511p pd=48.245u as=35.511p ps=48.245u w=46.725u l=1u
X9920 DVDD GATE BAT DVDD pfet_06v0 ad=58.1134p pd=77.985u as=58.1134p ps=77.985u w=76.465u l=1u
X9921 BAT GATE DVDD DVDD pfet_06v0 ad=49.3848p pd=66.5u as=49.3848p ps=66.5u w=64.98u l=1u
X9922 BAT GATE DVDD DVDD pfet_06v0 ad=58.1134p pd=77.985u as=58.1134p ps=77.985u w=76.465u l=1u
X9923 DVDD GATE BAT DVDD pfet_06v0 ad=71.8724p pd=0.1548m as=58.1096p ps=77.98u w=76.46u l=1u
X9924 BAT GATE DVDD DVDD pfet_06v0 ad=35.511p pd=48.245u as=43.9215p ps=95.32999u w=46.725u l=1u
X9925 DVDD GATE BAT DVDD pfet_06v0 ad=58.1552p pd=78.04u as=58.1552p ps=78.04u w=76.52u l=1u
X9926 BAT GATE DVDD DVDD pfet_06v0 ad=58.1552p pd=78.04u as=58.1552p ps=78.04u w=76.52u l=1u
X9927 DVDD GATE BAT DVDD pfet_06v0 ad=49.3848p pd=66.5u as=49.3848p ps=66.5u w=64.98u l=1u
X9928 DVDD GATE BAT DVDD pfet_06v0 ad=61.0812p pd=0.13184m as=49.3848p ps=66.5u w=64.98u l=1u
X9929 DVDD GATE BAT DVDD pfet_06v0 ad=35.511p pd=48.245u as=35.511p ps=48.245u w=46.725u l=1u
X9930 DVDD GATE BAT DVDD pfet_06v0 ad=58.0754p pd=77.935u as=58.0754p ps=77.935u w=76.41499u l=1u
X9931 BAT GATE DVDD DVDD pfet_06v0 ad=49.3848p pd=66.5u as=49.3848p ps=66.5u w=64.98u l=1u
X9932 DVDD GATE BAT DVDD pfet_06v0 ad=58.0754p pd=77.935u as=58.0754p ps=77.935u w=76.41499u l=1u
X9933 BAT GATE DVDD DVDD pfet_06v0 ad=58.1134p pd=77.985u as=58.1134p ps=77.985u w=76.465u l=1u
X9934 BAT GATE DVDD DVDD pfet_06v0 ad=58.1134p pd=77.985u as=58.1134p ps=77.985u w=76.465u l=1u
X9935 BAT GATE DVDD DVDD pfet_06v0 ad=35.511p pd=48.245u as=35.511p ps=48.245u w=46.725u l=1u
X9936 DVDD GATE BAT DVDD pfet_06v0 ad=58.0754p pd=77.935u as=58.0754p ps=77.935u w=76.41499u l=1u
X9937 DVDD GATE BAT DVDD pfet_06v0 ad=58.1134p pd=77.985u as=58.1134p ps=77.985u w=76.465u l=1u
X9938 BAT GATE DVDD DVDD pfet_06v0 ad=35.511p pd=48.245u as=35.511p ps=48.245u w=46.725u l=1u
X9939 BAT GATE DVDD DVDD pfet_06v0 ad=58.1552p pd=78.04u as=58.1552p ps=78.04u w=76.52u l=1u
X9940 DVDD GATE BAT DVDD pfet_06v0 ad=58.1134p pd=77.985u as=58.1134p ps=77.985u w=76.465u l=1u
X9941 DVDD GATE BAT DVDD pfet_06v0 ad=58.1134p pd=77.985u as=58.1134p ps=77.985u w=76.465u l=1u
X9942 DVDD GATE BAT DVDD pfet_06v0 ad=43.9215p pd=95.32999u as=35.511p ps=48.245u w=46.725u l=1u
X9943 DVDD GATE BAT DVDD pfet_06v0 ad=35.511p pd=48.245u as=35.511p ps=48.245u w=46.725u l=1u
X9944 DVDD GATE BAT DVDD pfet_06v0 ad=58.1134p pd=77.985u as=58.1134p ps=77.985u w=76.465u l=1u
X9945 DVDD GATE BAT DVDD pfet_06v0 ad=35.511p pd=48.245u as=35.511p ps=48.245u w=46.725u l=1u
X9946 DVDD GATE BAT DVDD pfet_06v0 ad=35.511p pd=48.245u as=35.511p ps=48.245u w=46.725u l=1u
X9947 DVDD GATE BAT DVDD pfet_06v0 ad=43.9215p pd=95.32999u as=35.511p ps=48.245u w=46.725u l=1u
X9948 BAT GATE DVDD DVDD pfet_06v0 ad=35.511p pd=48.245u as=35.511p ps=48.245u w=46.725u l=1u
X9949 BAT GATE DVDD DVDD pfet_06v0 ad=58.1134p pd=77.985u as=58.1134p ps=77.985u w=76.465u l=1u
X9950 DVDD GATE BAT DVDD pfet_06v0 ad=43.9215p pd=95.32999u as=35.511p ps=48.245u w=46.725u l=1u
X9951 BAT GATE DVDD DVDD pfet_06v0 ad=35.511p pd=48.245u as=35.511p ps=48.245u w=46.725u l=1u
X9952 BAT GATE DVDD DVDD pfet_06v0 ad=58.1134p pd=77.985u as=71.8771p ps=0.15481m w=76.465u l=1u
X9953 DVDD GATE BAT DVDD pfet_06v0 ad=58.1134p pd=77.985u as=58.1134p ps=77.985u w=76.465u l=1u
X9954 DVDD GATE BAT DVDD pfet_06v0 ad=71.8818p pd=0.15482m as=58.1172p ps=77.99u w=76.47u l=1u
X9955 BAT GATE DVDD DVDD pfet_06v0 ad=49.3848p pd=66.5u as=49.3848p ps=66.5u w=64.98u l=1u
X9956 DVDD GATE BAT DVDD pfet_06v0 ad=43.9215p pd=95.32999u as=35.511p ps=48.245u w=46.725u l=1u
X9957 BAT GATE DVDD DVDD pfet_06v0 ad=35.511p pd=48.245u as=35.511p ps=48.245u w=46.725u l=1u
X9958 DVDD GATE BAT DVDD pfet_06v0 ad=58.1096p pd=77.98u as=58.1096p ps=77.98u w=76.46u l=1u
X9959 DVDD GATE BAT DVDD pfet_06v0 ad=58.0754p pd=77.935u as=58.0754p ps=77.935u w=76.41499u l=1u
X9960 BAT GATE DVDD DVDD pfet_06v0 ad=58.1552p pd=78.04u as=58.1552p ps=78.04u w=76.52u l=1u
X9961 BAT GATE DVDD DVDD pfet_06v0 ad=58.1134p pd=77.985u as=58.1134p ps=77.985u w=76.465u l=1u
X9962 BAT GATE DVDD DVDD pfet_06v0 ad=35.511p pd=48.245u as=43.9215p ps=95.32999u w=46.725u l=1u
X9963 BAT GATE DVDD DVDD pfet_06v0 ad=35.511p pd=48.245u as=35.511p ps=48.245u w=46.725u l=1u
X9964 BAT GATE DVDD DVDD pfet_06v0 ad=35.511p pd=48.245u as=43.9215p ps=95.32999u w=46.725u l=1u
X9965 DVDD GATE BAT DVDD pfet_06v0 ad=43.9215p pd=95.32999u as=35.511p ps=48.245u w=46.725u l=1u
X9966 DVDD GATE BAT DVDD pfet_06v0 ad=58.1096p pd=77.98u as=58.1096p ps=77.98u w=76.46u l=1u
X9967 BAT GATE DVDD DVDD pfet_06v0 ad=35.511p pd=48.245u as=35.511p ps=48.245u w=46.725u l=1u
X9968 DVDD GATE BAT DVDD pfet_06v0 ad=35.511p pd=48.245u as=35.511p ps=48.245u w=46.725u l=1u
X9969 DVDD GATE BAT DVDD pfet_06v0 ad=58.1134p pd=77.985u as=58.1134p ps=77.985u w=76.465u l=1u
X9970 DVDD GATE BAT DVDD pfet_06v0 ad=35.511p pd=48.245u as=35.511p ps=48.245u w=46.725u l=1u
X9971 BAT GATE DVDD DVDD pfet_06v0 ad=35.511p pd=48.245u as=43.9215p ps=95.32999u w=46.725u l=1u
X9972 DVDD GATE BAT DVDD pfet_06v0 ad=35.511p pd=48.245u as=35.511p ps=48.245u w=46.725u l=1u
X9973 BAT GATE DVDD DVDD pfet_06v0 ad=35.511p pd=48.245u as=35.511p ps=48.245u w=46.725u l=1u
X9974 BAT GATE DVDD DVDD pfet_06v0 ad=35.511p pd=48.245u as=35.511p ps=48.245u w=46.725u l=1u
X9975 DVDD GATE BAT DVDD pfet_06v0 ad=58.1172p pd=77.99u as=58.1172p ps=77.99u w=76.47u l=1u
X9976 DVDD GATE BAT DVDD pfet_06v0 ad=58.1134p pd=77.985u as=58.1134p ps=77.985u w=76.465u l=1u
X9977 DVDD GATE BAT DVDD pfet_06v0 ad=35.511p pd=48.245u as=35.511p ps=48.245u w=46.725u l=1u
X9978 DVDD GATE BAT DVDD pfet_06v0 ad=35.5072p pd=48.24u as=35.5072p ps=48.24u w=46.72u l=1u
X9979 BAT GATE DVDD DVDD pfet_06v0 ad=58.1134p pd=77.985u as=58.1134p ps=77.985u w=76.465u l=1u
X9980 BAT GATE DVDD DVDD pfet_06v0 ad=47.6862p pd=64.265u as=47.6862p ps=64.265u w=62.745u l=1u
X9981 BAT GATE DVDD DVDD pfet_06v0 ad=35.511p pd=48.245u as=35.511p ps=48.245u w=46.725u l=1u
X9982 BAT GATE DVDD DVDD pfet_06v0 ad=35.511p pd=48.245u as=43.9215p ps=95.32999u w=46.725u l=1u
X9983 BAT GATE DVDD DVDD pfet_06v0 ad=35.5072p pd=48.24u as=35.5072p ps=48.24u w=46.72u l=1u
X9984 DVDD GATE BAT DVDD pfet_06v0 ad=58.1172p pd=77.99u as=58.1172p ps=77.99u w=76.47u l=1u
X9985 BAT GATE DVDD DVDD pfet_06v0 ad=35.511p pd=48.245u as=35.511p ps=48.245u w=46.725u l=1u
X9986 DVDD GATE BAT DVDD pfet_06v0 ad=35.511p pd=48.245u as=35.511p ps=48.245u w=46.725u l=1u
X9987 BAT GATE DVDD DVDD pfet_06v0 ad=35.511p pd=48.245u as=35.511p ps=48.245u w=46.725u l=1u
X9988 BAT GATE DVDD DVDD pfet_06v0 ad=58.1134p pd=77.985u as=58.1134p ps=77.985u w=76.465u l=1u
X9989 DVDD GATE BAT DVDD pfet_06v0 ad=58.1134p pd=77.985u as=58.1134p ps=77.985u w=76.465u l=1u
X9990 DVDD GATE BAT DVDD pfet_06v0 ad=35.511p pd=48.245u as=35.511p ps=48.245u w=46.725u l=1u
X9991 BAT GATE DVDD DVDD pfet_06v0 ad=58.0754p pd=77.935u as=71.8301p ps=0.15471m w=76.41499u l=1u
X9992 BAT GATE DVDD DVDD pfet_06v0 ad=58.1552p pd=78.04u as=58.1552p ps=78.04u w=76.52u l=1u
X9993 DVDD GATE BAT DVDD pfet_06v0 ad=71.92879p pd=0.15492m as=58.1552p ps=78.04u w=76.52u l=1u
X9994 BAT GATE DVDD DVDD pfet_06v0 ad=58.0754p pd=77.935u as=58.0754p ps=77.935u w=76.41499u l=1u
X9995 BAT GATE DVDD DVDD pfet_06v0 ad=35.511p pd=48.245u as=35.511p ps=48.245u w=46.725u l=1u
X9996 DVDD GATE BAT DVDD pfet_06v0 ad=71.8771p pd=0.15481m as=58.1134p ps=77.985u w=76.465u l=1u
X9997 DVDD GATE BAT DVDD pfet_06v0 ad=35.511p pd=48.245u as=35.511p ps=48.245u w=46.725u l=1u
X9998 BAT GATE DVDD DVDD pfet_06v0 ad=35.511p pd=48.245u as=43.9215p ps=95.32999u w=46.725u l=1u
X9999 BAT GATE DVDD DVDD pfet_06v0 ad=35.511p pd=48.245u as=35.511p ps=48.245u w=46.725u l=1u
X10000 BAT GATE DVDD DVDD pfet_06v0 ad=58.1134p pd=77.985u as=71.8771p ps=0.15481m w=76.465u l=1u
X10001 BAT GATE DVDD DVDD pfet_06v0 ad=58.1134p pd=77.985u as=58.1134p ps=77.985u w=76.465u l=1u
X10002 BAT GATE DVDD DVDD pfet_06v0 ad=35.511p pd=48.245u as=35.511p ps=48.245u w=46.725u l=1u
X10003 DVDD GATE BAT DVDD pfet_06v0 ad=71.8771p pd=0.15481m as=58.1134p ps=77.985u w=76.465u l=1u
X10004 BAT GATE DVDD DVDD pfet_06v0 ad=58.1134p pd=77.985u as=58.1134p ps=77.985u w=76.465u l=1u
X10005 DVDD GATE BAT DVDD pfet_06v0 ad=35.511p pd=48.245u as=35.511p ps=48.245u w=46.725u l=1u
X10006 BAT GATE DVDD DVDD pfet_06v0 ad=47.6862p pd=64.265u as=47.6862p ps=64.265u w=62.745u l=1u
X10007 BAT GATE DVDD DVDD pfet_06v0 ad=58.1134p pd=77.985u as=58.1134p ps=77.985u w=76.465u l=1u
X10008 BAT GATE DVDD DVDD pfet_06v0 ad=58.1134p pd=77.985u as=58.1134p ps=77.985u w=76.465u l=1u
X10009 DVDD GATE BAT DVDD pfet_06v0 ad=58.1134p pd=77.985u as=58.1134p ps=77.985u w=76.465u l=1u
X10010 BAT GATE DVDD DVDD pfet_06v0 ad=35.511p pd=48.245u as=35.511p ps=48.245u w=46.725u l=1u
X10011 BAT GATE DVDD DVDD pfet_06v0 ad=58.1172p pd=77.99u as=58.1172p ps=77.99u w=76.47u l=1u
X10012 BAT GATE DVDD DVDD pfet_06v0 ad=35.511p pd=48.245u as=35.511p ps=48.245u w=46.725u l=1u
X10013 DVDD GATE BAT DVDD pfet_06v0 ad=58.1172p pd=77.99u as=58.1172p ps=77.99u w=76.47u l=1u
X10014 BAT GATE DVDD DVDD pfet_06v0 ad=35.511p pd=48.245u as=35.511p ps=48.245u w=46.725u l=1u
X10015 BAT GATE DVDD DVDD pfet_06v0 ad=58.1134p pd=77.985u as=58.1134p ps=77.985u w=76.465u l=1u
X10016 DVDD GATE BAT DVDD pfet_06v0 ad=58.1552p pd=78.04u as=58.1552p ps=78.04u w=76.52u l=1u
X10017 DVDD GATE BAT DVDD pfet_06v0 ad=35.511p pd=48.245u as=35.511p ps=48.245u w=46.725u l=1u
X10018 BAT GATE DVDD DVDD pfet_06v0 ad=47.6862p pd=64.265u as=47.6862p ps=64.265u w=62.745u l=1u
X10019 BAT GATE DVDD DVDD pfet_06v0 ad=58.1134p pd=77.985u as=58.1134p ps=77.985u w=76.465u l=1u
X10020 DVDD GATE BAT DVDD pfet_06v0 ad=43.9215p pd=95.32999u as=35.511p ps=48.245u w=46.725u l=1u
X10021 DVDD GATE BAT DVDD pfet_06v0 ad=49.3848p pd=66.5u as=49.3848p ps=66.5u w=64.98u l=1u
X10022 BAT GATE DVDD DVDD pfet_06v0 ad=58.1552p pd=78.04u as=58.1552p ps=78.04u w=76.52u l=1u
X10023 DVDD GATE BAT DVDD pfet_06v0 ad=61.0812p pd=0.13184m as=49.3848p ps=66.5u w=64.98u l=1u
X10024 BAT GATE DVDD DVDD pfet_06v0 ad=35.511p pd=48.245u as=43.9215p ps=95.32999u w=46.725u l=1u
X10025 DVDD GATE BAT DVDD pfet_06v0 ad=58.1134p pd=77.985u as=58.1134p ps=77.985u w=76.465u l=1u
X10026 BAT GATE DVDD DVDD pfet_06v0 ad=49.3848p pd=66.5u as=49.3848p ps=66.5u w=64.98u l=1u
X10027 DVDD GATE BAT DVDD pfet_06v0 ad=58.1134p pd=77.985u as=58.1134p ps=77.985u w=76.465u l=1u
X10028 DVDD GATE BAT DVDD pfet_06v0 ad=49.3848p pd=66.5u as=49.3848p ps=66.5u w=64.98u l=1u
X10029 BAT GATE DVDD DVDD pfet_06v0 ad=58.0754p pd=77.935u as=58.0754p ps=77.935u w=76.41499u l=1u
X10030 BAT GATE DVDD DVDD pfet_06v0 ad=58.1096p pd=77.98u as=58.1096p ps=77.98u w=76.46u l=1u
X10031 DVDD GATE BAT DVDD pfet_06v0 ad=35.511p pd=48.245u as=35.511p ps=48.245u w=46.725u l=1u
X10032 DVDD GATE BAT DVDD pfet_06v0 ad=58.1552p pd=78.04u as=58.1552p ps=78.04u w=76.52u l=1u
X10033 BAT GATE DVDD DVDD pfet_06v0 ad=58.0754p pd=77.935u as=58.0754p ps=77.935u w=76.41499u l=1u
X10034 DVDD GATE BAT DVDD pfet_06v0 ad=35.511p pd=48.245u as=35.511p ps=48.245u w=46.725u l=1u
X10035 DVDD GATE BAT DVDD pfet_06v0 ad=71.8771p pd=0.15481m as=58.1134p ps=77.985u w=76.465u l=1u
X10036 BAT GATE DVDD DVDD pfet_06v0 ad=35.511p pd=48.245u as=35.511p ps=48.245u w=46.725u l=1u
X10037 BAT GATE DVDD DVDD pfet_06v0 ad=58.1552p pd=78.04u as=58.1552p ps=78.04u w=76.52u l=1u
X10038 BAT GATE DVDD DVDD pfet_06v0 ad=35.511p pd=48.245u as=35.511p ps=48.245u w=46.725u l=1u
X10039 BAT GATE DVDD DVDD pfet_06v0 ad=35.511p pd=48.245u as=43.9215p ps=95.32999u w=46.725u l=1u
X10040 DVDD GATE BAT DVDD pfet_06v0 ad=58.1134p pd=77.985u as=58.1134p ps=77.985u w=76.465u l=1u
X10041 DVDD GATE BAT DVDD pfet_06v0 ad=58.1552p pd=78.04u as=58.1552p ps=78.04u w=76.52u l=1u
X10042 BAT GATE DVDD DVDD pfet_06v0 ad=58.0754p pd=77.935u as=58.0754p ps=77.935u w=76.41499u l=1u
X10043 DVDD GATE BAT DVDD pfet_06v0 ad=49.3848p pd=66.5u as=49.3848p ps=66.5u w=64.98u l=1u
X10044 BAT GATE DVDD DVDD pfet_06v0 ad=35.511p pd=48.245u as=35.511p ps=48.245u w=46.725u l=1u
X10045 BAT GATE DVDD DVDD pfet_06v0 ad=35.511p pd=48.245u as=35.511p ps=48.245u w=46.725u l=1u
X10046 DVDD GATE BAT DVDD pfet_06v0 ad=35.511p pd=48.245u as=35.511p ps=48.245u w=46.725u l=1u
X10047 DVDD GATE BAT DVDD pfet_06v0 ad=58.9803p pd=0.12737m as=47.6862p ps=64.265u w=62.745u l=1u
X10048 DVDD GATE BAT DVDD pfet_06v0 ad=58.1172p pd=77.99u as=58.1172p ps=77.99u w=76.47u l=1u
X10049 BAT GATE DVDD DVDD pfet_06v0 ad=35.511p pd=48.245u as=35.511p ps=48.245u w=46.725u l=1u
X10050 DVDD GATE BAT DVDD pfet_06v0 ad=43.9215p pd=95.32999u as=35.511p ps=48.245u w=46.725u l=1u
X10051 BAT GATE DVDD DVDD pfet_06v0 ad=35.511p pd=48.245u as=35.511p ps=48.245u w=46.725u l=1u
X10052 BAT GATE DVDD DVDD pfet_06v0 ad=58.1096p pd=77.98u as=58.1096p ps=77.98u w=76.46u l=1u
X10053 DVDD GATE BAT DVDD pfet_06v0 ad=35.511p pd=48.245u as=35.511p ps=48.245u w=46.725u l=1u
X10054 DVDD GATE BAT DVDD pfet_06v0 ad=35.511p pd=48.245u as=35.511p ps=48.245u w=46.725u l=1u
X10055 BAT GATE DVDD DVDD pfet_06v0 ad=35.511p pd=48.245u as=35.511p ps=48.245u w=46.725u l=1u
X10056 BAT GATE DVDD DVDD pfet_06v0 ad=58.1096p pd=77.98u as=71.8724p ps=0.1548m w=76.46u l=1u
X10057 DVDD GATE BAT DVDD pfet_06v0 ad=71.8818p pd=0.15482m as=58.1172p ps=77.99u w=76.47u l=1u
X10058 DVDD GATE BAT DVDD pfet_06v0 ad=71.8771p pd=0.15481m as=58.1134p ps=77.985u w=76.465u l=1u
X10059 BAT GATE DVDD DVDD pfet_06v0 ad=35.511p pd=48.245u as=43.9215p ps=95.32999u w=46.725u l=1u
X10060 DVDD GATE BAT DVDD pfet_06v0 ad=43.9215p pd=95.32999u as=35.511p ps=48.245u w=46.725u l=1u
X10061 BAT GATE DVDD DVDD pfet_06v0 ad=35.511p pd=48.245u as=43.9215p ps=95.32999u w=46.725u l=1u
X10062 DVDD GATE BAT DVDD pfet_06v0 ad=35.5072p pd=48.24u as=35.5072p ps=48.24u w=46.72u l=1u
X10063 BAT GATE DVDD DVDD pfet_06v0 ad=58.1172p pd=77.99u as=58.1172p ps=77.99u w=76.47u l=1u
X10064 BAT GATE DVDD DVDD pfet_06v0 ad=58.1134p pd=77.985u as=58.1134p ps=77.985u w=76.465u l=1u
X10065 BAT GATE DVDD DVDD pfet_06v0 ad=58.1134p pd=77.985u as=58.1134p ps=77.985u w=76.465u l=1u
X10066 DVDD GATE BAT DVDD pfet_06v0 ad=58.1552p pd=78.04u as=58.1552p ps=78.04u w=76.52u l=1u
X10067 BAT GATE DVDD DVDD pfet_06v0 ad=58.1134p pd=77.985u as=71.8771p ps=0.15481m w=76.465u l=1u
X10068 BAT GATE DVDD DVDD pfet_06v0 ad=49.3848p pd=66.5u as=49.3848p ps=66.5u w=64.98u l=1u
X10069 BAT GATE DVDD DVDD pfet_06v0 ad=35.5072p pd=48.24u as=43.9168p ps=95.32u w=46.72u l=1u
X10070 DVDD GATE BAT DVDD pfet_06v0 ad=71.8771p pd=0.15481m as=58.1134p ps=77.985u w=76.465u l=1u
X10071 BAT GATE DVDD DVDD pfet_06v0 ad=35.511p pd=48.245u as=35.511p ps=48.245u w=46.725u l=1u
X10072 DVDD GATE BAT DVDD pfet_06v0 ad=71.8771p pd=0.15481m as=58.1134p ps=77.985u w=76.465u l=1u
X10073 BAT GATE DVDD DVDD pfet_06v0 ad=35.511p pd=48.245u as=35.511p ps=48.245u w=46.725u l=1u
X10074 DVDD GATE BAT DVDD pfet_06v0 ad=71.8771p pd=0.15481m as=58.1134p ps=77.985u w=76.465u l=1u
X10075 BAT GATE DVDD DVDD pfet_06v0 ad=47.6862p pd=64.265u as=47.6862p ps=64.265u w=62.745u l=1u
X10076 BAT GATE DVDD DVDD pfet_06v0 ad=35.511p pd=48.245u as=35.511p ps=48.245u w=46.725u l=1u
X10077 DVDD GATE BAT DVDD pfet_06v0 ad=58.1134p pd=77.985u as=58.1134p ps=77.985u w=76.465u l=1u
X10078 DVDD GATE BAT DVDD pfet_06v0 ad=35.511p pd=48.245u as=35.511p ps=48.245u w=46.725u l=1u
X10079 DVDD GATE BAT DVDD pfet_06v0 ad=43.9215p pd=95.32999u as=35.511p ps=48.245u w=46.725u l=1u
X10080 DVDD GATE BAT DVDD pfet_06v0 ad=43.9215p pd=95.32999u as=35.511p ps=48.245u w=46.725u l=1u
X10081 BAT GATE DVDD DVDD pfet_06v0 ad=58.1134p pd=77.985u as=58.1134p ps=77.985u w=76.465u l=1u
X10082 BAT GATE DVDD DVDD pfet_06v0 ad=58.1134p pd=77.985u as=58.1134p ps=77.985u w=76.465u l=1u
X10083 BAT GATE DVDD DVDD pfet_06v0 ad=58.1172p pd=77.99u as=71.8818p ps=0.15482m w=76.47u l=1u
X10084 DVDD GATE BAT DVDD pfet_06v0 ad=35.511p pd=48.245u as=35.511p ps=48.245u w=46.725u l=1u
X10085 DVDD GATE BAT DVDD pfet_06v0 ad=58.1134p pd=77.985u as=58.1134p ps=77.985u w=76.465u l=1u
X10086 BAT GATE DVDD DVDD pfet_06v0 ad=58.1172p pd=77.99u as=58.1172p ps=77.99u w=76.47u l=1u
X10087 DVDD GATE BAT DVDD pfet_06v0 ad=58.1134p pd=77.985u as=58.1134p ps=77.985u w=76.465u l=1u
X10088 DVDD GATE BAT DVDD pfet_06v0 ad=43.9215p pd=95.32999u as=35.511p ps=48.245u w=46.725u l=1u
X10089 BAT GATE DVDD DVDD pfet_06v0 ad=58.1172p pd=77.99u as=58.1172p ps=77.99u w=76.47u l=1u
X10090 BAT GATE DVDD DVDD pfet_06v0 ad=35.511p pd=48.245u as=35.511p ps=48.245u w=46.725u l=1u
X10091 BAT GATE DVDD DVDD pfet_06v0 ad=35.511p pd=48.245u as=35.511p ps=48.245u w=46.725u l=1u
X10092 DVDD GATE BAT DVDD pfet_06v0 ad=71.8771p pd=0.15481m as=58.1134p ps=77.985u w=76.465u l=1u
X10093 DVDD GATE BAT DVDD pfet_06v0 ad=47.6862p pd=64.265u as=47.6862p ps=64.265u w=62.745u l=1u
X10094 DVDD GATE BAT DVDD pfet_06v0 ad=35.511p pd=48.245u as=35.511p ps=48.245u w=46.725u l=1u
X10095 DVDD GATE BAT DVDD pfet_06v0 ad=58.1096p pd=77.98u as=58.1096p ps=77.98u w=76.46u l=1u
X10096 DVDD GATE BAT DVDD pfet_06v0 ad=35.511p pd=48.245u as=35.511p ps=48.245u w=46.725u l=1u
X10097 BAT GATE DVDD DVDD pfet_06v0 ad=35.511p pd=48.245u as=43.9215p ps=95.32999u w=46.725u l=1u
X10098 DVDD GATE BAT DVDD pfet_06v0 ad=35.5072p pd=48.24u as=35.5072p ps=48.24u w=46.72u l=1u
X10099 DVDD GATE BAT DVDD pfet_06v0 ad=58.1134p pd=77.985u as=58.1134p ps=77.985u w=76.465u l=1u
X10100 BAT GATE DVDD DVDD pfet_06v0 ad=35.511p pd=48.245u as=43.9215p ps=95.32999u w=46.725u l=1u
X10101 DVDD GATE BAT DVDD pfet_06v0 ad=58.1134p pd=77.985u as=58.1134p ps=77.985u w=76.465u l=1u
X10102 BAT GATE DVDD DVDD pfet_06v0 ad=58.1134p pd=77.985u as=58.1134p ps=77.985u w=76.465u l=1u
X10103 BAT GATE DVDD DVDD pfet_06v0 ad=35.511p pd=48.245u as=35.511p ps=48.245u w=46.725u l=1u
X10104 BAT GATE DVDD DVDD pfet_06v0 ad=58.1552p pd=78.04u as=58.1552p ps=78.04u w=76.52u l=1u
X10105 BAT GATE DVDD DVDD pfet_06v0 ad=35.511p pd=48.245u as=43.9215p ps=95.32999u w=46.725u l=1u
X10106 BAT GATE DVDD DVDD pfet_06v0 ad=35.511p pd=48.245u as=35.511p ps=48.245u w=46.725u l=1u
X10107 DVDD GATE BAT DVDD pfet_06v0 ad=35.5072p pd=48.24u as=35.5072p ps=48.24u w=46.72u l=1u
X10108 DVDD GATE BAT DVDD pfet_06v0 ad=35.511p pd=48.245u as=35.511p ps=48.245u w=46.725u l=1u
X10109 BAT GATE DVDD DVDD pfet_06v0 ad=58.1134p pd=77.985u as=58.1134p ps=77.985u w=76.465u l=1u
X10110 BAT GATE DVDD DVDD pfet_06v0 ad=58.1134p pd=77.985u as=58.1134p ps=77.985u w=76.465u l=1u
X10111 DVDD GATE BAT DVDD pfet_06v0 ad=58.1134p pd=77.985u as=58.1134p ps=77.985u w=76.465u l=1u
X10112 BAT GATE DVDD DVDD pfet_06v0 ad=58.1096p pd=77.98u as=71.8724p ps=0.1548m w=76.46u l=1u
X10113 BAT GATE DVDD DVDD pfet_06v0 ad=35.511p pd=48.245u as=43.9215p ps=95.32999u w=46.725u l=1u
X10114 DVDD GATE BAT DVDD pfet_06v0 ad=58.1134p pd=77.985u as=58.1134p ps=77.985u w=76.465u l=1u
X10115 DVDD GATE BAT DVDD pfet_06v0 ad=71.8818p pd=0.15482m as=58.1172p ps=77.99u w=76.47u l=1u
X10116 BAT GATE DVDD DVDD pfet_06v0 ad=49.3848p pd=66.5u as=49.3848p ps=66.5u w=64.98u l=1u
X10117 BAT GATE DVDD DVDD pfet_06v0 ad=58.1134p pd=77.985u as=58.1134p ps=77.985u w=76.465u l=1u
X10118 BAT GATE DVDD DVDD pfet_06v0 ad=35.511p pd=48.245u as=43.9215p ps=95.32999u w=46.725u l=1u
X10119 DVDD GATE BAT DVDD pfet_06v0 ad=35.511p pd=48.245u as=35.511p ps=48.245u w=46.725u l=1u
X10120 BAT GATE DVDD DVDD pfet_06v0 ad=35.511p pd=48.245u as=35.511p ps=48.245u w=46.725u l=1u
X10121 BAT GATE DVDD DVDD pfet_06v0 ad=35.511p pd=48.245u as=43.9215p ps=95.32999u w=46.725u l=1u
X10122 DVDD GATE BAT DVDD pfet_06v0 ad=35.511p pd=48.245u as=35.511p ps=48.245u w=46.725u l=1u
X10123 DVDD GATE BAT DVDD pfet_06v0 ad=47.6862p pd=64.265u as=47.6862p ps=64.265u w=62.745u l=1u
X10124 BAT GATE DVDD DVDD pfet_06v0 ad=49.3848p pd=66.5u as=49.3848p ps=66.5u w=64.98u l=1u
X10125 DVDD GATE BAT DVDD pfet_06v0 ad=58.1552p pd=78.04u as=58.1552p ps=78.04u w=76.52u l=1u
X10126 DVDD GATE BAT DVDD pfet_06v0 ad=58.1096p pd=77.98u as=58.1096p ps=77.98u w=76.46u l=1u
X10127 BAT GATE DVDD DVDD pfet_06v0 ad=49.3848p pd=66.5u as=49.3848p ps=66.5u w=64.98u l=1u
X10128 BAT GATE DVDD DVDD pfet_06v0 ad=58.0754p pd=77.935u as=58.0754p ps=77.935u w=76.41499u l=1u
X10129 DVDD GATE BAT DVDD pfet_06v0 ad=35.511p pd=48.245u as=35.511p ps=48.245u w=46.725u l=1u
X10130 BAT GATE DVDD DVDD pfet_06v0 ad=58.1134p pd=77.985u as=58.1134p ps=77.985u w=76.465u l=1u
X10131 DVDD GATE BAT DVDD pfet_06v0 ad=35.511p pd=48.245u as=35.511p ps=48.245u w=46.725u l=1u
X10132 DVDD GATE BAT DVDD pfet_06v0 ad=35.511p pd=48.245u as=35.511p ps=48.245u w=46.725u l=1u
X10133 BAT GATE DVDD DVDD pfet_06v0 ad=35.511p pd=48.245u as=35.511p ps=48.245u w=46.725u l=1u
X10134 DVDD GATE BAT DVDD pfet_06v0 ad=58.1134p pd=77.985u as=58.1134p ps=77.985u w=76.465u l=1u
X10135 DVDD GATE BAT DVDD pfet_06v0 ad=58.0754p pd=77.935u as=58.0754p ps=77.935u w=76.41499u l=1u
X10136 BAT GATE DVDD DVDD pfet_06v0 ad=35.511p pd=48.245u as=43.9215p ps=95.32999u w=46.725u l=1u
X10137 DVDD GATE BAT DVDD pfet_06v0 ad=58.1134p pd=77.985u as=58.1134p ps=77.985u w=76.465u l=1u
X10138 BAT GATE DVDD DVDD pfet_06v0 ad=35.511p pd=48.245u as=35.511p ps=48.245u w=46.725u l=1u
X10139 DVDD GATE BAT DVDD pfet_06v0 ad=61.0812p pd=0.13184m as=49.3848p ps=66.5u w=64.98u l=1u
X10140 DVDD GATE BAT DVDD pfet_06v0 ad=35.511p pd=48.245u as=35.511p ps=48.245u w=46.725u l=1u
X10141 DVDD GATE BAT DVDD pfet_06v0 ad=35.5072p pd=48.24u as=35.5072p ps=48.24u w=46.72u l=1u
X10142 BAT GATE DVDD DVDD pfet_06v0 ad=58.1134p pd=77.985u as=58.1134p ps=77.985u w=76.465u l=1u
X10143 BAT GATE DVDD DVDD pfet_06v0 ad=58.1134p pd=77.985u as=58.1134p ps=77.985u w=76.465u l=1u
X10144 BAT GATE DVDD DVDD pfet_06v0 ad=58.1134p pd=77.985u as=58.1134p ps=77.985u w=76.465u l=1u
X10145 BAT GATE DVDD DVDD pfet_06v0 ad=58.1134p pd=77.985u as=58.1134p ps=77.985u w=76.465u l=1u
X10146 DVDD GATE BAT DVDD pfet_06v0 ad=58.1134p pd=77.985u as=58.1134p ps=77.985u w=76.465u l=1u
X10147 DVDD GATE BAT DVDD pfet_06v0 ad=49.3848p pd=66.5u as=49.3848p ps=66.5u w=64.98u l=1u
X10148 BAT GATE DVDD DVDD pfet_06v0 ad=47.6862p pd=64.265u as=47.6862p ps=64.265u w=62.745u l=1u
X10149 BAT GATE DVDD DVDD pfet_06v0 ad=58.1134p pd=77.985u as=58.1134p ps=77.985u w=76.465u l=1u
X10150 BAT GATE DVDD DVDD pfet_06v0 ad=35.511p pd=48.245u as=43.9215p ps=95.32999u w=46.725u l=1u
X10151 BAT GATE DVDD DVDD pfet_06v0 ad=49.3848p pd=66.5u as=61.0812p ps=0.13184m w=64.98u l=1u
X10152 DVDD GATE BAT DVDD pfet_06v0 ad=35.511p pd=48.245u as=35.511p ps=48.245u w=46.725u l=1u
X10153 DVDD GATE BAT DVDD pfet_06v0 ad=58.1134p pd=77.985u as=58.1134p ps=77.985u w=76.465u l=1u
X10154 DVDD GATE BAT DVDD pfet_06v0 ad=58.1172p pd=77.99u as=58.1172p ps=77.99u w=76.47u l=1u
X10155 DVDD GATE BAT DVDD pfet_06v0 ad=35.511p pd=48.245u as=35.511p ps=48.245u w=46.725u l=1u
X10156 DVDD GATE BAT DVDD pfet_06v0 ad=71.8771p pd=0.15481m as=58.1134p ps=77.985u w=76.465u l=1u
X10157 BAT GATE DVDD DVDD pfet_06v0 ad=58.1134p pd=77.985u as=58.1134p ps=77.985u w=76.465u l=1u
X10158 BAT GATE DVDD DVDD pfet_06v0 ad=49.3848p pd=66.5u as=49.3848p ps=66.5u w=64.98u l=1u
X10159 DVDD GATE BAT DVDD pfet_06v0 ad=58.1134p pd=77.985u as=58.1134p ps=77.985u w=76.465u l=1u
X10160 DVDD GATE BAT DVDD pfet_06v0 ad=49.3848p pd=66.5u as=49.3848p ps=66.5u w=64.98u l=1u
X10161 BAT GATE DVDD DVDD pfet_06v0 ad=58.1172p pd=77.99u as=58.1172p ps=77.99u w=76.47u l=1u
X10162 BAT GATE DVDD DVDD pfet_06v0 ad=58.0754p pd=77.935u as=58.0754p ps=77.935u w=76.41499u l=1u
X10163 DVDD GATE BAT DVDD pfet_06v0 ad=58.1134p pd=77.985u as=58.1134p ps=77.985u w=76.465u l=1u
X10164 BAT GATE DVDD DVDD pfet_06v0 ad=35.5072p pd=48.24u as=35.5072p ps=48.24u w=46.72u l=1u
X10165 DVDD GATE BAT DVDD pfet_06v0 ad=35.511p pd=48.245u as=35.511p ps=48.245u w=46.725u l=1u
X10166 DVDD GATE BAT DVDD pfet_06v0 ad=35.511p pd=48.245u as=35.511p ps=48.245u w=46.725u l=1u
X10167 DVDD GATE BAT DVDD pfet_06v0 ad=58.1134p pd=77.985u as=58.1134p ps=77.985u w=76.465u l=1u
X10168 DVDD GATE BAT DVDD pfet_06v0 ad=58.1134p pd=77.985u as=58.1134p ps=77.985u w=76.465u l=1u
X10169 BAT GATE DVDD DVDD pfet_06v0 ad=35.511p pd=48.245u as=43.9215p ps=95.32999u w=46.725u l=1u
X10170 DVDD GATE BAT DVDD pfet_06v0 ad=58.1134p pd=77.985u as=58.1134p ps=77.985u w=76.465u l=1u
X10171 DVDD GATE BAT DVDD pfet_06v0 ad=58.1134p pd=77.985u as=58.1134p ps=77.985u w=76.465u l=1u
X10172 DVDD GATE BAT DVDD pfet_06v0 ad=43.9215p pd=95.32999u as=35.511p ps=48.245u w=46.725u l=1u
X10173 DVDD GATE BAT DVDD pfet_06v0 ad=58.1134p pd=77.985u as=58.1134p ps=77.985u w=76.465u l=1u
X10174 DVDD GATE BAT DVDD pfet_06v0 ad=35.511p pd=48.245u as=35.511p ps=48.245u w=46.725u l=1u
X10175 BAT GATE DVDD DVDD pfet_06v0 ad=58.1134p pd=77.985u as=58.1134p ps=77.985u w=76.465u l=1u
X10176 DVDD GATE BAT DVDD pfet_06v0 ad=58.1096p pd=77.98u as=58.1096p ps=77.98u w=76.46u l=1u
X10177 DVDD GATE BAT DVDD pfet_06v0 ad=71.92879p pd=0.15492m as=58.1552p ps=78.04u w=76.52u l=1u
X10178 BAT GATE DVDD DVDD pfet_06v0 ad=58.1134p pd=77.985u as=71.8771p ps=0.15481m w=76.465u l=1u
X10179 BAT GATE DVDD DVDD pfet_06v0 ad=58.1096p pd=77.98u as=58.1096p ps=77.98u w=76.46u l=1u
X10180 BAT GATE DVDD DVDD pfet_06v0 ad=58.1134p pd=77.985u as=71.8771p ps=0.15481m w=76.465u l=1u
X10181 BAT GATE DVDD DVDD pfet_06v0 ad=35.511p pd=48.245u as=35.511p ps=48.245u w=46.725u l=1u
X10182 BAT GATE DVDD DVDD pfet_06v0 ad=35.511p pd=48.245u as=43.9215p ps=95.32999u w=46.725u l=1u
X10183 DVDD GATE BAT DVDD pfet_06v0 ad=58.1134p pd=77.985u as=58.1134p ps=77.985u w=76.465u l=1u
X10184 BAT GATE DVDD DVDD pfet_06v0 ad=58.1134p pd=77.985u as=58.1134p ps=77.985u w=76.465u l=1u
X10185 BAT GATE DVDD DVDD pfet_06v0 ad=35.511p pd=48.245u as=35.511p ps=48.245u w=46.725u l=1u
X10186 BAT GATE DVDD DVDD pfet_06v0 ad=58.1134p pd=77.985u as=58.1134p ps=77.985u w=76.465u l=1u
X10187 BAT GATE DVDD DVDD pfet_06v0 ad=35.511p pd=48.245u as=35.511p ps=48.245u w=46.725u l=1u
X10188 BAT GATE DVDD DVDD pfet_06v0 ad=35.511p pd=48.245u as=35.511p ps=48.245u w=46.725u l=1u
X10189 DVDD GATE BAT DVDD pfet_06v0 ad=35.511p pd=48.245u as=35.511p ps=48.245u w=46.725u l=1u
X10190 DVDD GATE BAT DVDD pfet_06v0 ad=35.511p pd=48.245u as=35.511p ps=48.245u w=46.725u l=1u
X10191 DVDD GATE BAT DVDD pfet_06v0 ad=43.9215p pd=95.32999u as=35.511p ps=48.245u w=46.725u l=1u
X10192 BAT GATE DVDD DVDD pfet_06v0 ad=58.1134p pd=77.985u as=58.1134p ps=77.985u w=76.465u l=1u
X10193 DVDD GATE BAT DVDD pfet_06v0 ad=35.511p pd=48.245u as=35.511p ps=48.245u w=46.725u l=1u
X10194 BAT GATE DVDD DVDD pfet_06v0 ad=35.511p pd=48.245u as=35.511p ps=48.245u w=46.725u l=1u
X10195 BAT GATE DVDD DVDD pfet_06v0 ad=35.511p pd=48.245u as=35.511p ps=48.245u w=46.725u l=1u
X10196 BAT GATE DVDD DVDD pfet_06v0 ad=47.6862p pd=64.265u as=58.9803p ps=0.12737m w=62.745u l=1u
X10197 DVDD GATE BAT DVDD pfet_06v0 ad=58.1134p pd=77.985u as=58.1134p ps=77.985u w=76.465u l=1u
X10198 BAT GATE DVDD DVDD pfet_06v0 ad=58.1134p pd=77.985u as=71.8771p ps=0.15481m w=76.465u l=1u
X10199 BAT GATE DVDD DVDD pfet_06v0 ad=58.0754p pd=77.935u as=71.8301p ps=0.15471m w=76.41499u l=1u
X10200 DVDD GATE BAT DVDD pfet_06v0 ad=35.511p pd=48.245u as=35.511p ps=48.245u w=46.725u l=1u
X10201 DVDD GATE BAT DVDD pfet_06v0 ad=35.511p pd=48.245u as=35.511p ps=48.245u w=46.725u l=1u
X10202 BAT GATE DVDD DVDD pfet_06v0 ad=58.1134p pd=77.985u as=58.1134p ps=77.985u w=76.465u l=1u
X10203 DVDD GATE BAT DVDD pfet_06v0 ad=35.511p pd=48.245u as=35.511p ps=48.245u w=46.725u l=1u
X10204 BAT GATE DVDD DVDD pfet_06v0 ad=58.1134p pd=77.985u as=58.1134p ps=77.985u w=76.465u l=1u
X10205 BAT GATE DVDD DVDD pfet_06v0 ad=35.511p pd=48.245u as=35.511p ps=48.245u w=46.725u l=1u
X10206 DVDD GATE BAT DVDD pfet_06v0 ad=35.511p pd=48.245u as=35.511p ps=48.245u w=46.725u l=1u
X10207 DVDD GATE BAT DVDD pfet_06v0 ad=58.1134p pd=77.985u as=58.1134p ps=77.985u w=76.465u l=1u
X10208 DVDD GATE BAT DVDD pfet_06v0 ad=58.1134p pd=77.985u as=58.1134p ps=77.985u w=76.465u l=1u
X10209 BAT GATE DVDD DVDD pfet_06v0 ad=58.1172p pd=77.99u as=58.1172p ps=77.99u w=76.47u l=1u
X10210 DVDD GATE BAT DVDD pfet_06v0 ad=35.511p pd=48.245u as=35.511p ps=48.245u w=46.725u l=1u
X10211 BAT GATE DVDD DVDD pfet_06v0 ad=58.1134p pd=77.985u as=71.8771p ps=0.15481m w=76.465u l=1u
X10212 DVDD GATE BAT DVDD pfet_06v0 ad=49.3848p pd=66.5u as=49.3848p ps=66.5u w=64.98u l=1u
X10213 BAT GATE DVDD DVDD pfet_06v0 ad=58.1172p pd=77.99u as=58.1172p ps=77.99u w=76.47u l=1u
X10214 DVDD GATE BAT DVDD pfet_06v0 ad=58.1134p pd=77.985u as=58.1134p ps=77.985u w=76.465u l=1u
X10215 DVDD GATE BAT DVDD pfet_06v0 ad=35.511p pd=48.245u as=35.511p ps=48.245u w=46.725u l=1u
X10216 BAT GATE DVDD DVDD pfet_06v0 ad=35.511p pd=48.245u as=35.511p ps=48.245u w=46.725u l=1u
X10217 BAT GATE DVDD DVDD pfet_06v0 ad=58.1134p pd=77.985u as=71.8771p ps=0.15481m w=76.465u l=1u
X10218 BAT GATE DVDD DVDD pfet_06v0 ad=58.1096p pd=77.98u as=58.1096p ps=77.98u w=76.46u l=1u
X10219 DVDD GATE BAT DVDD pfet_06v0 ad=35.511p pd=48.245u as=35.511p ps=48.245u w=46.725u l=1u
X10220 DVDD GATE BAT DVDD pfet_06v0 ad=58.0754p pd=77.935u as=58.0754p ps=77.935u w=76.41499u l=1u
X10221 DVDD GATE BAT DVDD pfet_06v0 ad=43.9215p pd=95.32999u as=35.511p ps=48.245u w=46.725u l=1u
X10222 BAT GATE DVDD DVDD pfet_06v0 ad=35.511p pd=48.245u as=35.511p ps=48.245u w=46.725u l=1u
X10223 DVDD GATE BAT DVDD pfet_06v0 ad=58.1134p pd=77.985u as=58.1134p ps=77.985u w=76.465u l=1u
X10224 BAT GATE DVDD DVDD pfet_06v0 ad=58.1134p pd=77.985u as=58.1134p ps=77.985u w=76.465u l=1u
X10225 DVDD GATE BAT DVDD pfet_06v0 ad=35.511p pd=48.245u as=35.511p ps=48.245u w=46.725u l=1u
X10226 DVDD GATE BAT DVDD pfet_06v0 ad=58.1172p pd=77.99u as=58.1172p ps=77.99u w=76.47u l=1u
X10227 DVDD GATE BAT DVDD pfet_06v0 ad=43.9215p pd=95.32999u as=35.511p ps=48.245u w=46.725u l=1u
X10228 DVDD GATE BAT DVDD pfet_06v0 ad=71.92879p pd=0.15492m as=58.1552p ps=78.04u w=76.52u l=1u
X10229 BAT GATE DVDD DVDD pfet_06v0 ad=58.1134p pd=77.985u as=58.1134p ps=77.985u w=76.465u l=1u
X10230 BAT GATE DVDD DVDD pfet_06v0 ad=35.5072p pd=48.24u as=35.5072p ps=48.24u w=46.72u l=1u
X10231 DVDD GATE BAT DVDD pfet_06v0 ad=58.1134p pd=77.985u as=58.1134p ps=77.985u w=76.465u l=1u
X10232 BAT GATE DVDD DVDD pfet_06v0 ad=58.1552p pd=78.04u as=58.1552p ps=78.04u w=76.52u l=1u
X10233 DVDD GATE BAT DVDD pfet_06v0 ad=71.8771p pd=0.15481m as=58.1134p ps=77.985u w=76.465u l=1u
X10234 DVDD GATE BAT DVDD pfet_06v0 ad=58.1134p pd=77.985u as=58.1134p ps=77.985u w=76.465u l=1u
X10235 BAT GATE DVDD DVDD pfet_06v0 ad=35.511p pd=48.245u as=35.511p ps=48.245u w=46.725u l=1u
X10236 DVDD GATE BAT DVDD pfet_06v0 ad=43.9215p pd=95.32999u as=35.511p ps=48.245u w=46.725u l=1u
X10237 DVDD GATE BAT DVDD pfet_06v0 ad=58.1134p pd=77.985u as=58.1134p ps=77.985u w=76.465u l=1u
X10238 DVDD GATE BAT DVDD pfet_06v0 ad=58.1134p pd=77.985u as=58.1134p ps=77.985u w=76.465u l=1u
X10239 DVDD GATE BAT DVDD pfet_06v0 ad=58.1134p pd=77.985u as=58.1134p ps=77.985u w=76.465u l=1u
X10240 BAT GATE DVDD DVDD pfet_06v0 ad=49.3848p pd=66.5u as=49.3848p ps=66.5u w=64.98u l=1u
X10241 BAT GATE DVDD DVDD pfet_06v0 ad=58.1134p pd=77.985u as=71.8771p ps=0.15481m w=76.465u l=1u
X10242 DVDD GATE BAT DVDD pfet_06v0 ad=58.1096p pd=77.98u as=58.1096p ps=77.98u w=76.46u l=1u
X10243 BAT GATE DVDD DVDD pfet_06v0 ad=58.1552p pd=78.04u as=58.1552p ps=78.04u w=76.52u l=1u
X10244 DVDD GATE BAT DVDD pfet_06v0 ad=71.8771p pd=0.15481m as=58.1134p ps=77.985u w=76.465u l=1u
X10245 BAT GATE DVDD DVDD pfet_06v0 ad=58.1134p pd=77.985u as=58.1134p ps=77.985u w=76.465u l=1u
X10246 DVDD GATE BAT DVDD pfet_06v0 ad=49.3848p pd=66.5u as=49.3848p ps=66.5u w=64.98u l=1u
X10247 DVDD GATE BAT DVDD pfet_06v0 ad=35.511p pd=48.245u as=35.511p ps=48.245u w=46.725u l=1u
X10248 DVDD GATE BAT DVDD pfet_06v0 ad=58.1552p pd=78.04u as=58.1552p ps=78.04u w=76.52u l=1u
X10249 DVDD GATE BAT DVDD pfet_06v0 ad=58.0754p pd=77.935u as=58.0754p ps=77.935u w=76.41499u l=1u
X10250 DVDD GATE BAT DVDD pfet_06v0 ad=58.0754p pd=77.935u as=58.0754p ps=77.935u w=76.41499u l=1u
X10251 DVDD GATE BAT DVDD pfet_06v0 ad=43.9215p pd=95.32999u as=35.511p ps=48.245u w=46.725u l=1u
X10252 BAT GATE DVDD DVDD pfet_06v0 ad=58.1134p pd=77.985u as=58.1134p ps=77.985u w=76.465u l=1u
X10253 DVDD GATE BAT DVDD pfet_06v0 ad=35.511p pd=48.245u as=35.511p ps=48.245u w=46.725u l=1u
X10254 BAT GATE DVDD DVDD pfet_06v0 ad=58.1134p pd=77.985u as=58.1134p ps=77.985u w=76.465u l=1u
X10255 BAT GATE DVDD DVDD pfet_06v0 ad=35.511p pd=48.245u as=35.511p ps=48.245u w=46.725u l=1u
X10256 BAT GATE DVDD DVDD pfet_06v0 ad=49.3848p pd=66.5u as=49.3848p ps=66.5u w=64.98u l=1u
X10257 DVDD GATE BAT DVDD pfet_06v0 ad=58.0754p pd=77.935u as=58.0754p ps=77.935u w=76.41499u l=1u
X10258 BAT GATE DVDD DVDD pfet_06v0 ad=35.511p pd=48.245u as=35.511p ps=48.245u w=46.725u l=1u
X10259 DVDD GATE BAT DVDD pfet_06v0 ad=71.8301p pd=0.15471m as=58.0754p ps=77.935u w=76.41499u l=1u
X10260 BAT GATE DVDD DVDD pfet_06v0 ad=35.511p pd=48.245u as=35.511p ps=48.245u w=46.725u l=1u
X10261 BAT GATE DVDD DVDD pfet_06v0 ad=58.1172p pd=77.99u as=71.8818p ps=0.15482m w=76.47u l=1u
X10262 BAT GATE DVDD DVDD pfet_06v0 ad=35.511p pd=48.245u as=35.511p ps=48.245u w=46.725u l=1u
X10263 BAT GATE DVDD DVDD pfet_06v0 ad=47.6862p pd=64.265u as=47.6862p ps=64.265u w=62.745u l=1u
X10264 DVDD GATE BAT DVDD pfet_06v0 ad=71.8771p pd=0.15481m as=58.1134p ps=77.985u w=76.465u l=1u
X10265 DVDD GATE BAT DVDD pfet_06v0 ad=35.511p pd=48.245u as=35.511p ps=48.245u w=46.725u l=1u
X10266 DVDD GATE BAT DVDD pfet_06v0 ad=35.511p pd=48.245u as=35.511p ps=48.245u w=46.725u l=1u
X10267 BAT GATE DVDD DVDD pfet_06v0 ad=58.1134p pd=77.985u as=58.1134p ps=77.985u w=76.465u l=1u
X10268 DVDD GATE BAT DVDD pfet_06v0 ad=35.511p pd=48.245u as=35.511p ps=48.245u w=46.725u l=1u
X10269 DVDD GATE BAT DVDD pfet_06v0 ad=43.9215p pd=95.32999u as=35.511p ps=48.245u w=46.725u l=1u
X10270 DVDD GATE BAT DVDD pfet_06v0 ad=58.1172p pd=77.99u as=58.1172p ps=77.99u w=76.47u l=1u
X10271 BAT GATE DVDD DVDD pfet_06v0 ad=35.511p pd=48.245u as=35.511p ps=48.245u w=46.725u l=1u
X10272 DVDD GATE BAT DVDD pfet_06v0 ad=58.1096p pd=77.98u as=58.1096p ps=77.98u w=76.46u l=1u
X10273 DVDD GATE BAT DVDD pfet_06v0 ad=43.9215p pd=95.32999u as=35.511p ps=48.245u w=46.725u l=1u
X10274 BAT GATE DVDD DVDD pfet_06v0 ad=58.1134p pd=77.985u as=58.1134p ps=77.985u w=76.465u l=1u
X10275 BAT GATE DVDD DVDD pfet_06v0 ad=58.1552p pd=78.04u as=58.1552p ps=78.04u w=76.52u l=1u
X10276 BAT GATE DVDD DVDD pfet_06v0 ad=58.1552p pd=78.04u as=58.1552p ps=78.04u w=76.52u l=1u
X10277 BAT GATE DVDD DVDD pfet_06v0 ad=35.511p pd=48.245u as=35.511p ps=48.245u w=46.725u l=1u
X10278 BAT GATE DVDD DVDD pfet_06v0 ad=58.1134p pd=77.985u as=58.1134p ps=77.985u w=76.465u l=1u
X10279 DVDD GATE BAT DVDD pfet_06v0 ad=35.511p pd=48.245u as=35.511p ps=48.245u w=46.725u l=1u
X10280 DVDD GATE BAT DVDD pfet_06v0 ad=35.511p pd=48.245u as=35.511p ps=48.245u w=46.725u l=1u
X10281 DVDD GATE BAT DVDD pfet_06v0 ad=35.511p pd=48.245u as=35.511p ps=48.245u w=46.725u l=1u
X10282 DVDD GATE BAT DVDD pfet_06v0 ad=58.1134p pd=77.985u as=58.1134p ps=77.985u w=76.465u l=1u
X10283 BAT GATE DVDD DVDD pfet_06v0 ad=35.511p pd=48.245u as=43.9215p ps=95.32999u w=46.725u l=1u
X10284 DVDD GATE BAT DVDD pfet_06v0 ad=35.511p pd=48.245u as=35.511p ps=48.245u w=46.725u l=1u
X10285 DVDD GATE BAT DVDD pfet_06v0 ad=71.8724p pd=0.1548m as=58.1096p ps=77.98u w=76.46u l=1u
X10286 BAT GATE DVDD DVDD pfet_06v0 ad=35.511p pd=48.245u as=35.511p ps=48.245u w=46.725u l=1u
X10287 DVDD GATE BAT DVDD pfet_06v0 ad=43.9215p pd=95.32999u as=35.511p ps=48.245u w=46.725u l=1u
X10288 DVDD GATE BAT DVDD pfet_06v0 ad=35.511p pd=48.245u as=35.511p ps=48.245u w=46.725u l=1u
X10289 DVDD GATE BAT DVDD pfet_06v0 ad=35.511p pd=48.245u as=35.511p ps=48.245u w=46.725u l=1u
X10290 BAT GATE DVDD DVDD pfet_06v0 ad=35.511p pd=48.245u as=35.511p ps=48.245u w=46.725u l=1u
X10291 BAT GATE DVDD DVDD pfet_06v0 ad=35.511p pd=48.245u as=35.511p ps=48.245u w=46.725u l=1u
X10292 BAT GATE DVDD DVDD pfet_06v0 ad=35.511p pd=48.245u as=35.511p ps=48.245u w=46.725u l=1u
X10293 BAT GATE DVDD DVDD pfet_06v0 ad=35.511p pd=48.245u as=35.511p ps=48.245u w=46.725u l=1u
X10294 DVDD GATE BAT DVDD pfet_06v0 ad=58.1134p pd=77.985u as=58.1134p ps=77.985u w=76.465u l=1u
X10295 DVDD GATE BAT DVDD pfet_06v0 ad=43.9168p pd=95.32u as=35.5072p ps=48.24u w=46.72u l=1u
X10296 BAT GATE DVDD DVDD pfet_06v0 ad=35.511p pd=48.245u as=35.511p ps=48.245u w=46.725u l=1u
X10297 DVDD GATE BAT DVDD pfet_06v0 ad=35.511p pd=48.245u as=35.511p ps=48.245u w=46.725u l=1u
X10298 DVDD GATE BAT DVDD pfet_06v0 ad=58.1172p pd=77.99u as=58.1172p ps=77.99u w=76.47u l=1u
X10299 BAT GATE DVDD DVDD pfet_06v0 ad=58.1134p pd=77.985u as=58.1134p ps=77.985u w=76.465u l=1u
X10300 DVDD GATE BAT DVDD pfet_06v0 ad=35.5072p pd=48.24u as=35.5072p ps=48.24u w=46.72u l=1u
X10301 BAT GATE DVDD DVDD pfet_06v0 ad=58.1134p pd=77.985u as=58.1134p ps=77.985u w=76.465u l=1u
X10302 BAT GATE DVDD DVDD pfet_06v0 ad=47.6862p pd=64.265u as=47.6862p ps=64.265u w=62.745u l=1u
X10303 BAT GATE DVDD DVDD pfet_06v0 ad=35.511p pd=48.245u as=35.511p ps=48.245u w=46.725u l=1u
X10304 BAT GATE DVDD DVDD pfet_06v0 ad=35.511p pd=48.245u as=35.511p ps=48.245u w=46.725u l=1u
X10305 BAT GATE DVDD DVDD pfet_06v0 ad=58.1134p pd=77.985u as=58.1134p ps=77.985u w=76.465u l=1u
X10306 BAT GATE DVDD DVDD pfet_06v0 ad=35.5072p pd=48.24u as=43.9168p ps=95.32u w=46.72u l=1u
X10307 DVDD GATE BAT DVDD pfet_06v0 ad=58.1172p pd=77.99u as=58.1172p ps=77.99u w=76.47u l=1u
X10308 BAT GATE DVDD DVDD pfet_06v0 ad=35.511p pd=48.245u as=35.511p ps=48.245u w=46.725u l=1u
X10309 BAT GATE DVDD DVDD pfet_06v0 ad=58.1134p pd=77.985u as=58.1134p ps=77.985u w=76.465u l=1u
X10310 DVDD GATE BAT DVDD pfet_06v0 ad=58.1134p pd=77.985u as=58.1134p ps=77.985u w=76.465u l=1u
X10311 DVDD GATE BAT DVDD pfet_06v0 ad=43.9215p pd=95.32999u as=35.511p ps=48.245u w=46.725u l=1u
X10312 BAT GATE DVDD DVDD pfet_06v0 ad=58.1552p pd=78.04u as=58.1552p ps=78.04u w=76.52u l=1u
X10313 DVDD GATE BAT DVDD pfet_06v0 ad=58.1552p pd=78.04u as=58.1552p ps=78.04u w=76.52u l=1u
X10314 BAT GATE DVDD DVDD pfet_06v0 ad=35.511p pd=48.245u as=35.511p ps=48.245u w=46.725u l=1u
X10315 DVDD GATE BAT DVDD pfet_06v0 ad=58.1134p pd=77.985u as=58.1134p ps=77.985u w=76.465u l=1u
X10316 BAT GATE DVDD DVDD pfet_06v0 ad=35.511p pd=48.245u as=35.511p ps=48.245u w=46.725u l=1u
X10317 DVDD GATE BAT DVDD pfet_06v0 ad=58.1134p pd=77.985u as=58.1134p ps=77.985u w=76.465u l=1u
X10318 DVDD GATE BAT DVDD pfet_06v0 ad=58.1134p pd=77.985u as=58.1134p ps=77.985u w=76.465u l=1u
X10319 BAT GATE DVDD DVDD pfet_06v0 ad=58.0754p pd=77.935u as=58.0754p ps=77.935u w=76.41499u l=1u
X10320 BAT GATE DVDD DVDD pfet_06v0 ad=58.1134p pd=77.985u as=58.1134p ps=77.985u w=76.465u l=1u
X10321 DVDD GATE BAT DVDD pfet_06v0 ad=43.9215p pd=95.32999u as=35.511p ps=48.245u w=46.725u l=1u
X10322 DVDD GATE BAT DVDD pfet_06v0 ad=71.92879p pd=0.15492m as=58.1552p ps=78.04u w=76.52u l=1u
X10323 BAT GATE DVDD DVDD pfet_06v0 ad=58.0754p pd=77.935u as=58.0754p ps=77.935u w=76.41499u l=1u
X10324 BAT GATE DVDD DVDD pfet_06v0 ad=47.6862p pd=64.265u as=47.6862p ps=64.265u w=62.745u l=1u
X10325 BAT GATE DVDD DVDD pfet_06v0 ad=58.1134p pd=77.985u as=58.1134p ps=77.985u w=76.465u l=1u
X10326 BAT GATE DVDD DVDD pfet_06v0 ad=58.1134p pd=77.985u as=58.1134p ps=77.985u w=76.465u l=1u
X10327 DVDD GATE BAT DVDD pfet_06v0 ad=71.8301p pd=0.15471m as=58.0754p ps=77.935u w=76.41499u l=1u
X10328 BAT GATE DVDD DVDD pfet_06v0 ad=35.511p pd=48.245u as=35.511p ps=48.245u w=46.725u l=1u
X10329 BAT GATE DVDD DVDD pfet_06v0 ad=58.1172p pd=77.99u as=58.1172p ps=77.99u w=76.47u l=1u
X10330 BAT GATE DVDD DVDD pfet_06v0 ad=35.511p pd=48.245u as=35.511p ps=48.245u w=46.725u l=1u
X10331 BAT GATE DVDD DVDD pfet_06v0 ad=35.511p pd=48.245u as=35.511p ps=48.245u w=46.725u l=1u
X10332 DVDD GATE BAT DVDD pfet_06v0 ad=71.8771p pd=0.15481m as=58.1134p ps=77.985u w=76.465u l=1u
X10333 DVDD GATE BAT DVDD pfet_06v0 ad=58.0754p pd=77.935u as=58.0754p ps=77.935u w=76.41499u l=1u
X10334 DVDD GATE BAT DVDD pfet_06v0 ad=58.1552p pd=78.04u as=58.1552p ps=78.04u w=76.52u l=1u
X10335 BAT GATE DVDD DVDD pfet_06v0 ad=47.6862p pd=64.265u as=47.6862p ps=64.265u w=62.745u l=1u
X10336 BAT GATE DVDD DVDD pfet_06v0 ad=58.1134p pd=77.985u as=58.1134p ps=77.985u w=76.465u l=1u
X10337 BAT GATE DVDD DVDD pfet_06v0 ad=58.1134p pd=77.985u as=58.1134p ps=77.985u w=76.465u l=1u
X10338 DVDD GATE BAT DVDD pfet_06v0 ad=49.3848p pd=66.5u as=49.3848p ps=66.5u w=64.98u l=1u
X10339 DVDD GATE BAT DVDD pfet_06v0 ad=35.511p pd=48.245u as=35.511p ps=48.245u w=46.725u l=1u
X10340 DVDD GATE BAT DVDD pfet_06v0 ad=49.3848p pd=66.5u as=49.3848p ps=66.5u w=64.98u l=1u
X10341 DVDD GATE BAT DVDD pfet_06v0 ad=43.9215p pd=95.32999u as=35.511p ps=48.245u w=46.725u l=1u
X10342 DVDD GATE BAT DVDD pfet_06v0 ad=58.1134p pd=77.985u as=58.1134p ps=77.985u w=76.465u l=1u
X10343 BAT GATE DVDD DVDD pfet_06v0 ad=58.1134p pd=77.985u as=58.1134p ps=77.985u w=76.465u l=1u
X10344 DVDD GATE BAT DVDD pfet_06v0 ad=71.8301p pd=0.15471m as=58.0754p ps=77.935u w=76.41499u l=1u
X10345 DVDD GATE BAT DVDD pfet_06v0 ad=49.3848p pd=66.5u as=49.3848p ps=66.5u w=64.98u l=1u
X10346 BAT GATE DVDD DVDD pfet_06v0 ad=58.1096p pd=77.98u as=58.1096p ps=77.98u w=76.46u l=1u
X10347 DVDD GATE BAT DVDD pfet_06v0 ad=35.511p pd=48.245u as=35.511p ps=48.245u w=46.725u l=1u
X10348 BAT GATE DVDD DVDD pfet_06v0 ad=58.0754p pd=77.935u as=58.0754p ps=77.935u w=76.41499u l=1u
X10349 DVDD GATE BAT DVDD pfet_06v0 ad=35.511p pd=48.245u as=35.511p ps=48.245u w=46.725u l=1u
X10350 BAT GATE DVDD DVDD pfet_06v0 ad=49.3848p pd=66.5u as=49.3848p ps=66.5u w=64.98u l=1u
X10351 DVDD GATE BAT DVDD pfet_06v0 ad=35.5072p pd=48.24u as=35.5072p ps=48.24u w=46.72u l=1u
X10352 BAT GATE DVDD DVDD pfet_06v0 ad=58.1552p pd=78.04u as=71.92879p ps=0.15492m w=76.52u l=1u
X10353 BAT GATE DVDD DVDD pfet_06v0 ad=35.511p pd=48.245u as=43.9215p ps=95.32999u w=46.725u l=1u
X10354 BAT GATE DVDD DVDD pfet_06v0 ad=35.511p pd=48.245u as=35.511p ps=48.245u w=46.725u l=1u
X10355 BAT GATE DVDD DVDD pfet_06v0 ad=58.1134p pd=77.985u as=58.1134p ps=77.985u w=76.465u l=1u
X10356 DVDD GATE BAT DVDD pfet_06v0 ad=58.1134p pd=77.985u as=58.1134p ps=77.985u w=76.465u l=1u
X10357 BAT GATE DVDD DVDD pfet_06v0 ad=58.0754p pd=77.935u as=58.0754p ps=77.935u w=76.41499u l=1u
X10358 BAT GATE DVDD DVDD pfet_06v0 ad=58.1134p pd=77.985u as=58.1134p ps=77.985u w=76.465u l=1u
X10359 BAT GATE DVDD DVDD pfet_06v0 ad=58.0754p pd=77.935u as=58.0754p ps=77.935u w=76.41499u l=1u
X10360 DVDD GATE BAT DVDD pfet_06v0 ad=35.511p pd=48.245u as=35.511p ps=48.245u w=46.725u l=1u
X10361 BAT GATE DVDD DVDD pfet_06v0 ad=35.511p pd=48.245u as=35.511p ps=48.245u w=46.725u l=1u
X10362 BAT GATE DVDD DVDD pfet_06v0 ad=35.511p pd=48.245u as=35.511p ps=48.245u w=46.725u l=1u
X10363 DVDD GATE BAT DVDD pfet_06v0 ad=47.6862p pd=64.265u as=47.6862p ps=64.265u w=62.745u l=1u
X10364 BAT GATE DVDD DVDD pfet_06v0 ad=35.511p pd=48.245u as=35.511p ps=48.245u w=46.725u l=1u
X10365 DVDD GATE BAT DVDD pfet_06v0 ad=58.1552p pd=78.04u as=58.1552p ps=78.04u w=76.52u l=1u
X10366 BAT GATE DVDD DVDD pfet_06v0 ad=58.1134p pd=77.985u as=58.1134p ps=77.985u w=76.465u l=1u
X10367 BAT GATE DVDD DVDD pfet_06v0 ad=35.511p pd=48.245u as=35.511p ps=48.245u w=46.725u l=1u
X10368 DVDD GATE BAT DVDD pfet_06v0 ad=58.1134p pd=77.985u as=58.1134p ps=77.985u w=76.465u l=1u
X10369 DVDD GATE BAT DVDD pfet_06v0 ad=47.6862p pd=64.265u as=47.6862p ps=64.265u w=62.745u l=1u
X10370 BAT GATE DVDD DVDD pfet_06v0 ad=35.511p pd=48.245u as=35.511p ps=48.245u w=46.725u l=1u
X10371 DVDD GATE BAT DVDD pfet_06v0 ad=35.511p pd=48.245u as=35.511p ps=48.245u w=46.725u l=1u
X10372 BAT GATE DVDD DVDD pfet_06v0 ad=35.511p pd=48.245u as=35.511p ps=48.245u w=46.725u l=1u
X10373 DVDD GATE BAT DVDD pfet_06v0 ad=58.1134p pd=77.985u as=58.1134p ps=77.985u w=76.465u l=1u
X10374 BAT GATE DVDD DVDD pfet_06v0 ad=35.511p pd=48.245u as=35.511p ps=48.245u w=46.725u l=1u
X10375 DVDD GATE BAT DVDD pfet_06v0 ad=43.9215p pd=95.32999u as=35.511p ps=48.245u w=46.725u l=1u
X10376 DVDD GATE BAT DVDD pfet_06v0 ad=35.511p pd=48.245u as=35.511p ps=48.245u w=46.725u l=1u
X10377 DVDD GATE BAT DVDD pfet_06v0 ad=35.511p pd=48.245u as=35.511p ps=48.245u w=46.725u l=1u
X10378 DVDD GATE BAT DVDD pfet_06v0 ad=35.5072p pd=48.24u as=35.5072p ps=48.24u w=46.72u l=1u
X10379 BAT GATE DVDD DVDD pfet_06v0 ad=58.1172p pd=77.99u as=58.1172p ps=77.99u w=76.47u l=1u
X10380 DVDD GATE BAT DVDD pfet_06v0 ad=43.9215p pd=95.32999u as=35.511p ps=48.245u w=46.725u l=1u
X10381 BAT GATE DVDD DVDD pfet_06v0 ad=58.1134p pd=77.985u as=58.1134p ps=77.985u w=76.465u l=1u
X10382 BAT GATE DVDD DVDD pfet_06v0 ad=58.1134p pd=77.985u as=71.8771p ps=0.15481m w=76.465u l=1u
X10383 BAT GATE DVDD DVDD pfet_06v0 ad=35.511p pd=48.245u as=35.511p ps=48.245u w=46.725u l=1u
X10384 BAT GATE DVDD DVDD pfet_06v0 ad=35.511p pd=48.245u as=43.9215p ps=95.32999u w=46.725u l=1u
X10385 BAT GATE DVDD DVDD pfet_06v0 ad=49.3848p pd=66.5u as=49.3848p ps=66.5u w=64.98u l=1u
X10386 DVDD GATE BAT DVDD pfet_06v0 ad=43.9215p pd=95.32999u as=35.511p ps=48.245u w=46.725u l=1u
X10387 DVDD GATE BAT DVDD pfet_06v0 ad=58.1134p pd=77.985u as=58.1134p ps=77.985u w=76.465u l=1u
X10388 BAT GATE DVDD DVDD pfet_06v0 ad=35.511p pd=48.245u as=43.9215p ps=95.32999u w=46.725u l=1u
X10389 DVDD GATE BAT DVDD pfet_06v0 ad=43.9215p pd=95.32999u as=35.511p ps=48.245u w=46.725u l=1u
X10390 BAT GATE DVDD DVDD pfet_06v0 ad=35.511p pd=48.245u as=35.511p ps=48.245u w=46.725u l=1u
X10391 BAT GATE DVDD DVDD pfet_06v0 ad=58.1134p pd=77.985u as=58.1134p ps=77.985u w=76.465u l=1u
X10392 DVDD GATE BAT DVDD pfet_06v0 ad=58.1134p pd=77.985u as=58.1134p ps=77.985u w=76.465u l=1u
X10393 DVDD GATE BAT DVDD pfet_06v0 ad=35.511p pd=48.245u as=35.511p ps=48.245u w=46.725u l=1u
X10394 DVDD GATE BAT DVDD pfet_06v0 ad=58.1134p pd=77.985u as=58.1134p ps=77.985u w=76.465u l=1u
X10395 BAT GATE DVDD DVDD pfet_06v0 ad=35.511p pd=48.245u as=35.511p ps=48.245u w=46.725u l=1u
X10396 BAT GATE DVDD DVDD pfet_06v0 ad=35.511p pd=48.245u as=35.511p ps=48.245u w=46.725u l=1u
X10397 DVDD GATE BAT DVDD pfet_06v0 ad=58.9803p pd=0.12737m as=47.6862p ps=64.265u w=62.745u l=1u
X10398 BAT GATE DVDD DVDD pfet_06v0 ad=47.6862p pd=64.265u as=47.6862p ps=64.265u w=62.745u l=1u
X10399 BAT GATE DVDD DVDD pfet_06v0 ad=35.511p pd=48.245u as=43.9215p ps=95.32999u w=46.725u l=1u
X10400 DVDD GATE BAT DVDD pfet_06v0 ad=35.511p pd=48.245u as=35.511p ps=48.245u w=46.725u l=1u
X10401 DVDD GATE BAT DVDD pfet_06v0 ad=43.9215p pd=95.32999u as=35.511p ps=48.245u w=46.725u l=1u
X10402 DVDD GATE BAT DVDD pfet_06v0 ad=35.511p pd=48.245u as=35.511p ps=48.245u w=46.725u l=1u
X10403 DVDD GATE BAT DVDD pfet_06v0 ad=58.1134p pd=77.985u as=58.1134p ps=77.985u w=76.465u l=1u
X10404 DVDD GATE BAT DVDD pfet_06v0 ad=35.511p pd=48.245u as=35.511p ps=48.245u w=46.725u l=1u
X10405 BAT GATE DVDD DVDD pfet_06v0 ad=58.1134p pd=77.985u as=58.1134p ps=77.985u w=76.465u l=1u
X10406 BAT GATE DVDD DVDD pfet_06v0 ad=58.1172p pd=77.99u as=58.1172p ps=77.99u w=76.47u l=1u
X10407 BAT GATE DVDD DVDD pfet_06v0 ad=58.1172p pd=77.99u as=58.1172p ps=77.99u w=76.47u l=1u
X10408 DVDD GATE BAT DVDD pfet_06v0 ad=35.511p pd=48.245u as=35.511p ps=48.245u w=46.725u l=1u
X10409 DVDD GATE BAT DVDD pfet_06v0 ad=58.1134p pd=77.985u as=58.1134p ps=77.985u w=76.465u l=1u
X10410 BAT GATE DVDD DVDD pfet_06v0 ad=35.511p pd=48.245u as=35.511p ps=48.245u w=46.725u l=1u
X10411 DVDD GATE BAT DVDD pfet_06v0 ad=58.1134p pd=77.985u as=58.1134p ps=77.985u w=76.465u l=1u
X10412 BAT GATE DVDD DVDD pfet_06v0 ad=35.511p pd=48.245u as=35.511p ps=48.245u w=46.725u l=1u
X10413 BAT GATE DVDD DVDD pfet_06v0 ad=49.3848p pd=66.5u as=49.3848p ps=66.5u w=64.98u l=1u
X10414 DVDD GATE BAT DVDD pfet_06v0 ad=35.511p pd=48.245u as=35.511p ps=48.245u w=46.725u l=1u
X10415 DVDD GATE BAT DVDD pfet_06v0 ad=35.511p pd=48.245u as=35.511p ps=48.245u w=46.725u l=1u
X10416 DVDD GATE BAT DVDD pfet_06v0 ad=58.1134p pd=77.985u as=58.1134p ps=77.985u w=76.465u l=1u
X10417 DVDD GATE BAT DVDD pfet_06v0 ad=61.0812p pd=0.13184m as=49.3848p ps=66.5u w=64.98u l=1u
X10418 BAT GATE DVDD DVDD pfet_06v0 ad=58.1134p pd=77.985u as=58.1134p ps=77.985u w=76.465u l=1u
X10419 DVDD GATE BAT DVDD pfet_06v0 ad=43.9215p pd=95.32999u as=35.511p ps=48.245u w=46.725u l=1u
X10420 DVDD GATE BAT DVDD pfet_06v0 ad=58.0754p pd=77.935u as=58.0754p ps=77.935u w=76.41499u l=1u
X10421 DVDD GATE BAT DVDD pfet_06v0 ad=58.1134p pd=77.985u as=58.1134p ps=77.985u w=76.465u l=1u
X10422 BAT GATE DVDD DVDD pfet_06v0 ad=35.511p pd=48.245u as=35.511p ps=48.245u w=46.725u l=1u
X10423 BAT GATE DVDD DVDD pfet_06v0 ad=58.1552p pd=78.04u as=58.1552p ps=78.04u w=76.52u l=1u
X10424 DVDD GATE BAT DVDD pfet_06v0 ad=35.511p pd=48.245u as=35.511p ps=48.245u w=46.725u l=1u
X10425 DVDD GATE BAT DVDD pfet_06v0 ad=58.1134p pd=77.985u as=58.1134p ps=77.985u w=76.465u l=1u
X10426 BAT GATE DVDD DVDD pfet_06v0 ad=58.1096p pd=77.98u as=58.1096p ps=77.98u w=76.46u l=1u
X10427 BAT GATE DVDD DVDD pfet_06v0 ad=58.1134p pd=77.985u as=58.1134p ps=77.985u w=76.465u l=1u
X10428 DVDD GATE BAT DVDD pfet_06v0 ad=35.511p pd=48.245u as=35.511p ps=48.245u w=46.725u l=1u
X10429 BAT GATE DVDD DVDD pfet_06v0 ad=58.1134p pd=77.985u as=58.1134p ps=77.985u w=76.465u l=1u
X10430 DVDD GATE BAT DVDD pfet_06v0 ad=61.0812p pd=0.13184m as=49.3848p ps=66.5u w=64.98u l=1u
X10431 BAT GATE DVDD DVDD pfet_06v0 ad=58.1552p pd=78.04u as=58.1552p ps=78.04u w=76.52u l=1u
X10432 DVDD GATE BAT DVDD pfet_06v0 ad=58.0754p pd=77.935u as=58.0754p ps=77.935u w=76.41499u l=1u
X10433 DVDD GATE BAT DVDD pfet_06v0 ad=58.1172p pd=77.99u as=58.1172p ps=77.99u w=76.47u l=1u
X10434 BAT GATE DVDD DVDD pfet_06v0 ad=49.3848p pd=66.5u as=49.3848p ps=66.5u w=64.98u l=1u
X10435 BAT GATE DVDD DVDD pfet_06v0 ad=58.1134p pd=77.985u as=71.8771p ps=0.15481m w=76.465u l=1u
X10436 BAT GATE DVDD DVDD pfet_06v0 ad=58.1172p pd=77.99u as=58.1172p ps=77.99u w=76.47u l=1u
X10437 BAT GATE DVDD DVDD pfet_06v0 ad=35.5072p pd=48.24u as=35.5072p ps=48.24u w=46.72u l=1u
X10438 BAT GATE DVDD DVDD pfet_06v0 ad=35.511p pd=48.245u as=35.511p ps=48.245u w=46.725u l=1u
X10439 BAT GATE DVDD DVDD pfet_06v0 ad=58.0754p pd=77.935u as=58.0754p ps=77.935u w=76.41499u l=1u
X10440 BAT GATE DVDD DVDD pfet_06v0 ad=58.1096p pd=77.98u as=58.1096p ps=77.98u w=76.46u l=1u
X10441 DVDD GATE BAT DVDD pfet_06v0 ad=47.6862p pd=64.265u as=47.6862p ps=64.265u w=62.745u l=1u
X10442 DVDD GATE BAT DVDD pfet_06v0 ad=58.1134p pd=77.985u as=58.1134p ps=77.985u w=76.465u l=1u
X10443 DVDD GATE BAT DVDD pfet_06v0 ad=58.1134p pd=77.985u as=58.1134p ps=77.985u w=76.465u l=1u
X10444 DVDD GATE BAT DVDD pfet_06v0 ad=58.1096p pd=77.98u as=58.1096p ps=77.98u w=76.46u l=1u
X10445 BAT GATE DVDD DVDD pfet_06v0 ad=58.0754p pd=77.935u as=71.8301p ps=0.15471m w=76.41499u l=1u
X10446 BAT GATE DVDD DVDD pfet_06v0 ad=58.1134p pd=77.985u as=58.1134p ps=77.985u w=76.465u l=1u
X10447 DVDD GATE BAT DVDD pfet_06v0 ad=35.511p pd=48.245u as=35.511p ps=48.245u w=46.725u l=1u
X10448 DVDD GATE BAT DVDD pfet_06v0 ad=35.511p pd=48.245u as=35.511p ps=48.245u w=46.725u l=1u
X10449 DVDD GATE BAT DVDD pfet_06v0 ad=71.8771p pd=0.15481m as=58.1134p ps=77.985u w=76.465u l=1u
X10450 BAT GATE DVDD DVDD pfet_06v0 ad=35.511p pd=48.245u as=35.511p ps=48.245u w=46.725u l=1u
X10451 DVDD GATE BAT DVDD pfet_06v0 ad=58.1134p pd=77.985u as=58.1134p ps=77.985u w=76.465u l=1u
X10452 BAT GATE DVDD DVDD pfet_06v0 ad=35.5072p pd=48.24u as=35.5072p ps=48.24u w=46.72u l=1u
X10453 BAT GATE DVDD DVDD pfet_06v0 ad=35.511p pd=48.245u as=35.511p ps=48.245u w=46.725u l=1u
X10454 BAT GATE DVDD DVDD pfet_06v0 ad=58.1552p pd=78.04u as=58.1552p ps=78.04u w=76.52u l=1u
X10455 DVDD GATE BAT DVDD pfet_06v0 ad=58.1134p pd=77.985u as=58.1134p ps=77.985u w=76.465u l=1u
X10456 DVDD GATE BAT DVDD pfet_06v0 ad=49.3848p pd=66.5u as=49.3848p ps=66.5u w=64.98u l=1u
X10457 DVDD GATE BAT DVDD pfet_06v0 ad=35.511p pd=48.245u as=35.511p ps=48.245u w=46.725u l=1u
X10458 DVDD GATE BAT DVDD pfet_06v0 ad=35.5072p pd=48.24u as=35.5072p ps=48.24u w=46.72u l=1u
X10459 BAT GATE DVDD DVDD pfet_06v0 ad=35.5072p pd=48.24u as=35.5072p ps=48.24u w=46.72u l=1u
X10460 BAT GATE DVDD DVDD pfet_06v0 ad=58.1134p pd=77.985u as=71.8771p ps=0.15481m w=76.465u l=1u
X10461 DVDD GATE BAT DVDD pfet_06v0 ad=35.511p pd=48.245u as=35.511p ps=48.245u w=46.725u l=1u
X10462 BAT GATE DVDD DVDD pfet_06v0 ad=35.511p pd=48.245u as=43.9215p ps=95.32999u w=46.725u l=1u
X10463 DVDD GATE BAT DVDD pfet_06v0 ad=49.3848p pd=66.5u as=49.3848p ps=66.5u w=64.98u l=1u
X10464 BAT GATE DVDD DVDD pfet_06v0 ad=47.6862p pd=64.265u as=58.9803p ps=0.12737m w=62.745u l=1u
X10465 BAT GATE DVDD DVDD pfet_06v0 ad=47.6862p pd=64.265u as=47.6862p ps=64.265u w=62.745u l=1u
X10466 BAT GATE DVDD DVDD pfet_06v0 ad=58.1134p pd=77.985u as=71.8771p ps=0.15481m w=76.465u l=1u
X10467 BAT GATE DVDD DVDD pfet_06v0 ad=35.511p pd=48.245u as=35.511p ps=48.245u w=46.725u l=1u
X10468 BAT GATE DVDD DVDD pfet_06v0 ad=58.1552p pd=78.04u as=58.1552p ps=78.04u w=76.52u l=1u
X10469 BAT GATE DVDD DVDD pfet_06v0 ad=58.1134p pd=77.985u as=58.1134p ps=77.985u w=76.465u l=1u
X10470 DVDD GATE BAT DVDD pfet_06v0 ad=35.511p pd=48.245u as=35.511p ps=48.245u w=46.725u l=1u
X10471 DVDD GATE BAT DVDD pfet_06v0 ad=58.1172p pd=77.99u as=58.1172p ps=77.99u w=76.47u l=1u
X10472 DVDD GATE BAT DVDD pfet_06v0 ad=58.1134p pd=77.985u as=58.1134p ps=77.985u w=76.465u l=1u
X10473 BAT GATE DVDD DVDD pfet_06v0 ad=58.1134p pd=77.985u as=58.1134p ps=77.985u w=76.465u l=1u
X10474 DVDD GATE BAT DVDD pfet_06v0 ad=71.8818p pd=0.15482m as=58.1172p ps=77.99u w=76.47u l=1u
X10475 BAT GATE DVDD DVDD pfet_06v0 ad=49.3848p pd=66.5u as=49.3848p ps=66.5u w=64.98u l=1u
X10476 BAT GATE DVDD DVDD pfet_06v0 ad=47.6862p pd=64.265u as=47.6862p ps=64.265u w=62.745u l=1u
X10477 BAT GATE DVDD DVDD pfet_06v0 ad=58.1134p pd=77.985u as=58.1134p ps=77.985u w=76.465u l=1u
X10478 BAT GATE DVDD DVDD pfet_06v0 ad=58.0754p pd=77.935u as=71.8301p ps=0.15471m w=76.41499u l=1u
X10479 BAT GATE DVDD DVDD pfet_06v0 ad=35.511p pd=48.245u as=35.511p ps=48.245u w=46.725u l=1u
X10480 DVDD GATE BAT DVDD pfet_06v0 ad=58.1134p pd=77.985u as=58.1134p ps=77.985u w=76.465u l=1u
X10481 DVDD GATE BAT DVDD pfet_06v0 ad=58.1134p pd=77.985u as=58.1134p ps=77.985u w=76.465u l=1u
X10482 BAT GATE DVDD DVDD pfet_06v0 ad=58.1134p pd=77.985u as=58.1134p ps=77.985u w=76.465u l=1u
X10483 DVDD GATE BAT DVDD pfet_06v0 ad=35.511p pd=48.245u as=35.511p ps=48.245u w=46.725u l=1u
X10484 BAT GATE DVDD DVDD pfet_06v0 ad=58.1134p pd=77.985u as=58.1134p ps=77.985u w=76.465u l=1u
X10485 DVDD GATE BAT DVDD pfet_06v0 ad=71.8771p pd=0.15481m as=58.1134p ps=77.985u w=76.465u l=1u
X10486 BAT GATE DVDD DVDD pfet_06v0 ad=35.5072p pd=48.24u as=35.5072p ps=48.24u w=46.72u l=1u
X10487 DVDD GATE BAT DVDD pfet_06v0 ad=71.8771p pd=0.15481m as=58.1134p ps=77.985u w=76.465u l=1u
X10488 BAT GATE DVDD DVDD pfet_06v0 ad=35.511p pd=48.245u as=35.511p ps=48.245u w=46.725u l=1u
X10489 BAT GATE DVDD DVDD pfet_06v0 ad=58.1134p pd=77.985u as=58.1134p ps=77.985u w=76.465u l=1u
X10490 DVDD GATE BAT DVDD pfet_06v0 ad=35.511p pd=48.245u as=35.511p ps=48.245u w=46.725u l=1u
X10491 DVDD GATE BAT DVDD pfet_06v0 ad=35.511p pd=48.245u as=35.511p ps=48.245u w=46.725u l=1u
X10492 DVDD GATE BAT DVDD pfet_06v0 ad=58.1134p pd=77.985u as=58.1134p ps=77.985u w=76.465u l=1u
X10493 DVDD GATE BAT DVDD pfet_06v0 ad=71.8771p pd=0.15481m as=58.1134p ps=77.985u w=76.465u l=1u
X10494 DVDD GATE BAT DVDD pfet_06v0 ad=58.1134p pd=77.985u as=58.1134p ps=77.985u w=76.465u l=1u
X10495 DVDD GATE BAT DVDD pfet_06v0 ad=58.1134p pd=77.985u as=58.1134p ps=77.985u w=76.465u l=1u
X10496 DVDD GATE BAT DVDD pfet_06v0 ad=58.1096p pd=77.98u as=58.1096p ps=77.98u w=76.46u l=1u
X10497 DVDD GATE BAT DVDD pfet_06v0 ad=35.511p pd=48.245u as=35.511p ps=48.245u w=46.725u l=1u
X10498 DVDD GATE BAT DVDD pfet_06v0 ad=35.511p pd=48.245u as=35.511p ps=48.245u w=46.725u l=1u
X10499 BAT GATE DVDD DVDD pfet_06v0 ad=58.1134p pd=77.985u as=58.1134p ps=77.985u w=76.465u l=1u
X10500 DVDD GATE BAT DVDD pfet_06v0 ad=58.1552p pd=78.04u as=58.1552p ps=78.04u w=76.52u l=1u
X10501 BAT GATE DVDD DVDD pfet_06v0 ad=58.1134p pd=77.985u as=58.1134p ps=77.985u w=76.465u l=1u
X10502 BAT GATE DVDD DVDD pfet_06v0 ad=35.511p pd=48.245u as=35.511p ps=48.245u w=46.725u l=1u
X10503 BAT GATE DVDD DVDD pfet_06v0 ad=35.511p pd=48.245u as=43.9215p ps=95.32999u w=46.725u l=1u
X10504 BAT GATE DVDD DVDD pfet_06v0 ad=58.1096p pd=77.98u as=71.8724p ps=0.1548m w=76.46u l=1u
X10505 BAT GATE DVDD DVDD pfet_06v0 ad=58.1134p pd=77.985u as=71.8771p ps=0.15481m w=76.465u l=1u
X10506 BAT GATE DVDD DVDD pfet_06v0 ad=35.511p pd=48.245u as=35.511p ps=48.245u w=46.725u l=1u
X10507 DVDD GATE BAT DVDD pfet_06v0 ad=58.1134p pd=77.985u as=58.1134p ps=77.985u w=76.465u l=1u
X10508 DVDD GATE BAT DVDD pfet_06v0 ad=35.511p pd=48.245u as=35.511p ps=48.245u w=46.725u l=1u
X10509 BAT GATE DVDD DVDD pfet_06v0 ad=35.511p pd=48.245u as=35.511p ps=48.245u w=46.725u l=1u
X10510 BAT GATE DVDD DVDD pfet_06v0 ad=35.511p pd=48.245u as=35.511p ps=48.245u w=46.725u l=1u
X10511 DVDD GATE BAT DVDD pfet_06v0 ad=35.511p pd=48.245u as=35.511p ps=48.245u w=46.725u l=1u
X10512 BAT GATE DVDD DVDD pfet_06v0 ad=35.511p pd=48.245u as=35.511p ps=48.245u w=46.725u l=1u
X10513 DVDD GATE BAT DVDD pfet_06v0 ad=58.0754p pd=77.935u as=58.0754p ps=77.935u w=76.41499u l=1u
X10514 BAT GATE DVDD DVDD pfet_06v0 ad=35.511p pd=48.245u as=35.511p ps=48.245u w=46.725u l=1u
X10515 BAT GATE DVDD DVDD pfet_06v0 ad=58.1552p pd=78.04u as=58.1552p ps=78.04u w=76.52u l=1u
X10516 BAT GATE DVDD DVDD pfet_06v0 ad=58.1134p pd=77.985u as=71.8771p ps=0.15481m w=76.465u l=1u
X10517 DVDD GATE BAT DVDD pfet_06v0 ad=35.511p pd=48.245u as=35.511p ps=48.245u w=46.725u l=1u
X10518 DVDD GATE BAT DVDD pfet_06v0 ad=35.511p pd=48.245u as=35.511p ps=48.245u w=46.725u l=1u
X10519 DVDD GATE BAT DVDD pfet_06v0 ad=43.9215p pd=95.32999u as=35.511p ps=48.245u w=46.725u l=1u
X10520 BAT GATE DVDD DVDD pfet_06v0 ad=58.1134p pd=77.985u as=58.1134p ps=77.985u w=76.465u l=1u
X10521 BAT GATE DVDD DVDD pfet_06v0 ad=58.1134p pd=77.985u as=58.1134p ps=77.985u w=76.465u l=1u
X10522 BAT GATE DVDD DVDD pfet_06v0 ad=35.511p pd=48.245u as=35.511p ps=48.245u w=46.725u l=1u
X10523 DVDD GATE BAT DVDD pfet_06v0 ad=58.1134p pd=77.985u as=58.1134p ps=77.985u w=76.465u l=1u
X10524 DVDD GATE BAT DVDD pfet_06v0 ad=58.9803p pd=0.12737m as=47.6862p ps=64.265u w=62.745u l=1u
X10525 DVDD GATE BAT DVDD pfet_06v0 ad=58.1134p pd=77.985u as=58.1134p ps=77.985u w=76.465u l=1u
X10526 BAT GATE DVDD DVDD pfet_06v0 ad=35.511p pd=48.245u as=35.511p ps=48.245u w=46.725u l=1u
X10527 BAT GATE DVDD DVDD pfet_06v0 ad=58.1134p pd=77.985u as=58.1134p ps=77.985u w=76.465u l=1u
X10528 DVDD GATE BAT DVDD pfet_06v0 ad=35.511p pd=48.245u as=35.511p ps=48.245u w=46.725u l=1u
X10529 BAT GATE DVDD DVDD pfet_06v0 ad=58.1172p pd=77.99u as=71.8818p ps=0.15482m w=76.47u l=1u
X10530 DVDD GATE BAT DVDD pfet_06v0 ad=35.511p pd=48.245u as=35.511p ps=48.245u w=46.725u l=1u
X10531 DVDD GATE BAT DVDD pfet_06v0 ad=71.8771p pd=0.15481m as=58.1134p ps=77.985u w=76.465u l=1u
X10532 BAT GATE DVDD DVDD pfet_06v0 ad=58.1172p pd=77.99u as=58.1172p ps=77.99u w=76.47u l=1u
X10533 DVDD GATE BAT DVDD pfet_06v0 ad=49.3848p pd=66.5u as=49.3848p ps=66.5u w=64.98u l=1u
X10534 DVDD GATE BAT DVDD pfet_06v0 ad=58.1552p pd=78.04u as=58.1552p ps=78.04u w=76.52u l=1u
X10535 DVDD GATE BAT DVDD pfet_06v0 ad=58.1134p pd=77.985u as=58.1134p ps=77.985u w=76.465u l=1u
X10536 BAT GATE DVDD DVDD pfet_06v0 ad=35.511p pd=48.245u as=35.511p ps=48.245u w=46.725u l=1u
X10537 BAT GATE DVDD DVDD pfet_06v0 ad=58.1134p pd=77.985u as=71.8771p ps=0.15481m w=76.465u l=1u
X10538 BAT GATE DVDD DVDD pfet_06v0 ad=58.1096p pd=77.98u as=58.1096p ps=77.98u w=76.46u l=1u
X10539 DVDD GATE BAT DVDD pfet_06v0 ad=58.1096p pd=77.98u as=58.1096p ps=77.98u w=76.46u l=1u
X10540 DVDD GATE BAT DVDD pfet_06v0 ad=58.0754p pd=77.935u as=58.0754p ps=77.935u w=76.41499u l=1u
X10541 DVDD GATE BAT DVDD pfet_06v0 ad=58.1134p pd=77.985u as=58.1134p ps=77.985u w=76.465u l=1u
X10542 BAT GATE DVDD DVDD pfet_06v0 ad=58.1134p pd=77.985u as=58.1134p ps=77.985u w=76.465u l=1u
X10543 BAT GATE DVDD DVDD pfet_06v0 ad=35.511p pd=48.245u as=35.511p ps=48.245u w=46.725u l=1u
X10544 DVDD GATE BAT DVDD pfet_06v0 ad=43.9168p pd=95.32u as=35.5072p ps=48.24u w=46.72u l=1u
X10545 BAT GATE DVDD DVDD pfet_06v0 ad=35.511p pd=48.245u as=35.511p ps=48.245u w=46.725u l=1u
X10546 BAT GATE DVDD DVDD pfet_06v0 ad=58.1134p pd=77.985u as=58.1134p ps=77.985u w=76.465u l=1u
X10547 BAT GATE DVDD DVDD pfet_06v0 ad=58.1134p pd=77.985u as=58.1134p ps=77.985u w=76.465u l=1u
X10548 BAT GATE DVDD DVDD pfet_06v0 ad=35.5072p pd=48.24u as=35.5072p ps=48.24u w=46.72u l=1u
X10549 DVDD GATE BAT DVDD pfet_06v0 ad=35.511p pd=48.245u as=35.511p ps=48.245u w=46.725u l=1u
X10550 DVDD GATE BAT DVDD pfet_06v0 ad=58.1172p pd=77.99u as=58.1172p ps=77.99u w=76.47u l=1u
X10551 DVDD GATE BAT DVDD pfet_06v0 ad=35.511p pd=48.245u as=35.511p ps=48.245u w=46.725u l=1u
X10552 DVDD GATE BAT DVDD pfet_06v0 ad=58.1552p pd=78.04u as=58.1552p ps=78.04u w=76.52u l=1u
X10553 BAT GATE DVDD DVDD pfet_06v0 ad=58.1134p pd=77.985u as=58.1134p ps=77.985u w=76.465u l=1u
X10554 BAT GATE DVDD DVDD pfet_06v0 ad=35.5072p pd=48.24u as=35.5072p ps=48.24u w=46.72u l=1u
X10555 BAT GATE DVDD DVDD pfet_06v0 ad=58.1552p pd=78.04u as=58.1552p ps=78.04u w=76.52u l=1u
X10556 DVDD GATE BAT DVDD pfet_06v0 ad=58.1134p pd=77.985u as=58.1134p ps=77.985u w=76.465u l=1u
X10557 BAT GATE DVDD DVDD pfet_06v0 ad=35.511p pd=48.245u as=35.511p ps=48.245u w=46.725u l=1u
X10558 DVDD GATE BAT DVDD pfet_06v0 ad=58.1134p pd=77.985u as=58.1134p ps=77.985u w=76.465u l=1u
X10559 DVDD GATE BAT DVDD pfet_06v0 ad=58.1134p pd=77.985u as=58.1134p ps=77.985u w=76.465u l=1u
X10560 BAT GATE DVDD DVDD pfet_06v0 ad=58.0754p pd=77.935u as=58.0754p ps=77.935u w=76.41499u l=1u
X10561 DVDD GATE BAT DVDD pfet_06v0 ad=58.1096p pd=77.98u as=58.1096p ps=77.98u w=76.46u l=1u
X10562 BAT GATE DVDD DVDD pfet_06v0 ad=58.1552p pd=78.04u as=71.92879p ps=0.15492m w=76.52u l=1u
X10563 DVDD GATE BAT DVDD pfet_06v0 ad=58.1134p pd=77.985u as=58.1134p ps=77.985u w=76.465u l=1u
X10564 BAT GATE DVDD DVDD pfet_06v0 ad=58.1134p pd=77.985u as=71.8771p ps=0.15481m w=76.465u l=1u
X10565 BAT GATE DVDD DVDD pfet_06v0 ad=58.1134p pd=77.985u as=71.8771p ps=0.15481m w=76.465u l=1u
X10566 DVDD GATE BAT DVDD pfet_06v0 ad=35.511p pd=48.245u as=35.511p ps=48.245u w=46.725u l=1u
X10567 BAT GATE DVDD DVDD pfet_06v0 ad=35.511p pd=48.245u as=35.511p ps=48.245u w=46.725u l=1u
X10568 BAT GATE DVDD DVDD pfet_06v0 ad=49.3848p pd=66.5u as=49.3848p ps=66.5u w=64.98u l=1u
X10569 DVDD GATE BAT DVDD pfet_06v0 ad=58.0754p pd=77.935u as=58.0754p ps=77.935u w=76.41499u l=1u
X10570 BAT GATE DVDD DVDD pfet_06v0 ad=58.1134p pd=77.985u as=58.1134p ps=77.985u w=76.465u l=1u
X10571 DVDD GATE BAT DVDD pfet_06v0 ad=58.1134p pd=77.985u as=58.1134p ps=77.985u w=76.465u l=1u
X10572 DVDD GATE BAT DVDD pfet_06v0 ad=58.0754p pd=77.935u as=58.0754p ps=77.935u w=76.41499u l=1u
X10573 DVDD GATE BAT DVDD pfet_06v0 ad=58.0754p pd=77.935u as=58.0754p ps=77.935u w=76.41499u l=1u
X10574 BAT GATE DVDD DVDD pfet_06v0 ad=35.511p pd=48.245u as=35.511p ps=48.245u w=46.725u l=1u
X10575 BAT GATE DVDD DVDD pfet_06v0 ad=35.511p pd=48.245u as=35.511p ps=48.245u w=46.725u l=1u
X10576 BAT GATE DVDD DVDD pfet_06v0 ad=35.511p pd=48.245u as=35.511p ps=48.245u w=46.725u l=1u
X10577 BAT GATE DVDD DVDD pfet_06v0 ad=35.511p pd=48.245u as=43.9215p ps=95.32999u w=46.725u l=1u
X10578 DVDD GATE BAT DVDD pfet_06v0 ad=58.1134p pd=77.985u as=58.1134p ps=77.985u w=76.465u l=1u
X10579 DVDD GATE BAT DVDD pfet_06v0 ad=43.9215p pd=95.32999u as=35.511p ps=48.245u w=46.725u l=1u
X10580 DVDD GATE BAT DVDD pfet_06v0 ad=35.511p pd=48.245u as=35.511p ps=48.245u w=46.725u l=1u
X10581 DVDD GATE BAT DVDD pfet_06v0 ad=58.1134p pd=77.985u as=58.1134p ps=77.985u w=76.465u l=1u
X10582 BAT GATE DVDD DVDD pfet_06v0 ad=35.511p pd=48.245u as=43.9215p ps=95.32999u w=46.725u l=1u
X10583 BAT GATE DVDD DVDD pfet_06v0 ad=35.511p pd=48.245u as=35.511p ps=48.245u w=46.725u l=1u
X10584 DVDD GATE BAT DVDD pfet_06v0 ad=35.511p pd=48.245u as=35.511p ps=48.245u w=46.725u l=1u
X10585 DVDD GATE BAT DVDD pfet_06v0 ad=35.511p pd=48.245u as=35.511p ps=48.245u w=46.725u l=1u
X10586 BAT GATE DVDD DVDD pfet_06v0 ad=35.511p pd=48.245u as=35.511p ps=48.245u w=46.725u l=1u
X10587 DVDD GATE BAT DVDD pfet_06v0 ad=58.1172p pd=77.99u as=58.1172p ps=77.99u w=76.47u l=1u
X10588 BAT GATE DVDD DVDD pfet_06v0 ad=35.511p pd=48.245u as=35.511p ps=48.245u w=46.725u l=1u
X10589 DVDD GATE BAT DVDD pfet_06v0 ad=35.511p pd=48.245u as=35.511p ps=48.245u w=46.725u l=1u
X10590 BAT GATE DVDD DVDD pfet_06v0 ad=58.1134p pd=77.985u as=58.1134p ps=77.985u w=76.465u l=1u
X10591 BAT GATE DVDD DVDD pfet_06v0 ad=58.1552p pd=78.04u as=58.1552p ps=78.04u w=76.52u l=1u
X10592 BAT GATE DVDD DVDD pfet_06v0 ad=35.511p pd=48.245u as=35.511p ps=48.245u w=46.725u l=1u
X10593 BAT GATE DVDD DVDD pfet_06v0 ad=58.1552p pd=78.04u as=71.92879p ps=0.15492m w=76.52u l=1u
X10594 BAT GATE DVDD DVDD pfet_06v0 ad=58.1134p pd=77.985u as=58.1134p ps=77.985u w=76.465u l=1u
X10595 BAT GATE DVDD DVDD pfet_06v0 ad=35.511p pd=48.245u as=35.511p ps=48.245u w=46.725u l=1u
X10596 DVDD GATE BAT DVDD pfet_06v0 ad=35.511p pd=48.245u as=35.511p ps=48.245u w=46.725u l=1u
X10597 DVDD GATE BAT DVDD pfet_06v0 ad=58.1134p pd=77.985u as=58.1134p ps=77.985u w=76.465u l=1u
X10598 BAT GATE DVDD DVDD pfet_06v0 ad=35.511p pd=48.245u as=35.511p ps=48.245u w=46.725u l=1u
X10599 DVDD GATE BAT DVDD pfet_06v0 ad=58.1096p pd=77.98u as=58.1096p ps=77.98u w=76.46u l=1u
X10600 BAT GATE DVDD DVDD pfet_06v0 ad=35.511p pd=48.245u as=35.511p ps=48.245u w=46.725u l=1u
X10601 DVDD GATE BAT DVDD pfet_06v0 ad=35.511p pd=48.245u as=35.511p ps=48.245u w=46.725u l=1u
X10602 DVDD GATE BAT DVDD pfet_06v0 ad=35.511p pd=48.245u as=35.511p ps=48.245u w=46.725u l=1u
X10603 BAT GATE DVDD DVDD pfet_06v0 ad=47.6862p pd=64.265u as=47.6862p ps=64.265u w=62.745u l=1u
X10604 DVDD GATE BAT DVDD pfet_06v0 ad=58.1552p pd=78.04u as=58.1552p ps=78.04u w=76.52u l=1u
X10605 BAT GATE DVDD DVDD pfet_06v0 ad=35.511p pd=48.245u as=35.511p ps=48.245u w=46.725u l=1u
X10606 BAT GATE DVDD DVDD pfet_06v0 ad=35.511p pd=48.245u as=35.511p ps=48.245u w=46.725u l=1u
X10607 BAT GATE DVDD DVDD pfet_06v0 ad=35.511p pd=48.245u as=43.9215p ps=95.32999u w=46.725u l=1u
X10608 BAT GATE DVDD DVDD pfet_06v0 ad=35.511p pd=48.245u as=35.511p ps=48.245u w=46.725u l=1u
X10609 DVDD GATE BAT DVDD pfet_06v0 ad=47.6862p pd=64.265u as=47.6862p ps=64.265u w=62.745u l=1u
X10610 DVDD GATE BAT DVDD pfet_06v0 ad=35.5072p pd=48.24u as=35.5072p ps=48.24u w=46.72u l=1u
X10611 DVDD GATE BAT DVDD pfet_06v0 ad=35.511p pd=48.245u as=35.511p ps=48.245u w=46.725u l=1u
X10612 BAT GATE DVDD DVDD pfet_06v0 ad=58.1134p pd=77.985u as=58.1134p ps=77.985u w=76.465u l=1u
X10613 DVDD GATE BAT DVDD pfet_06v0 ad=71.92879p pd=0.15492m as=58.1552p ps=78.04u w=76.52u l=1u
X10614 BAT GATE DVDD DVDD pfet_06v0 ad=58.1134p pd=77.985u as=58.1134p ps=77.985u w=76.465u l=1u
X10615 DVDD GATE BAT DVDD pfet_06v0 ad=35.5072p pd=48.24u as=35.5072p ps=48.24u w=46.72u l=1u
X10616 DVDD GATE BAT DVDD pfet_06v0 ad=71.8301p pd=0.15471m as=58.0754p ps=77.935u w=76.41499u l=1u
X10617 BAT GATE DVDD DVDD pfet_06v0 ad=35.511p pd=48.245u as=43.9215p ps=95.32999u w=46.725u l=1u
X10618 BAT GATE DVDD DVDD pfet_06v0 ad=35.511p pd=48.245u as=35.511p ps=48.245u w=46.725u l=1u
X10619 BAT GATE DVDD DVDD pfet_06v0 ad=58.1134p pd=77.985u as=58.1134p ps=77.985u w=76.465u l=1u
X10620 DVDD GATE BAT DVDD pfet_06v0 ad=61.0812p pd=0.13184m as=49.3848p ps=66.5u w=64.98u l=1u
X10621 DVDD GATE BAT DVDD pfet_06v0 ad=58.1134p pd=77.985u as=58.1134p ps=77.985u w=76.465u l=1u
X10622 DVDD GATE BAT DVDD pfet_06v0 ad=35.511p pd=48.245u as=35.511p ps=48.245u w=46.725u l=1u
X10623 BAT GATE DVDD DVDD pfet_06v0 ad=58.1552p pd=78.04u as=71.92879p ps=0.15492m w=76.52u l=1u
X10624 DVDD GATE BAT DVDD pfet_06v0 ad=35.511p pd=48.245u as=35.511p ps=48.245u w=46.725u l=1u
X10625 BAT GATE DVDD DVDD pfet_06v0 ad=35.511p pd=48.245u as=35.511p ps=48.245u w=46.725u l=1u
X10626 DVDD GATE BAT DVDD pfet_06v0 ad=58.1552p pd=78.04u as=58.1552p ps=78.04u w=76.52u l=1u
X10627 DVDD GATE BAT DVDD pfet_06v0 ad=58.1134p pd=77.985u as=58.1134p ps=77.985u w=76.465u l=1u
X10628 BAT GATE DVDD DVDD pfet_06v0 ad=58.1552p pd=78.04u as=58.1552p ps=78.04u w=76.52u l=1u
X10629 BAT GATE DVDD DVDD pfet_06v0 ad=35.511p pd=48.245u as=35.511p ps=48.245u w=46.725u l=1u
X10630 BAT GATE DVDD DVDD pfet_06v0 ad=58.1096p pd=77.98u as=58.1096p ps=77.98u w=76.46u l=1u
X10631 BAT GATE DVDD DVDD pfet_06v0 ad=58.0754p pd=77.935u as=58.0754p ps=77.935u w=76.41499u l=1u
X10632 DVDD GATE BAT DVDD pfet_06v0 ad=58.1134p pd=77.985u as=58.1134p ps=77.985u w=76.465u l=1u
X10633 BAT GATE DVDD DVDD pfet_06v0 ad=58.1134p pd=77.985u as=71.8771p ps=0.15481m w=76.465u l=1u
X10634 DVDD GATE BAT DVDD pfet_06v0 ad=35.511p pd=48.245u as=35.511p ps=48.245u w=46.725u l=1u
X10635 DVDD GATE BAT DVDD pfet_06v0 ad=61.0812p pd=0.13184m as=49.3848p ps=66.5u w=64.98u l=1u
X10636 BAT GATE DVDD DVDD pfet_06v0 ad=58.0754p pd=77.935u as=58.0754p ps=77.935u w=76.41499u l=1u
X10637 BAT GATE DVDD DVDD pfet_06v0 ad=47.6862p pd=64.265u as=47.6862p ps=64.265u w=62.745u l=1u
X10638 BAT GATE DVDD DVDD pfet_06v0 ad=49.3848p pd=66.5u as=49.3848p ps=66.5u w=64.98u l=1u
X10639 DVDD GATE BAT DVDD pfet_06v0 ad=71.8771p pd=0.15481m as=58.1134p ps=77.985u w=76.465u l=1u
X10640 BAT GATE DVDD DVDD pfet_06v0 ad=35.511p pd=48.245u as=43.9215p ps=95.32999u w=46.725u l=1u
X10641 BAT GATE DVDD DVDD pfet_06v0 ad=35.511p pd=48.245u as=35.511p ps=48.245u w=46.725u l=1u
X10642 BAT GATE DVDD DVDD pfet_06v0 ad=35.511p pd=48.245u as=35.511p ps=48.245u w=46.725u l=1u
X10643 DVDD GATE BAT DVDD pfet_06v0 ad=58.0754p pd=77.935u as=58.0754p ps=77.935u w=76.41499u l=1u
X10644 DVDD GATE BAT DVDD pfet_06v0 ad=71.92879p pd=0.15492m as=58.1552p ps=78.04u w=76.52u l=1u
X10645 BAT GATE DVDD DVDD pfet_06v0 ad=47.6862p pd=64.265u as=47.6862p ps=64.265u w=62.745u l=1u
X10646 BAT GATE DVDD DVDD pfet_06v0 ad=58.1134p pd=77.985u as=71.8771p ps=0.15481m w=76.465u l=1u
X10647 BAT GATE DVDD DVDD pfet_06v0 ad=58.1134p pd=77.985u as=71.8771p ps=0.15481m w=76.465u l=1u
X10648 BAT GATE DVDD DVDD pfet_06v0 ad=35.511p pd=48.245u as=35.511p ps=48.245u w=46.725u l=1u
X10649 DVDD GATE BAT DVDD pfet_06v0 ad=71.8771p pd=0.15481m as=58.1134p ps=77.985u w=76.465u l=1u
X10650 DVDD GATE BAT DVDD pfet_06v0 ad=49.3848p pd=66.5u as=49.3848p ps=66.5u w=64.98u l=1u
X10651 DVDD GATE BAT DVDD pfet_06v0 ad=58.1134p pd=77.985u as=58.1134p ps=77.985u w=76.465u l=1u
X10652 DVDD GATE BAT DVDD pfet_06v0 ad=58.1134p pd=77.985u as=58.1134p ps=77.985u w=76.465u l=1u
X10653 DVDD GATE BAT DVDD pfet_06v0 ad=35.511p pd=48.245u as=35.511p ps=48.245u w=46.725u l=1u
X10654 DVDD GATE BAT DVDD pfet_06v0 ad=43.9215p pd=95.32999u as=35.511p ps=48.245u w=46.725u l=1u
X10655 BAT GATE DVDD DVDD pfet_06v0 ad=58.1096p pd=77.98u as=58.1096p ps=77.98u w=76.46u l=1u
X10656 BAT GATE DVDD DVDD pfet_06v0 ad=58.0754p pd=77.935u as=58.0754p ps=77.935u w=76.41499u l=1u
X10657 DVDD GATE BAT DVDD pfet_06v0 ad=35.511p pd=48.245u as=35.511p ps=48.245u w=46.725u l=1u
X10658 DVDD GATE BAT DVDD pfet_06v0 ad=71.8771p pd=0.15481m as=58.1134p ps=77.985u w=76.465u l=1u
X10659 DVDD GATE BAT DVDD pfet_06v0 ad=58.1552p pd=78.04u as=58.1552p ps=78.04u w=76.52u l=1u
X10660 BAT GATE DVDD DVDD pfet_06v0 ad=49.3848p pd=66.5u as=49.3848p ps=66.5u w=64.98u l=1u
X10661 DVDD GATE BAT DVDD pfet_06v0 ad=35.5072p pd=48.24u as=35.5072p ps=48.24u w=46.72u l=1u
X10662 BAT GATE DVDD DVDD pfet_06v0 ad=35.511p pd=48.245u as=35.511p ps=48.245u w=46.725u l=1u
X10663 BAT GATE DVDD DVDD pfet_06v0 ad=35.511p pd=48.245u as=35.511p ps=48.245u w=46.725u l=1u
X10664 BAT GATE DVDD DVDD pfet_06v0 ad=58.1134p pd=77.985u as=71.8771p ps=0.15481m w=76.465u l=1u
X10665 BAT GATE DVDD DVDD pfet_06v0 ad=58.0754p pd=77.935u as=71.8301p ps=0.15471m w=76.41499u l=1u
X10666 BAT GATE DVDD DVDD pfet_06v0 ad=35.511p pd=48.245u as=35.511p ps=48.245u w=46.725u l=1u
X10667 DVDD GATE BAT DVDD pfet_06v0 ad=43.9215p pd=95.32999u as=35.511p ps=48.245u w=46.725u l=1u
X10668 BAT GATE DVDD DVDD pfet_06v0 ad=58.1134p pd=77.985u as=58.1134p ps=77.985u w=76.465u l=1u
X10669 BAT GATE DVDD DVDD pfet_06v0 ad=58.0754p pd=77.935u as=58.0754p ps=77.935u w=76.41499u l=1u
X10670 BAT GATE DVDD DVDD pfet_06v0 ad=35.511p pd=48.245u as=35.511p ps=48.245u w=46.725u l=1u
X10671 DVDD GATE BAT DVDD pfet_06v0 ad=35.511p pd=48.245u as=35.511p ps=48.245u w=46.725u l=1u
X10672 BAT GATE DVDD DVDD pfet_06v0 ad=58.0754p pd=77.935u as=58.0754p ps=77.935u w=76.41499u l=1u
X10673 DVDD GATE BAT DVDD pfet_06v0 ad=35.511p pd=48.245u as=35.511p ps=48.245u w=46.725u l=1u
X10674 BAT GATE DVDD DVDD pfet_06v0 ad=35.511p pd=48.245u as=35.511p ps=48.245u w=46.725u l=1u
X10675 DVDD GATE BAT DVDD pfet_06v0 ad=35.511p pd=48.245u as=35.511p ps=48.245u w=46.725u l=1u
X10676 DVDD GATE BAT DVDD pfet_06v0 ad=43.9215p pd=95.32999u as=35.511p ps=48.245u w=46.725u l=1u
X10677 BAT GATE DVDD DVDD pfet_06v0 ad=35.511p pd=48.245u as=43.9215p ps=95.32999u w=46.725u l=1u
X10678 BAT GATE DVDD DVDD pfet_06v0 ad=58.1172p pd=77.99u as=58.1172p ps=77.99u w=76.47u l=1u
X10679 BAT GATE DVDD DVDD pfet_06v0 ad=35.511p pd=48.245u as=35.511p ps=48.245u w=46.725u l=1u
X10680 DVDD GATE BAT DVDD pfet_06v0 ad=58.1134p pd=77.985u as=58.1134p ps=77.985u w=76.465u l=1u
X10681 BAT GATE DVDD DVDD pfet_06v0 ad=58.1134p pd=77.985u as=58.1134p ps=77.985u w=76.465u l=1u
X10682 BAT GATE DVDD DVDD pfet_06v0 ad=35.511p pd=48.245u as=35.511p ps=48.245u w=46.725u l=1u
X10683 DVDD GATE BAT DVDD pfet_06v0 ad=47.6862p pd=64.265u as=47.6862p ps=64.265u w=62.745u l=1u
X10684 DVDD GATE BAT DVDD pfet_06v0 ad=71.8771p pd=0.15481m as=58.1134p ps=77.985u w=76.465u l=1u
X10685 DVDD GATE BAT DVDD pfet_06v0 ad=58.1134p pd=77.985u as=58.1134p ps=77.985u w=76.465u l=1u
X10686 DVDD GATE BAT DVDD pfet_06v0 ad=58.9803p pd=0.12737m as=47.6862p ps=64.265u w=62.745u l=1u
X10687 DVDD GATE BAT DVDD pfet_06v0 ad=35.511p pd=48.245u as=35.511p ps=48.245u w=46.725u l=1u
X10688 DVDD GATE BAT DVDD pfet_06v0 ad=35.511p pd=48.245u as=35.511p ps=48.245u w=46.725u l=1u
X10689 DVDD GATE BAT DVDD pfet_06v0 ad=58.1134p pd=77.985u as=58.1134p ps=77.985u w=76.465u l=1u
X10690 DVDD GATE BAT DVDD pfet_06v0 ad=35.511p pd=48.245u as=35.511p ps=48.245u w=46.725u l=1u
X10691 DVDD GATE BAT DVDD pfet_06v0 ad=35.5072p pd=48.24u as=35.5072p ps=48.24u w=46.72u l=1u
X10692 BAT GATE DVDD DVDD pfet_06v0 ad=58.1172p pd=77.99u as=58.1172p ps=77.99u w=76.47u l=1u
X10693 DVDD GATE BAT DVDD pfet_06v0 ad=58.1134p pd=77.985u as=58.1134p ps=77.985u w=76.465u l=1u
X10694 BAT GATE DVDD DVDD pfet_06v0 ad=58.1134p pd=77.985u as=58.1134p ps=77.985u w=76.465u l=1u
X10695 DVDD GATE BAT DVDD pfet_06v0 ad=35.511p pd=48.245u as=35.511p ps=48.245u w=46.725u l=1u
X10696 DVDD GATE BAT DVDD pfet_06v0 ad=71.8771p pd=0.15481m as=58.1134p ps=77.985u w=76.465u l=1u
X10697 BAT GATE DVDD DVDD pfet_06v0 ad=58.1134p pd=77.985u as=58.1134p ps=77.985u w=76.465u l=1u
X10698 DVDD GATE BAT DVDD pfet_06v0 ad=35.511p pd=48.245u as=35.511p ps=48.245u w=46.725u l=1u
X10699 DVDD GATE BAT DVDD pfet_06v0 ad=35.511p pd=48.245u as=35.511p ps=48.245u w=46.725u l=1u
X10700 DVDD GATE BAT DVDD pfet_06v0 ad=58.1134p pd=77.985u as=58.1134p ps=77.985u w=76.465u l=1u
X10701 BAT GATE DVDD DVDD pfet_06v0 ad=58.1134p pd=77.985u as=71.8771p ps=0.15481m w=76.465u l=1u
X10702 DVDD GATE BAT DVDD pfet_06v0 ad=35.511p pd=48.245u as=35.511p ps=48.245u w=46.725u l=1u
X10703 DVDD GATE BAT DVDD pfet_06v0 ad=71.8301p pd=0.15471m as=58.0754p ps=77.935u w=76.41499u l=1u
X10704 DVDD GATE BAT DVDD pfet_06v0 ad=58.1134p pd=77.985u as=58.1134p ps=77.985u w=76.465u l=1u
X10705 DVDD GATE BAT DVDD pfet_06v0 ad=58.1134p pd=77.985u as=58.1134p ps=77.985u w=76.465u l=1u
X10706 BAT GATE DVDD DVDD pfet_06v0 ad=35.511p pd=48.245u as=35.511p ps=48.245u w=46.725u l=1u
X10707 BAT GATE DVDD DVDD pfet_06v0 ad=35.511p pd=48.245u as=35.511p ps=48.245u w=46.725u l=1u
X10708 DVDD GATE BAT DVDD pfet_06v0 ad=58.1134p pd=77.985u as=58.1134p ps=77.985u w=76.465u l=1u
X10709 BAT GATE DVDD DVDD pfet_06v0 ad=47.6862p pd=64.265u as=47.6862p ps=64.265u w=62.745u l=1u
X10710 DVDD GATE BAT DVDD pfet_06v0 ad=47.6862p pd=64.265u as=47.6862p ps=64.265u w=62.745u l=1u
X10711 DVDD GATE BAT DVDD pfet_06v0 ad=35.511p pd=48.245u as=35.511p ps=48.245u w=46.725u l=1u
X10712 DVDD GATE BAT DVDD pfet_06v0 ad=35.511p pd=48.245u as=35.511p ps=48.245u w=46.725u l=1u
X10713 BAT GATE DVDD DVDD pfet_06v0 ad=58.1134p pd=77.985u as=71.8771p ps=0.15481m w=76.465u l=1u
X10714 BAT GATE DVDD DVDD pfet_06v0 ad=58.1172p pd=77.99u as=58.1172p ps=77.99u w=76.47u l=1u
X10715 BAT GATE DVDD DVDD pfet_06v0 ad=35.511p pd=48.245u as=35.511p ps=48.245u w=46.725u l=1u
X10716 BAT GATE DVDD DVDD pfet_06v0 ad=35.511p pd=48.245u as=35.511p ps=48.245u w=46.725u l=1u
X10717 BAT GATE DVDD DVDD pfet_06v0 ad=58.1552p pd=78.04u as=58.1552p ps=78.04u w=76.52u l=1u
X10718 BAT GATE DVDD DVDD pfet_06v0 ad=35.511p pd=48.245u as=35.511p ps=48.245u w=46.725u l=1u
X10719 DVDD GATE BAT DVDD pfet_06v0 ad=58.9803p pd=0.12737m as=47.6862p ps=64.265u w=62.745u l=1u
X10720 DVDD GATE BAT DVDD pfet_06v0 ad=58.1134p pd=77.985u as=58.1134p ps=77.985u w=76.465u l=1u
X10721 DVDD GATE BAT DVDD pfet_06v0 ad=58.1134p pd=77.985u as=58.1134p ps=77.985u w=76.465u l=1u
X10722 DVDD GATE BAT DVDD pfet_06v0 ad=71.8771p pd=0.15481m as=58.1134p ps=77.985u w=76.465u l=1u
X10723 BAT GATE DVDD DVDD pfet_06v0 ad=49.3848p pd=66.5u as=49.3848p ps=66.5u w=64.98u l=1u
X10724 DVDD GATE BAT DVDD pfet_06v0 ad=58.1134p pd=77.985u as=58.1134p ps=77.985u w=76.465u l=1u
X10725 DVDD GATE BAT DVDD pfet_06v0 ad=71.8771p pd=0.15481m as=58.1134p ps=77.985u w=76.465u l=1u
X10726 BAT GATE DVDD DVDD pfet_06v0 ad=58.1134p pd=77.985u as=58.1134p ps=77.985u w=76.465u l=1u
X10727 BAT GATE DVDD DVDD pfet_06v0 ad=49.3848p pd=66.5u as=49.3848p ps=66.5u w=64.98u l=1u
X10728 DVDD GATE BAT DVDD pfet_06v0 ad=71.8724p pd=0.1548m as=58.1096p ps=77.98u w=76.46u l=1u
X10729 BAT GATE DVDD DVDD pfet_06v0 ad=35.511p pd=48.245u as=43.9215p ps=95.32999u w=46.725u l=1u
X10730 BAT GATE DVDD DVDD pfet_06v0 ad=58.1096p pd=77.98u as=58.1096p ps=77.98u w=76.46u l=1u
X10731 DVDD GATE BAT DVDD pfet_06v0 ad=35.511p pd=48.245u as=35.511p ps=48.245u w=46.725u l=1u
X10732 BAT GATE DVDD DVDD pfet_06v0 ad=58.1134p pd=77.985u as=71.8771p ps=0.15481m w=76.465u l=1u
X10733 DVDD GATE BAT DVDD pfet_06v0 ad=43.9215p pd=95.32999u as=35.511p ps=48.245u w=46.725u l=1u
X10734 DVDD GATE BAT DVDD pfet_06v0 ad=35.511p pd=48.245u as=35.511p ps=48.245u w=46.725u l=1u
X10735 DVDD GATE BAT DVDD pfet_06v0 ad=58.1134p pd=77.985u as=58.1134p ps=77.985u w=76.465u l=1u
X10736 DVDD GATE BAT DVDD pfet_06v0 ad=61.0812p pd=0.13184m as=49.3848p ps=66.5u w=64.98u l=1u
X10737 DVDD GATE BAT DVDD pfet_06v0 ad=49.3848p pd=66.5u as=49.3848p ps=66.5u w=64.98u l=1u
X10738 BAT GATE DVDD DVDD pfet_06v0 ad=49.3848p pd=66.5u as=49.3848p ps=66.5u w=64.98u l=1u
X10739 DVDD GATE BAT DVDD pfet_06v0 ad=58.0754p pd=77.935u as=58.0754p ps=77.935u w=76.41499u l=1u
X10740 BAT GATE DVDD DVDD pfet_06v0 ad=58.1134p pd=77.985u as=58.1134p ps=77.985u w=76.465u l=1u
X10741 BAT GATE DVDD DVDD pfet_06v0 ad=49.3848p pd=66.5u as=49.3848p ps=66.5u w=64.98u l=1u
X10742 BAT GATE DVDD DVDD pfet_06v0 ad=58.1172p pd=77.99u as=58.1172p ps=77.99u w=76.47u l=1u
X10743 BAT GATE DVDD DVDD pfet_06v0 ad=58.0754p pd=77.935u as=58.0754p ps=77.935u w=76.41499u l=1u
X10744 BAT GATE DVDD DVDD pfet_06v0 ad=58.1552p pd=78.04u as=58.1552p ps=78.04u w=76.52u l=1u
X10745 BAT GATE DVDD DVDD pfet_06v0 ad=58.1096p pd=77.98u as=58.1096p ps=77.98u w=76.46u l=1u
X10746 DVDD GATE BAT DVDD pfet_06v0 ad=47.6862p pd=64.265u as=47.6862p ps=64.265u w=62.745u l=1u
X10747 BAT GATE DVDD DVDD pfet_06v0 ad=47.6862p pd=64.265u as=47.6862p ps=64.265u w=62.745u l=1u
X10748 DVDD GATE BAT DVDD pfet_06v0 ad=43.9215p pd=95.32999u as=35.511p ps=48.245u w=46.725u l=1u
X10749 DVDD GATE BAT DVDD pfet_06v0 ad=58.1096p pd=77.98u as=58.1096p ps=77.98u w=76.46u l=1u
X10750 BAT GATE DVDD DVDD pfet_06v0 ad=58.1134p pd=77.985u as=71.8771p ps=0.15481m w=76.465u l=1u
X10751 BAT GATE DVDD DVDD pfet_06v0 ad=35.5072p pd=48.24u as=35.5072p ps=48.24u w=46.72u l=1u
X10752 BAT GATE DVDD DVDD pfet_06v0 ad=49.3848p pd=66.5u as=49.3848p ps=66.5u w=64.98u l=1u
X10753 DVDD GATE BAT DVDD pfet_06v0 ad=71.8818p pd=0.15482m as=58.1172p ps=77.99u w=76.47u l=1u
X10754 BAT GATE DVDD DVDD pfet_06v0 ad=35.511p pd=48.245u as=35.511p ps=48.245u w=46.725u l=1u
X10755 DVDD GATE BAT DVDD pfet_06v0 ad=58.1134p pd=77.985u as=58.1134p ps=77.985u w=76.465u l=1u
X10756 DVDD GATE BAT DVDD pfet_06v0 ad=58.1134p pd=77.985u as=58.1134p ps=77.985u w=76.465u l=1u
X10757 DVDD GATE BAT DVDD pfet_06v0 ad=35.511p pd=48.245u as=35.511p ps=48.245u w=46.725u l=1u
X10758 BAT GATE DVDD DVDD pfet_06v0 ad=35.5072p pd=48.24u as=35.5072p ps=48.24u w=46.72u l=1u
X10759 DVDD GATE BAT DVDD pfet_06v0 ad=58.1134p pd=77.985u as=58.1134p ps=77.985u w=76.465u l=1u
X10760 BAT GATE DVDD DVDD pfet_06v0 ad=58.0754p pd=77.935u as=71.8301p ps=0.15471m w=76.41499u l=1u
X10761 DVDD GATE BAT DVDD pfet_06v0 ad=58.1134p pd=77.985u as=58.1134p ps=77.985u w=76.465u l=1u
X10762 DVDD GATE BAT DVDD pfet_06v0 ad=35.511p pd=48.245u as=35.511p ps=48.245u w=46.725u l=1u
X10763 DVDD GATE BAT DVDD pfet_06v0 ad=49.3848p pd=66.5u as=49.3848p ps=66.5u w=64.98u l=1u
X10764 DVDD GATE BAT DVDD pfet_06v0 ad=58.1134p pd=77.985u as=58.1134p ps=77.985u w=76.465u l=1u
X10765 DVDD GATE BAT DVDD pfet_06v0 ad=35.5072p pd=48.24u as=35.5072p ps=48.24u w=46.72u l=1u
X10766 DVDD GATE BAT DVDD pfet_06v0 ad=43.9215p pd=95.32999u as=35.511p ps=48.245u w=46.725u l=1u
X10767 DVDD GATE BAT DVDD pfet_06v0 ad=35.511p pd=48.245u as=35.511p ps=48.245u w=46.725u l=1u
X10768 DVDD GATE BAT DVDD pfet_06v0 ad=58.1096p pd=77.98u as=58.1096p ps=77.98u w=76.46u l=1u
X10769 DVDD GATE BAT DVDD pfet_06v0 ad=71.8771p pd=0.15481m as=58.1134p ps=77.985u w=76.465u l=1u
X10770 DVDD GATE BAT DVDD pfet_06v0 ad=43.9215p pd=95.32999u as=35.511p ps=48.245u w=46.725u l=1u
X10771 BAT GATE DVDD DVDD pfet_06v0 ad=35.511p pd=48.245u as=35.511p ps=48.245u w=46.725u l=1u
X10772 BAT GATE DVDD DVDD pfet_06v0 ad=58.1552p pd=78.04u as=58.1552p ps=78.04u w=76.52u l=1u
X10773 DVDD GATE BAT DVDD pfet_06v0 ad=35.511p pd=48.245u as=35.511p ps=48.245u w=46.725u l=1u
X10774 DVDD GATE BAT DVDD pfet_06v0 ad=71.8771p pd=0.15481m as=58.1134p ps=77.985u w=76.465u l=1u
X10775 DVDD GATE BAT DVDD pfet_06v0 ad=35.511p pd=48.245u as=35.511p ps=48.245u w=46.725u l=1u
X10776 BAT GATE DVDD DVDD pfet_06v0 ad=58.1134p pd=77.985u as=58.1134p ps=77.985u w=76.465u l=1u
X10777 DVDD GATE BAT DVDD pfet_06v0 ad=35.5072p pd=48.24u as=35.5072p ps=48.24u w=46.72u l=1u
X10778 BAT GATE DVDD DVDD pfet_06v0 ad=35.511p pd=48.245u as=43.9215p ps=95.32999u w=46.725u l=1u
X10779 DVDD GATE BAT DVDD pfet_06v0 ad=58.1172p pd=77.99u as=58.1172p ps=77.99u w=76.47u l=1u
X10780 DVDD GATE BAT DVDD pfet_06v0 ad=58.1172p pd=77.99u as=58.1172p ps=77.99u w=76.47u l=1u
X10781 BAT GATE DVDD DVDD pfet_06v0 ad=58.1134p pd=77.985u as=58.1134p ps=77.985u w=76.465u l=1u
X10782 BAT GATE DVDD DVDD pfet_06v0 ad=35.511p pd=48.245u as=35.511p ps=48.245u w=46.725u l=1u
X10783 BAT GATE DVDD DVDD pfet_06v0 ad=58.1134p pd=77.985u as=58.1134p ps=77.985u w=76.465u l=1u
X10784 BAT GATE DVDD DVDD pfet_06v0 ad=58.1134p pd=77.985u as=71.8771p ps=0.15481m w=76.465u l=1u
X10785 DVDD GATE BAT DVDD pfet_06v0 ad=35.511p pd=48.245u as=35.511p ps=48.245u w=46.725u l=1u
X10786 BAT GATE DVDD DVDD pfet_06v0 ad=35.5072p pd=48.24u as=35.5072p ps=48.24u w=46.72u l=1u
X10787 BAT GATE DVDD DVDD pfet_06v0 ad=58.1134p pd=77.985u as=58.1134p ps=77.985u w=76.465u l=1u
X10788 DVDD GATE BAT DVDD pfet_06v0 ad=58.1134p pd=77.985u as=58.1134p ps=77.985u w=76.465u l=1u
X10789 DVDD GATE BAT DVDD pfet_06v0 ad=58.1134p pd=77.985u as=58.1134p ps=77.985u w=76.465u l=1u
X10790 BAT GATE DVDD DVDD pfet_06v0 ad=58.1134p pd=77.985u as=58.1134p ps=77.985u w=76.465u l=1u
X10791 BAT GATE DVDD DVDD pfet_06v0 ad=35.511p pd=48.245u as=35.511p ps=48.245u w=46.725u l=1u
X10792 BAT GATE DVDD DVDD pfet_06v0 ad=58.1134p pd=77.985u as=58.1134p ps=77.985u w=76.465u l=1u
X10793 DVDD GATE BAT DVDD pfet_06v0 ad=35.511p pd=48.245u as=35.511p ps=48.245u w=46.725u l=1u
X10794 DVDD GATE BAT DVDD pfet_06v0 ad=71.92879p pd=0.15492m as=58.1552p ps=78.04u w=76.52u l=1u
X10795 BAT GATE DVDD DVDD pfet_06v0 ad=35.511p pd=48.245u as=35.511p ps=48.245u w=46.725u l=1u
X10796 DVDD GATE BAT DVDD pfet_06v0 ad=58.1134p pd=77.985u as=58.1134p ps=77.985u w=76.465u l=1u
X10797 BAT GATE DVDD DVDD pfet_06v0 ad=58.1134p pd=77.985u as=58.1134p ps=77.985u w=76.465u l=1u
X10798 DVDD GATE BAT DVDD pfet_06v0 ad=35.511p pd=48.245u as=35.511p ps=48.245u w=46.725u l=1u
X10799 DVDD GATE BAT DVDD pfet_06v0 ad=58.1096p pd=77.98u as=58.1096p ps=77.98u w=76.46u l=1u
X10800 DVDD GATE BAT DVDD pfet_06v0 ad=58.1552p pd=78.04u as=58.1552p ps=78.04u w=76.52u l=1u
X10801 BAT GATE DVDD DVDD pfet_06v0 ad=58.1134p pd=77.985u as=58.1134p ps=77.985u w=76.465u l=1u
X10802 BAT GATE DVDD DVDD pfet_06v0 ad=58.1134p pd=77.985u as=58.1134p ps=77.985u w=76.465u l=1u
X10803 BAT GATE DVDD DVDD pfet_06v0 ad=35.511p pd=48.245u as=35.511p ps=48.245u w=46.725u l=1u
X10804 BAT GATE DVDD DVDD pfet_06v0 ad=35.511p pd=48.245u as=43.9215p ps=95.32999u w=46.725u l=1u
X10805 DVDD GATE BAT DVDD pfet_06v0 ad=58.1134p pd=77.985u as=58.1134p ps=77.985u w=76.465u l=1u
X10806 DVDD GATE BAT DVDD pfet_06v0 ad=35.511p pd=48.245u as=35.511p ps=48.245u w=46.725u l=1u
X10807 BAT GATE DVDD DVDD pfet_06v0 ad=35.511p pd=48.245u as=43.9215p ps=95.32999u w=46.725u l=1u
X10808 DVDD GATE BAT DVDD pfet_06v0 ad=43.9215p pd=95.32999u as=35.511p ps=48.245u w=46.725u l=1u
X10809 BAT GATE DVDD DVDD pfet_06v0 ad=47.6862p pd=64.265u as=47.6862p ps=64.265u w=62.745u l=1u
X10810 BAT GATE DVDD DVDD pfet_06v0 ad=35.511p pd=48.245u as=43.9215p ps=95.32999u w=46.725u l=1u
X10811 DVDD GATE BAT DVDD pfet_06v0 ad=35.511p pd=48.245u as=35.511p ps=48.245u w=46.725u l=1u
X10812 BAT GATE DVDD DVDD pfet_06v0 ad=58.1134p pd=77.985u as=58.1134p ps=77.985u w=76.465u l=1u
X10813 BAT GATE DVDD DVDD pfet_06v0 ad=58.1134p pd=77.985u as=58.1134p ps=77.985u w=76.465u l=1u
X10814 BAT GATE DVDD DVDD pfet_06v0 ad=58.1134p pd=77.985u as=58.1134p ps=77.985u w=76.465u l=1u
X10815 DVDD GATE BAT DVDD pfet_06v0 ad=58.1134p pd=77.985u as=58.1134p ps=77.985u w=76.465u l=1u
X10816 DVDD GATE BAT DVDD pfet_06v0 ad=58.0754p pd=77.935u as=58.0754p ps=77.935u w=76.41499u l=1u
X10817 BAT GATE DVDD DVDD pfet_06v0 ad=35.511p pd=48.245u as=35.511p ps=48.245u w=46.725u l=1u
X10818 DVDD GATE BAT DVDD pfet_06v0 ad=47.6862p pd=64.265u as=47.6862p ps=64.265u w=62.745u l=1u
X10819 DVDD GATE BAT DVDD pfet_06v0 ad=35.511p pd=48.245u as=35.511p ps=48.245u w=46.725u l=1u
X10820 BAT GATE DVDD DVDD pfet_06v0 ad=58.1552p pd=78.04u as=71.92879p ps=0.15492m w=76.52u l=1u
X10821 DVDD GATE BAT DVDD pfet_06v0 ad=58.1134p pd=77.985u as=58.1134p ps=77.985u w=76.465u l=1u
X10822 DVDD GATE BAT DVDD pfet_06v0 ad=71.92879p pd=0.15492m as=58.1552p ps=78.04u w=76.52u l=1u
X10823 DVDD GATE BAT DVDD pfet_06v0 ad=35.511p pd=48.245u as=35.511p ps=48.245u w=46.725u l=1u
X10824 BAT GATE DVDD DVDD pfet_06v0 ad=58.1134p pd=77.985u as=71.8771p ps=0.15481m w=76.465u l=1u
X10825 BAT GATE DVDD DVDD pfet_06v0 ad=35.511p pd=48.245u as=35.511p ps=48.245u w=46.725u l=1u
X10826 DVDD GATE BAT DVDD pfet_06v0 ad=43.9168p pd=95.32u as=35.5072p ps=48.24u w=46.72u l=1u
X10827 BAT GATE DVDD DVDD pfet_06v0 ad=58.1134p pd=77.985u as=71.8771p ps=0.15481m w=76.465u l=1u
X10828 DVDD GATE BAT DVDD pfet_06v0 ad=58.1134p pd=77.985u as=58.1134p ps=77.985u w=76.465u l=1u
X10829 DVDD GATE BAT DVDD pfet_06v0 ad=58.1134p pd=77.985u as=58.1134p ps=77.985u w=76.465u l=1u
X10830 BAT GATE DVDD DVDD pfet_06v0 ad=49.3848p pd=66.5u as=49.3848p ps=66.5u w=64.98u l=1u
X10831 BAT GATE DVDD DVDD pfet_06v0 ad=58.0754p pd=77.935u as=58.0754p ps=77.935u w=76.41499u l=1u
X10832 DVDD GATE BAT DVDD pfet_06v0 ad=35.511p pd=48.245u as=35.511p ps=48.245u w=46.725u l=1u
X10833 DVDD GATE BAT DVDD pfet_06v0 ad=47.6862p pd=64.265u as=47.6862p ps=64.265u w=62.745u l=1u
X10834 DVDD GATE BAT DVDD pfet_06v0 ad=35.511p pd=48.245u as=35.511p ps=48.245u w=46.725u l=1u
X10835 DVDD GATE BAT DVDD pfet_06v0 ad=35.511p pd=48.245u as=35.511p ps=48.245u w=46.725u l=1u
X10836 DVDD GATE BAT DVDD pfet_06v0 ad=58.1134p pd=77.985u as=58.1134p ps=77.985u w=76.465u l=1u
X10837 DVDD GATE BAT DVDD pfet_06v0 ad=49.3848p pd=66.5u as=49.3848p ps=66.5u w=64.98u l=1u
X10838 DVDD GATE BAT DVDD pfet_06v0 ad=58.1134p pd=77.985u as=58.1134p ps=77.985u w=76.465u l=1u
X10839 DVDD GATE BAT DVDD pfet_06v0 ad=71.8771p pd=0.15481m as=58.1134p ps=77.985u w=76.465u l=1u
X10840 DVDD GATE BAT DVDD pfet_06v0 ad=71.8771p pd=0.15481m as=58.1134p ps=77.985u w=76.465u l=1u
X10841 BAT GATE DVDD DVDD pfet_06v0 ad=35.511p pd=48.245u as=35.511p ps=48.245u w=46.725u l=1u
X10842 DVDD GATE BAT DVDD pfet_06v0 ad=58.1096p pd=77.98u as=58.1096p ps=77.98u w=76.46u l=1u
X10843 DVDD GATE BAT DVDD pfet_06v0 ad=47.6862p pd=64.265u as=47.6862p ps=64.265u w=62.745u l=1u
X10844 DVDD GATE BAT DVDD pfet_06v0 ad=58.1134p pd=77.985u as=58.1134p ps=77.985u w=76.465u l=1u
X10845 BAT GATE DVDD DVDD pfet_06v0 ad=58.1096p pd=77.98u as=71.8724p ps=0.1548m w=76.46u l=1u
X10846 DVDD GATE BAT DVDD pfet_06v0 ad=58.0754p pd=77.935u as=58.0754p ps=77.935u w=76.41499u l=1u
X10847 BAT GATE DVDD DVDD pfet_06v0 ad=58.1134p pd=77.985u as=58.1134p ps=77.985u w=76.465u l=1u
X10848 DVDD GATE BAT DVDD pfet_06v0 ad=58.1134p pd=77.985u as=58.1134p ps=77.985u w=76.465u l=1u
X10849 DVDD GATE BAT DVDD pfet_06v0 ad=35.5072p pd=48.24u as=35.5072p ps=48.24u w=46.72u l=1u
X10850 BAT GATE DVDD DVDD pfet_06v0 ad=35.511p pd=48.245u as=35.511p ps=48.245u w=46.725u l=1u
X10851 DVDD GATE BAT DVDD pfet_06v0 ad=35.511p pd=48.245u as=35.511p ps=48.245u w=46.725u l=1u
X10852 BAT GATE DVDD DVDD pfet_06v0 ad=58.1134p pd=77.985u as=58.1134p ps=77.985u w=76.465u l=1u
X10853 DVDD GATE BAT DVDD pfet_06v0 ad=58.1552p pd=78.04u as=58.1552p ps=78.04u w=76.52u l=1u
X10854 BAT GATE DVDD DVDD pfet_06v0 ad=58.1134p pd=77.985u as=71.8771p ps=0.15481m w=76.465u l=1u
X10855 DVDD GATE BAT DVDD pfet_06v0 ad=35.511p pd=48.245u as=35.511p ps=48.245u w=46.725u l=1u
X10856 BAT GATE DVDD DVDD pfet_06v0 ad=35.5072p pd=48.24u as=43.9168p ps=95.32u w=46.72u l=1u
X10857 BAT GATE DVDD DVDD pfet_06v0 ad=35.511p pd=48.245u as=35.511p ps=48.245u w=46.725u l=1u
X10858 BAT GATE DVDD DVDD pfet_06v0 ad=58.1552p pd=78.04u as=58.1552p ps=78.04u w=76.52u l=1u
X10859 BAT GATE DVDD DVDD pfet_06v0 ad=35.511p pd=48.245u as=35.511p ps=48.245u w=46.725u l=1u
X10860 BAT GATE DVDD DVDD pfet_06v0 ad=58.1134p pd=77.985u as=58.1134p ps=77.985u w=76.465u l=1u
X10861 BAT GATE DVDD DVDD pfet_06v0 ad=58.1134p pd=77.985u as=58.1134p ps=77.985u w=76.465u l=1u
X10862 DVDD GATE BAT DVDD pfet_06v0 ad=58.1134p pd=77.985u as=58.1134p ps=77.985u w=76.465u l=1u
X10863 BAT GATE DVDD DVDD pfet_06v0 ad=58.1134p pd=77.985u as=58.1134p ps=77.985u w=76.465u l=1u
X10864 DVDD GATE BAT DVDD pfet_06v0 ad=71.8771p pd=0.15481m as=58.1134p ps=77.985u w=76.465u l=1u
X10865 DVDD GATE BAT DVDD pfet_06v0 ad=35.511p pd=48.245u as=35.511p ps=48.245u w=46.725u l=1u
X10866 BAT GATE DVDD DVDD pfet_06v0 ad=35.511p pd=48.245u as=35.511p ps=48.245u w=46.725u l=1u
X10867 BAT GATE DVDD DVDD pfet_06v0 ad=35.511p pd=48.245u as=35.511p ps=48.245u w=46.725u l=1u
X10868 DVDD GATE BAT DVDD pfet_06v0 ad=58.1134p pd=77.985u as=58.1134p ps=77.985u w=76.465u l=1u
X10869 BAT GATE DVDD DVDD pfet_06v0 ad=58.0754p pd=77.935u as=58.0754p ps=77.935u w=76.41499u l=1u
X10870 DVDD GATE BAT DVDD pfet_06v0 ad=58.1096p pd=77.98u as=58.1096p ps=77.98u w=76.46u l=1u
X10871 DVDD GATE BAT DVDD pfet_06v0 ad=43.9215p pd=95.32999u as=35.511p ps=48.245u w=46.725u l=1u
X10872 DVDD GATE BAT DVDD pfet_06v0 ad=43.9215p pd=95.32999u as=35.511p ps=48.245u w=46.725u l=1u
X10873 BAT GATE DVDD DVDD pfet_06v0 ad=35.511p pd=48.245u as=35.511p ps=48.245u w=46.725u l=1u
X10874 DVDD GATE BAT DVDD pfet_06v0 ad=35.511p pd=48.245u as=35.511p ps=48.245u w=46.725u l=1u
X10875 DVDD GATE BAT DVDD pfet_06v0 ad=43.9215p pd=95.32999u as=35.511p ps=48.245u w=46.725u l=1u
X10876 BAT GATE DVDD DVDD pfet_06v0 ad=35.511p pd=48.245u as=43.9215p ps=95.32999u w=46.725u l=1u
X10877 DVDD GATE BAT DVDD pfet_06v0 ad=58.1096p pd=77.98u as=58.1096p ps=77.98u w=76.46u l=1u
X10878 BAT GATE DVDD DVDD pfet_06v0 ad=49.3848p pd=66.5u as=49.3848p ps=66.5u w=64.98u l=1u
X10879 BAT GATE DVDD DVDD pfet_06v0 ad=35.511p pd=48.245u as=35.511p ps=48.245u w=46.725u l=1u
X10880 DVDD GATE BAT DVDD pfet_06v0 ad=58.1134p pd=77.985u as=58.1134p ps=77.985u w=76.465u l=1u
X10881 DVDD GATE BAT DVDD pfet_06v0 ad=58.1552p pd=78.04u as=58.1552p ps=78.04u w=76.52u l=1u
X10882 DVDD GATE BAT DVDD pfet_06v0 ad=58.0754p pd=77.935u as=58.0754p ps=77.935u w=76.41499u l=1u
X10883 DVDD GATE BAT DVDD pfet_06v0 ad=71.92879p pd=0.15492m as=58.1552p ps=78.04u w=76.52u l=1u
X10884 BAT GATE DVDD DVDD pfet_06v0 ad=35.511p pd=48.245u as=43.9215p ps=95.32999u w=46.725u l=1u
X10885 DVDD GATE BAT DVDD pfet_06v0 ad=35.511p pd=48.245u as=35.511p ps=48.245u w=46.725u l=1u
X10886 DVDD GATE BAT DVDD pfet_06v0 ad=58.1134p pd=77.985u as=58.1134p ps=77.985u w=76.465u l=1u
X10887 BAT GATE DVDD DVDD pfet_06v0 ad=35.511p pd=48.245u as=35.511p ps=48.245u w=46.725u l=1u
X10888 BAT GATE DVDD DVDD pfet_06v0 ad=35.511p pd=48.245u as=35.511p ps=48.245u w=46.725u l=1u
X10889 BAT GATE DVDD DVDD pfet_06v0 ad=35.511p pd=48.245u as=35.511p ps=48.245u w=46.725u l=1u
X10890 DVDD GATE BAT DVDD pfet_06v0 ad=61.0812p pd=0.13184m as=49.3848p ps=66.5u w=64.98u l=1u
X10891 DVDD GATE BAT DVDD pfet_06v0 ad=58.1134p pd=77.985u as=58.1134p ps=77.985u w=76.465u l=1u
X10892 DVDD GATE BAT DVDD pfet_06v0 ad=35.511p pd=48.245u as=35.511p ps=48.245u w=46.725u l=1u
X10893 DVDD GATE BAT DVDD pfet_06v0 ad=58.1134p pd=77.985u as=58.1134p ps=77.985u w=76.465u l=1u
X10894 DVDD GATE BAT DVDD pfet_06v0 ad=35.511p pd=48.245u as=35.511p ps=48.245u w=46.725u l=1u
X10895 DVDD GATE BAT DVDD pfet_06v0 ad=43.9215p pd=95.32999u as=35.511p ps=48.245u w=46.725u l=1u
X10896 BAT GATE DVDD DVDD pfet_06v0 ad=58.1134p pd=77.985u as=58.1134p ps=77.985u w=76.465u l=1u
X10897 DVDD GATE BAT DVDD pfet_06v0 ad=35.511p pd=48.245u as=35.511p ps=48.245u w=46.725u l=1u
X10898 DVDD GATE BAT DVDD pfet_06v0 ad=71.8771p pd=0.15481m as=58.1134p ps=77.985u w=76.465u l=1u
X10899 DVDD GATE BAT DVDD pfet_06v0 ad=35.511p pd=48.245u as=35.511p ps=48.245u w=46.725u l=1u
X10900 BAT GATE DVDD DVDD pfet_06v0 ad=35.511p pd=48.245u as=35.511p ps=48.245u w=46.725u l=1u
X10901 BAT GATE DVDD DVDD pfet_06v0 ad=35.511p pd=48.245u as=35.511p ps=48.245u w=46.725u l=1u
X10902 DVDD GATE BAT DVDD pfet_06v0 ad=58.1134p pd=77.985u as=58.1134p ps=77.985u w=76.465u l=1u
X10903 DVDD GATE BAT DVDD pfet_06v0 ad=58.1172p pd=77.99u as=58.1172p ps=77.99u w=76.47u l=1u
X10904 BAT GATE DVDD DVDD pfet_06v0 ad=35.511p pd=48.245u as=35.511p ps=48.245u w=46.725u l=1u
X10905 BAT GATE DVDD DVDD pfet_06v0 ad=58.1134p pd=77.985u as=58.1134p ps=77.985u w=76.465u l=1u
X10906 DVDD GATE BAT DVDD pfet_06v0 ad=71.8818p pd=0.15482m as=58.1172p ps=77.99u w=76.47u l=1u
X10907 BAT GATE DVDD DVDD pfet_06v0 ad=58.1134p pd=77.985u as=58.1134p ps=77.985u w=76.465u l=1u
X10908 BAT GATE DVDD DVDD pfet_06v0 ad=58.1134p pd=77.985u as=58.1134p ps=77.985u w=76.465u l=1u
X10909 BAT GATE DVDD DVDD pfet_06v0 ad=35.511p pd=48.245u as=35.511p ps=48.245u w=46.725u l=1u
X10910 DVDD GATE BAT DVDD pfet_06v0 ad=43.9215p pd=95.32999u as=35.511p ps=48.245u w=46.725u l=1u
X10911 DVDD GATE BAT DVDD pfet_06v0 ad=71.8771p pd=0.15481m as=58.1134p ps=77.985u w=76.465u l=1u
X10912 DVDD GATE BAT DVDD pfet_06v0 ad=58.1134p pd=77.985u as=58.1134p ps=77.985u w=76.465u l=1u
X10913 BAT GATE DVDD DVDD pfet_06v0 ad=35.511p pd=48.245u as=35.511p ps=48.245u w=46.725u l=1u
X10914 DVDD GATE BAT DVDD pfet_06v0 ad=58.1134p pd=77.985u as=58.1134p ps=77.985u w=76.465u l=1u
X10915 DVDD GATE BAT DVDD pfet_06v0 ad=58.1096p pd=77.98u as=58.1096p ps=77.98u w=76.46u l=1u
X10916 DVDD GATE BAT DVDD pfet_06v0 ad=71.8771p pd=0.15481m as=58.1134p ps=77.985u w=76.465u l=1u
X10917 BAT GATE DVDD DVDD pfet_06v0 ad=58.0754p pd=77.935u as=58.0754p ps=77.935u w=76.41499u l=1u
X10918 BAT GATE DVDD DVDD pfet_06v0 ad=49.3848p pd=66.5u as=49.3848p ps=66.5u w=64.98u l=1u
X10919 BAT GATE DVDD DVDD pfet_06v0 ad=58.1134p pd=77.985u as=58.1134p ps=77.985u w=76.465u l=1u
X10920 DVDD GATE BAT DVDD pfet_06v0 ad=35.511p pd=48.245u as=35.511p ps=48.245u w=46.725u l=1u
X10921 BAT GATE DVDD DVDD pfet_06v0 ad=47.6862p pd=64.265u as=47.6862p ps=64.265u w=62.745u l=1u
X10922 DVDD GATE BAT DVDD pfet_06v0 ad=35.511p pd=48.245u as=35.511p ps=48.245u w=46.725u l=1u
X10923 BAT GATE DVDD DVDD pfet_06v0 ad=35.511p pd=48.245u as=35.511p ps=48.245u w=46.725u l=1u
X10924 BAT GATE DVDD DVDD pfet_06v0 ad=35.511p pd=48.245u as=35.511p ps=48.245u w=46.725u l=1u
X10925 DVDD GATE BAT DVDD pfet_06v0 ad=35.511p pd=48.245u as=35.511p ps=48.245u w=46.725u l=1u
X10926 DVDD GATE BAT DVDD pfet_06v0 ad=35.5072p pd=48.24u as=35.5072p ps=48.24u w=46.72u l=1u
X10927 DVDD GATE BAT DVDD pfet_06v0 ad=35.511p pd=48.245u as=35.511p ps=48.245u w=46.725u l=1u
X10928 DVDD GATE BAT DVDD pfet_06v0 ad=35.511p pd=48.245u as=35.511p ps=48.245u w=46.725u l=1u
X10929 DVDD GATE BAT DVDD pfet_06v0 ad=58.1552p pd=78.04u as=58.1552p ps=78.04u w=76.52u l=1u
X10930 BAT GATE DVDD DVDD pfet_06v0 ad=58.1134p pd=77.985u as=58.1134p ps=77.985u w=76.465u l=1u
X10931 BAT GATE DVDD DVDD pfet_06v0 ad=58.1134p pd=77.985u as=58.1134p ps=77.985u w=76.465u l=1u
X10932 DVDD GATE BAT DVDD pfet_06v0 ad=43.9215p pd=95.32999u as=35.511p ps=48.245u w=46.725u l=1u
X10933 BAT GATE DVDD DVDD pfet_06v0 ad=35.511p pd=48.245u as=43.9215p ps=95.32999u w=46.725u l=1u
X10934 BAT GATE DVDD DVDD pfet_06v0 ad=58.1134p pd=77.985u as=58.1134p ps=77.985u w=76.465u l=1u
X10935 BAT GATE DVDD DVDD pfet_06v0 ad=47.6862p pd=64.265u as=47.6862p ps=64.265u w=62.745u l=1u
X10936 DVDD GATE BAT DVDD pfet_06v0 ad=35.511p pd=48.245u as=35.511p ps=48.245u w=46.725u l=1u
X10937 BAT GATE DVDD DVDD pfet_06v0 ad=58.1096p pd=77.98u as=58.1096p ps=77.98u w=76.46u l=1u
X10938 BAT GATE DVDD DVDD pfet_06v0 ad=35.511p pd=48.245u as=35.511p ps=48.245u w=46.725u l=1u
X10939 DVDD GATE BAT DVDD pfet_06v0 ad=43.9215p pd=95.32999u as=35.511p ps=48.245u w=46.725u l=1u
X10940 DVDD GATE BAT DVDD pfet_06v0 ad=58.1552p pd=78.04u as=58.1552p ps=78.04u w=76.52u l=1u
X10941 DVDD GATE BAT DVDD pfet_06v0 ad=35.511p pd=48.245u as=35.511p ps=48.245u w=46.725u l=1u
X10942 BAT GATE DVDD DVDD pfet_06v0 ad=35.511p pd=48.245u as=43.9215p ps=95.32999u w=46.725u l=1u
X10943 BAT GATE DVDD DVDD pfet_06v0 ad=58.1134p pd=77.985u as=58.1134p ps=77.985u w=76.465u l=1u
X10944 BAT GATE DVDD DVDD pfet_06v0 ad=58.1552p pd=78.04u as=58.1552p ps=78.04u w=76.52u l=1u
X10945 DVDD GATE BAT DVDD pfet_06v0 ad=61.0812p pd=0.13184m as=49.3848p ps=66.5u w=64.98u l=1u
X10946 BAT GATE DVDD DVDD pfet_06v0 ad=58.0754p pd=77.935u as=58.0754p ps=77.935u w=76.41499u l=1u
X10947 DVDD GATE BAT DVDD pfet_06v0 ad=58.1134p pd=77.985u as=58.1134p ps=77.985u w=76.465u l=1u
X10948 DVDD GATE BAT DVDD pfet_06v0 ad=35.511p pd=48.245u as=35.511p ps=48.245u w=46.725u l=1u
X10949 BAT GATE DVDD DVDD pfet_06v0 ad=58.1134p pd=77.985u as=58.1134p ps=77.985u w=76.465u l=1u
X10950 DVDD GATE BAT DVDD pfet_06v0 ad=49.3848p pd=66.5u as=49.3848p ps=66.5u w=64.98u l=1u
X10951 BAT GATE DVDD DVDD pfet_06v0 ad=58.0754p pd=77.935u as=58.0754p ps=77.935u w=76.41499u l=1u
X10952 BAT GATE DVDD DVDD pfet_06v0 ad=47.6862p pd=64.265u as=58.9803p ps=0.12737m w=62.745u l=1u
X10953 BAT GATE DVDD DVDD pfet_06v0 ad=49.3848p pd=66.5u as=49.3848p ps=66.5u w=64.98u l=1u
X10954 DVDD GATE BAT DVDD pfet_06v0 ad=58.1134p pd=77.985u as=58.1134p ps=77.985u w=76.465u l=1u
X10955 BAT GATE DVDD DVDD pfet_06v0 ad=58.0754p pd=77.935u as=58.0754p ps=77.935u w=76.41499u l=1u
X10956 DVDD GATE BAT DVDD pfet_06v0 ad=35.511p pd=48.245u as=35.511p ps=48.245u w=46.725u l=1u
X10957 DVDD GATE BAT DVDD pfet_06v0 ad=58.0754p pd=77.935u as=58.0754p ps=77.935u w=76.41499u l=1u
X10958 DVDD GATE BAT DVDD pfet_06v0 ad=58.1552p pd=78.04u as=58.1552p ps=78.04u w=76.52u l=1u
X10959 BAT GATE DVDD DVDD pfet_06v0 ad=58.1172p pd=77.99u as=71.8818p ps=0.15482m w=76.47u l=1u
X10960 BAT GATE DVDD DVDD pfet_06v0 ad=58.1134p pd=77.985u as=58.1134p ps=77.985u w=76.465u l=1u
X10961 BAT GATE DVDD DVDD pfet_06v0 ad=58.1172p pd=77.99u as=58.1172p ps=77.99u w=76.47u l=1u
X10962 BAT GATE DVDD DVDD pfet_06v0 ad=47.6862p pd=64.265u as=47.6862p ps=64.265u w=62.745u l=1u
X10963 DVDD GATE BAT DVDD pfet_06v0 ad=43.9215p pd=95.32999u as=35.511p ps=48.245u w=46.725u l=1u
X10964 BAT GATE DVDD DVDD pfet_06v0 ad=58.1134p pd=77.985u as=58.1134p ps=77.985u w=76.465u l=1u
X10965 BAT GATE DVDD DVDD pfet_06v0 ad=35.511p pd=48.245u as=35.511p ps=48.245u w=46.725u l=1u
X10966 BAT GATE DVDD DVDD pfet_06v0 ad=58.1172p pd=77.99u as=58.1172p ps=77.99u w=76.47u l=1u
X10967 DVDD GATE BAT DVDD pfet_06v0 ad=49.3848p pd=66.5u as=49.3848p ps=66.5u w=64.98u l=1u
X10968 BAT GATE DVDD DVDD pfet_06v0 ad=58.1096p pd=77.98u as=58.1096p ps=77.98u w=76.46u l=1u
X10969 DVDD GATE BAT DVDD pfet_06v0 ad=58.1172p pd=77.99u as=58.1172p ps=77.99u w=76.47u l=1u
X10970 DVDD GATE BAT DVDD pfet_06v0 ad=58.9803p pd=0.12737m as=47.6862p ps=64.265u w=62.745u l=1u
X10971 DVDD GATE BAT DVDD pfet_06v0 ad=71.8771p pd=0.15481m as=58.1134p ps=77.985u w=76.465u l=1u
X10972 BAT GATE DVDD DVDD pfet_06v0 ad=35.511p pd=48.245u as=35.511p ps=48.245u w=46.725u l=1u
X10973 DVDD GATE BAT DVDD pfet_06v0 ad=35.511p pd=48.245u as=35.511p ps=48.245u w=46.725u l=1u
X10974 DVDD GATE BAT DVDD pfet_06v0 ad=58.1134p pd=77.985u as=58.1134p ps=77.985u w=76.465u l=1u
X10975 DVDD GATE BAT DVDD pfet_06v0 ad=58.1552p pd=78.04u as=58.1552p ps=78.04u w=76.52u l=1u
X10976 DVDD GATE BAT DVDD pfet_06v0 ad=35.5072p pd=48.24u as=35.5072p ps=48.24u w=46.72u l=1u
X10977 DVDD GATE BAT DVDD pfet_06v0 ad=43.9168p pd=95.32u as=35.5072p ps=48.24u w=46.72u l=1u
X10978 BAT GATE DVDD DVDD pfet_06v0 ad=35.511p pd=48.245u as=35.511p ps=48.245u w=46.725u l=1u
X10979 BAT GATE DVDD DVDD pfet_06v0 ad=58.1096p pd=77.98u as=71.8724p ps=0.1548m w=76.46u l=1u
X10980 BAT GATE DVDD DVDD pfet_06v0 ad=58.1134p pd=77.985u as=58.1134p ps=77.985u w=76.465u l=1u
X10981 BAT GATE DVDD DVDD pfet_06v0 ad=58.1134p pd=77.985u as=71.8771p ps=0.15481m w=76.465u l=1u
X10982 BAT GATE DVDD DVDD pfet_06v0 ad=35.511p pd=48.245u as=35.511p ps=48.245u w=46.725u l=1u
X10983 DVDD GATE BAT DVDD pfet_06v0 ad=43.9215p pd=95.32999u as=35.511p ps=48.245u w=46.725u l=1u
X10984 BAT GATE DVDD DVDD pfet_06v0 ad=35.511p pd=48.245u as=35.511p ps=48.245u w=46.725u l=1u
X10985 DVDD GATE BAT DVDD pfet_06v0 ad=35.511p pd=48.245u as=35.511p ps=48.245u w=46.725u l=1u
X10986 BAT GATE DVDD DVDD pfet_06v0 ad=58.1134p pd=77.985u as=71.8771p ps=0.15481m w=76.465u l=1u
X10987 DVDD GATE BAT DVDD pfet_06v0 ad=43.9215p pd=95.32999u as=35.511p ps=48.245u w=46.725u l=1u
X10988 BAT GATE DVDD DVDD pfet_06v0 ad=35.511p pd=48.245u as=35.511p ps=48.245u w=46.725u l=1u
X10989 BAT GATE DVDD DVDD pfet_06v0 ad=58.0754p pd=77.935u as=71.8301p ps=0.15471m w=76.41499u l=1u
X10990 BAT GATE DVDD DVDD pfet_06v0 ad=58.1134p pd=77.985u as=58.1134p ps=77.985u w=76.465u l=1u
X10991 BAT GATE DVDD DVDD pfet_06v0 ad=58.1552p pd=78.04u as=58.1552p ps=78.04u w=76.52u l=1u
X10992 BAT GATE DVDD DVDD pfet_06v0 ad=58.1552p pd=78.04u as=58.1552p ps=78.04u w=76.52u l=1u
X10993 BAT GATE DVDD DVDD pfet_06v0 ad=35.511p pd=48.245u as=35.511p ps=48.245u w=46.725u l=1u
X10994 BAT GATE DVDD DVDD pfet_06v0 ad=35.5072p pd=48.24u as=43.9168p ps=95.32u w=46.72u l=1u
X10995 DVDD GATE BAT DVDD pfet_06v0 ad=35.511p pd=48.245u as=35.511p ps=48.245u w=46.725u l=1u
X10996 BAT GATE DVDD DVDD pfet_06v0 ad=35.511p pd=48.245u as=35.511p ps=48.245u w=46.725u l=1u
X10997 DVDD GATE BAT DVDD pfet_06v0 ad=71.8771p pd=0.15481m as=58.1134p ps=77.985u w=76.465u l=1u
X10998 DVDD GATE BAT DVDD pfet_06v0 ad=58.1134p pd=77.985u as=58.1134p ps=77.985u w=76.465u l=1u
X10999 BAT GATE DVDD DVDD pfet_06v0 ad=35.511p pd=48.245u as=35.511p ps=48.245u w=46.725u l=1u
X11000 DVDD GATE BAT DVDD pfet_06v0 ad=58.1134p pd=77.985u as=58.1134p ps=77.985u w=76.465u l=1u
X11001 DVDD GATE BAT DVDD pfet_06v0 ad=58.1134p pd=77.985u as=58.1134p ps=77.985u w=76.465u l=1u
X11002 DVDD GATE BAT DVDD pfet_06v0 ad=35.511p pd=48.245u as=35.511p ps=48.245u w=46.725u l=1u
X11003 DVDD GATE BAT DVDD pfet_06v0 ad=58.1552p pd=78.04u as=58.1552p ps=78.04u w=76.52u l=1u
X11004 DVDD GATE BAT DVDD pfet_06v0 ad=35.511p pd=48.245u as=35.511p ps=48.245u w=46.725u l=1u
X11005 DVDD GATE BAT DVDD pfet_06v0 ad=35.511p pd=48.245u as=35.511p ps=48.245u w=46.725u l=1u
X11006 BAT GATE DVDD DVDD pfet_06v0 ad=58.1134p pd=77.985u as=71.8771p ps=0.15481m w=76.465u l=1u
X11007 BAT GATE DVDD DVDD pfet_06v0 ad=58.1134p pd=77.985u as=58.1134p ps=77.985u w=76.465u l=1u
X11008 BAT GATE DVDD DVDD pfet_06v0 ad=35.511p pd=48.245u as=35.511p ps=48.245u w=46.725u l=1u
X11009 DVDD GATE BAT DVDD pfet_06v0 ad=58.1134p pd=77.985u as=58.1134p ps=77.985u w=76.465u l=1u
X11010 DVDD GATE BAT DVDD pfet_06v0 ad=35.511p pd=48.245u as=35.511p ps=48.245u w=46.725u l=1u
X11011 BAT GATE DVDD DVDD pfet_06v0 ad=35.511p pd=48.245u as=35.511p ps=48.245u w=46.725u l=1u
X11012 BAT GATE DVDD DVDD pfet_06v0 ad=58.1552p pd=78.04u as=58.1552p ps=78.04u w=76.52u l=1u
X11013 DVDD GATE BAT DVDD pfet_06v0 ad=35.511p pd=48.245u as=35.511p ps=48.245u w=46.725u l=1u
X11014 DVDD GATE BAT DVDD pfet_06v0 ad=58.1134p pd=77.985u as=58.1134p ps=77.985u w=76.465u l=1u
X11015 DVDD GATE BAT DVDD pfet_06v0 ad=35.511p pd=48.245u as=35.511p ps=48.245u w=46.725u l=1u
X11016 DVDD GATE BAT DVDD pfet_06v0 ad=71.8724p pd=0.1548m as=58.1096p ps=77.98u w=76.46u l=1u
X11017 BAT GATE DVDD DVDD pfet_06v0 ad=35.511p pd=48.245u as=43.9215p ps=95.32999u w=46.725u l=1u
X11018 DVDD GATE BAT DVDD pfet_06v0 ad=58.1134p pd=77.985u as=58.1134p ps=77.985u w=76.465u l=1u
X11019 BAT GATE DVDD DVDD pfet_06v0 ad=35.511p pd=48.245u as=43.9215p ps=95.32999u w=46.725u l=1u
X11020 BAT GATE DVDD DVDD pfet_06v0 ad=35.511p pd=48.245u as=35.511p ps=48.245u w=46.725u l=1u
X11021 DVDD GATE BAT DVDD pfet_06v0 ad=58.0754p pd=77.935u as=58.0754p ps=77.935u w=76.41499u l=1u
X11022 DVDD GATE BAT DVDD pfet_06v0 ad=58.1134p pd=77.985u as=58.1134p ps=77.985u w=76.465u l=1u
X11023 DVDD GATE BAT DVDD pfet_06v0 ad=58.1134p pd=77.985u as=58.1134p ps=77.985u w=76.465u l=1u
X11024 BAT GATE DVDD DVDD pfet_06v0 ad=35.511p pd=48.245u as=43.9215p ps=95.32999u w=46.725u l=1u
X11025 DVDD GATE BAT DVDD pfet_06v0 ad=71.8301p pd=0.15471m as=58.0754p ps=77.935u w=76.41499u l=1u
X11026 BAT GATE DVDD DVDD pfet_06v0 ad=35.511p pd=48.245u as=43.9215p ps=95.32999u w=46.725u l=1u
X11027 DVDD GATE BAT DVDD pfet_06v0 ad=47.6862p pd=64.265u as=47.6862p ps=64.265u w=62.745u l=1u
X11028 DVDD GATE BAT DVDD pfet_06v0 ad=43.9215p pd=95.32999u as=35.511p ps=48.245u w=46.725u l=1u
X11029 DVDD GATE BAT DVDD pfet_06v0 ad=35.511p pd=48.245u as=35.511p ps=48.245u w=46.725u l=1u
X11030 DVDD GATE BAT DVDD pfet_06v0 ad=35.511p pd=48.245u as=35.511p ps=48.245u w=46.725u l=1u
X11031 DVDD GATE BAT DVDD pfet_06v0 ad=58.1134p pd=77.985u as=58.1134p ps=77.985u w=76.465u l=1u
X11032 BAT GATE DVDD DVDD pfet_06v0 ad=58.1172p pd=77.99u as=58.1172p ps=77.99u w=76.47u l=1u
X11033 BAT GATE DVDD DVDD pfet_06v0 ad=35.511p pd=48.245u as=35.511p ps=48.245u w=46.725u l=1u
X11034 BAT GATE DVDD DVDD pfet_06v0 ad=35.511p pd=48.245u as=35.511p ps=48.245u w=46.725u l=1u
X11035 DVDD GATE BAT DVDD pfet_06v0 ad=47.6862p pd=64.265u as=47.6862p ps=64.265u w=62.745u l=1u
X11036 DVDD GATE BAT DVDD pfet_06v0 ad=58.1134p pd=77.985u as=58.1134p ps=77.985u w=76.465u l=1u
X11037 DVDD GATE BAT DVDD pfet_06v0 ad=58.1134p pd=77.985u as=58.1134p ps=77.985u w=76.465u l=1u
X11038 BAT GATE DVDD DVDD pfet_06v0 ad=49.3848p pd=66.5u as=49.3848p ps=66.5u w=64.98u l=1u
X11039 DVDD GATE BAT DVDD pfet_06v0 ad=58.1134p pd=77.985u as=58.1134p ps=77.985u w=76.465u l=1u
X11040 DVDD GATE BAT DVDD pfet_06v0 ad=58.1096p pd=77.98u as=58.1096p ps=77.98u w=76.46u l=1u
X11041 BAT GATE DVDD DVDD pfet_06v0 ad=35.511p pd=48.245u as=35.511p ps=48.245u w=46.725u l=1u
X11042 DVDD GATE BAT DVDD pfet_06v0 ad=61.0812p pd=0.13184m as=49.3848p ps=66.5u w=64.98u l=1u
X11043 DVDD GATE BAT DVDD pfet_06v0 ad=35.511p pd=48.245u as=35.511p ps=48.245u w=46.725u l=1u
X11044 BAT GATE DVDD DVDD pfet_06v0 ad=35.5072p pd=48.24u as=35.5072p ps=48.24u w=46.72u l=1u
X11045 DVDD GATE BAT DVDD pfet_06v0 ad=35.511p pd=48.245u as=35.511p ps=48.245u w=46.725u l=1u
X11046 BAT GATE DVDD DVDD pfet_06v0 ad=35.511p pd=48.245u as=35.511p ps=48.245u w=46.725u l=1u
X11047 DVDD GATE BAT DVDD pfet_06v0 ad=43.9215p pd=95.32999u as=35.511p ps=48.245u w=46.725u l=1u
X11048 DVDD GATE BAT DVDD pfet_06v0 ad=58.1134p pd=77.985u as=58.1134p ps=77.985u w=76.465u l=1u
X11049 DVDD GATE BAT DVDD pfet_06v0 ad=58.0754p pd=77.935u as=58.0754p ps=77.935u w=76.41499u l=1u
X11050 DVDD GATE BAT DVDD pfet_06v0 ad=49.3848p pd=66.5u as=49.3848p ps=66.5u w=64.98u l=1u
X11051 BAT GATE DVDD DVDD pfet_06v0 ad=58.1134p pd=77.985u as=58.1134p ps=77.985u w=76.465u l=1u
X11052 BAT GATE DVDD DVDD pfet_06v0 ad=58.1134p pd=77.985u as=58.1134p ps=77.985u w=76.465u l=1u
X11053 DVDD GATE BAT DVDD pfet_06v0 ad=58.0754p pd=77.935u as=58.0754p ps=77.935u w=76.41499u l=1u
X11054 DVDD GATE BAT DVDD pfet_06v0 ad=71.8301p pd=0.15471m as=58.0754p ps=77.935u w=76.41499u l=1u
X11055 BAT GATE DVDD DVDD pfet_06v0 ad=58.1172p pd=77.99u as=71.8818p ps=0.15482m w=76.47u l=1u
X11056 BAT GATE DVDD DVDD pfet_06v0 ad=35.511p pd=48.245u as=35.511p ps=48.245u w=46.725u l=1u
X11057 BAT GATE DVDD DVDD pfet_06v0 ad=58.0754p pd=77.935u as=58.0754p ps=77.935u w=76.41499u l=1u
X11058 DVDD GATE BAT DVDD pfet_06v0 ad=71.8771p pd=0.15481m as=58.1134p ps=77.985u w=76.465u l=1u
X11059 BAT GATE DVDD DVDD pfet_06v0 ad=58.1096p pd=77.98u as=58.1096p ps=77.98u w=76.46u l=1u
X11060 BAT GATE DVDD DVDD pfet_06v0 ad=58.1134p pd=77.985u as=58.1134p ps=77.985u w=76.465u l=1u
X11061 DVDD GATE BAT DVDD pfet_06v0 ad=43.9215p pd=95.32999u as=35.511p ps=48.245u w=46.725u l=1u
X11062 BAT GATE DVDD DVDD pfet_06v0 ad=58.1134p pd=77.985u as=58.1134p ps=77.985u w=76.465u l=1u
X11063 BAT GATE DVDD DVDD pfet_06v0 ad=47.6862p pd=64.265u as=47.6862p ps=64.265u w=62.745u l=1u
X11064 BAT GATE DVDD DVDD pfet_06v0 ad=58.1134p pd=77.985u as=58.1134p ps=77.985u w=76.465u l=1u
X11065 BAT GATE DVDD DVDD pfet_06v0 ad=35.5072p pd=48.24u as=35.5072p ps=48.24u w=46.72u l=1u
X11066 BAT GATE DVDD DVDD pfet_06v0 ad=49.3848p pd=66.5u as=61.0812p ps=0.13184m w=64.98u l=1u
X11067 DVDD GATE BAT DVDD pfet_06v0 ad=58.1172p pd=77.99u as=58.1172p ps=77.99u w=76.47u l=1u
X11068 DVDD GATE BAT DVDD pfet_06v0 ad=58.1134p pd=77.985u as=58.1134p ps=77.985u w=76.465u l=1u
X11069 DVDD GATE BAT DVDD pfet_06v0 ad=58.1134p pd=77.985u as=58.1134p ps=77.985u w=76.465u l=1u
X11070 BAT GATE DVDD DVDD pfet_06v0 ad=35.5072p pd=48.24u as=35.5072p ps=48.24u w=46.72u l=1u
X11071 BAT GATE DVDD DVDD pfet_06v0 ad=35.511p pd=48.245u as=35.511p ps=48.245u w=46.725u l=1u
X11072 DVDD GATE BAT DVDD pfet_06v0 ad=35.511p pd=48.245u as=35.511p ps=48.245u w=46.725u l=1u
X11073 DVDD GATE BAT DVDD pfet_06v0 ad=58.1134p pd=77.985u as=58.1134p ps=77.985u w=76.465u l=1u
X11074 DVDD GATE BAT DVDD pfet_06v0 ad=35.511p pd=48.245u as=35.511p ps=48.245u w=46.725u l=1u
X11075 DVDD GATE BAT DVDD pfet_06v0 ad=58.1134p pd=77.985u as=58.1134p ps=77.985u w=76.465u l=1u
X11076 DVDD GATE BAT DVDD pfet_06v0 ad=35.511p pd=48.245u as=35.511p ps=48.245u w=46.725u l=1u
X11077 BAT GATE DVDD DVDD pfet_06v0 ad=58.1134p pd=77.985u as=58.1134p ps=77.985u w=76.465u l=1u
X11078 DVDD GATE BAT DVDD pfet_06v0 ad=58.0754p pd=77.935u as=58.0754p ps=77.935u w=76.41499u l=1u
X11079 DVDD GATE BAT DVDD pfet_06v0 ad=49.3848p pd=66.5u as=49.3848p ps=66.5u w=64.98u l=1u
X11080 BAT GATE DVDD DVDD pfet_06v0 ad=35.511p pd=48.245u as=43.9215p ps=95.32999u w=46.725u l=1u
X11081 BAT GATE DVDD DVDD pfet_06v0 ad=58.1552p pd=78.04u as=58.1552p ps=78.04u w=76.52u l=1u
X11082 DVDD GATE BAT DVDD pfet_06v0 ad=35.511p pd=48.245u as=35.511p ps=48.245u w=46.725u l=1u
X11083 BAT GATE DVDD DVDD pfet_06v0 ad=58.1134p pd=77.985u as=58.1134p ps=77.985u w=76.465u l=1u
X11084 DVDD GATE BAT DVDD pfet_06v0 ad=71.92879p pd=0.15492m as=58.1552p ps=78.04u w=76.52u l=1u
X11085 BAT GATE DVDD DVDD pfet_06v0 ad=35.511p pd=48.245u as=43.9215p ps=95.32999u w=46.725u l=1u
X11086 DVDD GATE BAT DVDD pfet_06v0 ad=58.1134p pd=77.985u as=58.1134p ps=77.985u w=76.465u l=1u
X11087 DVDD GATE BAT DVDD pfet_06v0 ad=35.511p pd=48.245u as=35.511p ps=48.245u w=46.725u l=1u
X11088 BAT GATE DVDD DVDD pfet_06v0 ad=35.511p pd=48.245u as=35.511p ps=48.245u w=46.725u l=1u
X11089 DVDD GATE BAT DVDD pfet_06v0 ad=58.1134p pd=77.985u as=58.1134p ps=77.985u w=76.465u l=1u
X11090 BAT GATE DVDD DVDD pfet_06v0 ad=35.511p pd=48.245u as=35.511p ps=48.245u w=46.725u l=1u
X11091 BAT GATE DVDD DVDD pfet_06v0 ad=58.1172p pd=77.99u as=58.1172p ps=77.99u w=76.47u l=1u
X11092 BAT GATE DVDD DVDD pfet_06v0 ad=58.1134p pd=77.985u as=58.1134p ps=77.985u w=76.465u l=1u
X11093 BAT GATE DVDD DVDD pfet_06v0 ad=58.1134p pd=77.985u as=58.1134p ps=77.985u w=76.465u l=1u
X11094 DVDD GATE BAT DVDD pfet_06v0 ad=35.511p pd=48.245u as=35.511p ps=48.245u w=46.725u l=1u
X11095 BAT GATE DVDD DVDD pfet_06v0 ad=58.1134p pd=77.985u as=58.1134p ps=77.985u w=76.465u l=1u
X11096 DVDD GATE BAT DVDD pfet_06v0 ad=43.9215p pd=95.32999u as=35.511p ps=48.245u w=46.725u l=1u
X11097 BAT GATE DVDD DVDD pfet_06v0 ad=58.1134p pd=77.985u as=58.1134p ps=77.985u w=76.465u l=1u
X11098 BAT GATE DVDD DVDD pfet_06v0 ad=35.511p pd=48.245u as=35.511p ps=48.245u w=46.725u l=1u
X11099 DVDD GATE BAT DVDD pfet_06v0 ad=49.3848p pd=66.5u as=49.3848p ps=66.5u w=64.98u l=1u
X11100 DVDD GATE BAT DVDD pfet_06v0 ad=35.511p pd=48.245u as=35.511p ps=48.245u w=46.725u l=1u
X11101 DVDD GATE BAT DVDD pfet_06v0 ad=58.1134p pd=77.985u as=58.1134p ps=77.985u w=76.465u l=1u
X11102 BAT GATE DVDD DVDD pfet_06v0 ad=35.511p pd=48.245u as=35.511p ps=48.245u w=46.725u l=1u
X11103 DVDD GATE BAT DVDD pfet_06v0 ad=58.1134p pd=77.985u as=58.1134p ps=77.985u w=76.465u l=1u
X11104 BAT GATE DVDD DVDD pfet_06v0 ad=35.511p pd=48.245u as=43.9215p ps=95.32999u w=46.725u l=1u
X11105 BAT GATE DVDD DVDD pfet_06v0 ad=58.1134p pd=77.985u as=58.1134p ps=77.985u w=76.465u l=1u
X11106 DVDD GATE BAT DVDD pfet_06v0 ad=35.511p pd=48.245u as=35.511p ps=48.245u w=46.725u l=1u
X11107 DVDD GATE BAT DVDD pfet_06v0 ad=58.1134p pd=77.985u as=58.1134p ps=77.985u w=76.465u l=1u
X11108 BAT GATE DVDD DVDD pfet_06v0 ad=35.511p pd=48.245u as=35.511p ps=48.245u w=46.725u l=1u
X11109 BAT GATE DVDD DVDD pfet_06v0 ad=35.511p pd=48.245u as=35.511p ps=48.245u w=46.725u l=1u
X11110 DVDD GATE BAT DVDD pfet_06v0 ad=58.1134p pd=77.985u as=58.1134p ps=77.985u w=76.465u l=1u
X11111 DVDD GATE BAT DVDD pfet_06v0 ad=35.511p pd=48.245u as=35.511p ps=48.245u w=46.725u l=1u
X11112 BAT GATE DVDD DVDD pfet_06v0 ad=58.1134p pd=77.985u as=71.8771p ps=0.15481m w=76.465u l=1u
X11113 BAT GATE DVDD DVDD pfet_06v0 ad=58.0754p pd=77.935u as=58.0754p ps=77.935u w=76.41499u l=1u
X11114 BAT GATE DVDD DVDD pfet_06v0 ad=58.1134p pd=77.985u as=58.1134p ps=77.985u w=76.465u l=1u
X11115 BAT GATE DVDD DVDD pfet_06v0 ad=58.1552p pd=78.04u as=58.1552p ps=78.04u w=76.52u l=1u
X11116 BAT GATE DVDD DVDD pfet_06v0 ad=35.511p pd=48.245u as=35.511p ps=48.245u w=46.725u l=1u
X11117 BAT GATE DVDD DVDD pfet_06v0 ad=58.1134p pd=77.985u as=58.1134p ps=77.985u w=76.465u l=1u
X11118 DVDD GATE BAT DVDD pfet_06v0 ad=58.1134p pd=77.985u as=58.1134p ps=77.985u w=76.465u l=1u
X11119 DVDD GATE BAT DVDD pfet_06v0 ad=71.8771p pd=0.15481m as=58.1134p ps=77.985u w=76.465u l=1u
X11120 BAT GATE DVDD DVDD pfet_06v0 ad=58.1134p pd=77.985u as=58.1134p ps=77.985u w=76.465u l=1u
X11121 BAT GATE DVDD DVDD pfet_06v0 ad=58.1134p pd=77.985u as=58.1134p ps=77.985u w=76.465u l=1u
X11122 DVDD GATE BAT DVDD pfet_06v0 ad=71.8724p pd=0.1548m as=58.1096p ps=77.98u w=76.46u l=1u
X11123 BAT GATE DVDD DVDD pfet_06v0 ad=35.511p pd=48.245u as=35.511p ps=48.245u w=46.725u l=1u
X11124 BAT GATE DVDD DVDD pfet_06v0 ad=47.6862p pd=64.265u as=47.6862p ps=64.265u w=62.745u l=1u
X11125 BAT GATE DVDD DVDD pfet_06v0 ad=58.1134p pd=77.985u as=58.1134p ps=77.985u w=76.465u l=1u
X11126 DVDD GATE BAT DVDD pfet_06v0 ad=58.1134p pd=77.985u as=58.1134p ps=77.985u w=76.465u l=1u
X11127 DVDD GATE BAT DVDD pfet_06v0 ad=49.3848p pd=66.5u as=49.3848p ps=66.5u w=64.98u l=1u
X11128 BAT GATE DVDD DVDD pfet_06v0 ad=58.1172p pd=77.99u as=58.1172p ps=77.99u w=76.47u l=1u
X11129 DVDD GATE BAT DVDD pfet_06v0 ad=58.1134p pd=77.985u as=58.1134p ps=77.985u w=76.465u l=1u
X11130 DVDD GATE BAT DVDD pfet_06v0 ad=35.511p pd=48.245u as=35.511p ps=48.245u w=46.725u l=1u
X11131 DVDD GATE BAT DVDD pfet_06v0 ad=43.9168p pd=95.32u as=35.5072p ps=48.24u w=46.72u l=1u
X11132 DVDD GATE BAT DVDD pfet_06v0 ad=58.1134p pd=77.985u as=58.1134p ps=77.985u w=76.465u l=1u
X11133 DVDD GATE BAT DVDD pfet_06v0 ad=58.0754p pd=77.935u as=58.0754p ps=77.935u w=76.41499u l=1u
X11134 BAT GATE DVDD DVDD pfet_06v0 ad=49.3848p pd=66.5u as=49.3848p ps=66.5u w=64.98u l=1u
X11135 DVDD GATE BAT DVDD pfet_06v0 ad=71.8301p pd=0.15471m as=58.0754p ps=77.935u w=76.41499u l=1u
X11136 BAT GATE DVDD DVDD pfet_06v0 ad=35.511p pd=48.245u as=35.511p ps=48.245u w=46.725u l=1u
X11137 DVDD GATE BAT DVDD pfet_06v0 ad=43.9215p pd=95.32999u as=35.511p ps=48.245u w=46.725u l=1u
X11138 BAT GATE DVDD DVDD pfet_06v0 ad=35.511p pd=48.245u as=35.511p ps=48.245u w=46.725u l=1u
X11139 DVDD GATE BAT DVDD pfet_06v0 ad=58.1134p pd=77.985u as=58.1134p ps=77.985u w=76.465u l=1u
X11140 BAT GATE DVDD DVDD pfet_06v0 ad=35.511p pd=48.245u as=35.511p ps=48.245u w=46.725u l=1u
X11141 DVDD GATE BAT DVDD pfet_06v0 ad=58.1134p pd=77.985u as=58.1134p ps=77.985u w=76.465u l=1u
X11142 BAT GATE DVDD DVDD pfet_06v0 ad=58.1096p pd=77.98u as=58.1096p ps=77.98u w=76.46u l=1u
X11143 BAT GATE DVDD DVDD pfet_06v0 ad=58.0754p pd=77.935u as=58.0754p ps=77.935u w=76.41499u l=1u
X11144 DVDD GATE BAT DVDD pfet_06v0 ad=35.511p pd=48.245u as=35.511p ps=48.245u w=46.725u l=1u
X11145 DVDD GATE BAT DVDD pfet_06v0 ad=43.9215p pd=95.32999u as=35.511p ps=48.245u w=46.725u l=1u
X11146 DVDD GATE BAT DVDD pfet_06v0 ad=47.6862p pd=64.265u as=47.6862p ps=64.265u w=62.745u l=1u
X11147 DVDD GATE BAT DVDD pfet_06v0 ad=43.9215p pd=95.32999u as=35.511p ps=48.245u w=46.725u l=1u
X11148 DVDD GATE BAT DVDD pfet_06v0 ad=35.511p pd=48.245u as=35.511p ps=48.245u w=46.725u l=1u
X11149 BAT GATE DVDD DVDD pfet_06v0 ad=35.5072p pd=48.24u as=35.5072p ps=48.24u w=46.72u l=1u
X11150 DVDD GATE BAT DVDD pfet_06v0 ad=58.1134p pd=77.985u as=58.1134p ps=77.985u w=76.465u l=1u
X11151 BAT GATE DVDD DVDD pfet_06v0 ad=35.511p pd=48.245u as=35.511p ps=48.245u w=46.725u l=1u
X11152 DVDD GATE BAT DVDD pfet_06v0 ad=58.1134p pd=77.985u as=58.1134p ps=77.985u w=76.465u l=1u
X11153 DVDD GATE BAT DVDD pfet_06v0 ad=58.1096p pd=77.98u as=58.1096p ps=77.98u w=76.46u l=1u
X11154 DVDD GATE BAT DVDD pfet_06v0 ad=43.9215p pd=95.32999u as=35.511p ps=48.245u w=46.725u l=1u
X11155 DVDD GATE BAT DVDD pfet_06v0 ad=71.8724p pd=0.1548m as=58.1096p ps=77.98u w=76.46u l=1u
X11156 DVDD GATE BAT DVDD pfet_06v0 ad=58.0754p pd=77.935u as=58.0754p ps=77.935u w=76.41499u l=1u
X11157 DVDD GATE BAT DVDD pfet_06v0 ad=58.1134p pd=77.985u as=58.1134p ps=77.985u w=76.465u l=1u
X11158 BAT GATE DVDD DVDD pfet_06v0 ad=35.511p pd=48.245u as=35.511p ps=48.245u w=46.725u l=1u
X11159 DVDD GATE BAT DVDD pfet_06v0 ad=71.8771p pd=0.15481m as=58.1134p ps=77.985u w=76.465u l=1u
X11160 DVDD GATE BAT DVDD pfet_06v0 ad=35.5072p pd=48.24u as=35.5072p ps=48.24u w=46.72u l=1u
X11161 DVDD GATE BAT DVDD pfet_06v0 ad=58.1552p pd=78.04u as=58.1552p ps=78.04u w=76.52u l=1u
X11162 DVDD GATE BAT DVDD pfet_06v0 ad=43.9215p pd=95.32999u as=35.511p ps=48.245u w=46.725u l=1u
X11163 BAT GATE DVDD DVDD pfet_06v0 ad=35.511p pd=48.245u as=35.511p ps=48.245u w=46.725u l=1u
X11164 DVDD GATE BAT DVDD pfet_06v0 ad=35.511p pd=48.245u as=35.511p ps=48.245u w=46.725u l=1u
X11165 DVDD GATE BAT DVDD pfet_06v0 ad=35.5072p pd=48.24u as=35.5072p ps=48.24u w=46.72u l=1u
X11166 BAT GATE DVDD DVDD pfet_06v0 ad=49.3848p pd=66.5u as=49.3848p ps=66.5u w=64.98u l=1u
X11167 BAT GATE DVDD DVDD pfet_06v0 ad=35.511p pd=48.245u as=35.511p ps=48.245u w=46.725u l=1u
X11168 BAT GATE DVDD DVDD pfet_06v0 ad=35.511p pd=48.245u as=35.511p ps=48.245u w=46.725u l=1u
X11169 DVDD GATE BAT DVDD pfet_06v0 ad=58.1134p pd=77.985u as=58.1134p ps=77.985u w=76.465u l=1u
X11170 DVDD GATE BAT DVDD pfet_06v0 ad=58.1134p pd=77.985u as=58.1134p ps=77.985u w=76.465u l=1u
X11171 DVDD GATE BAT DVDD pfet_06v0 ad=58.1134p pd=77.985u as=58.1134p ps=77.985u w=76.465u l=1u
X11172 DVDD GATE BAT DVDD pfet_06v0 ad=58.1134p pd=77.985u as=58.1134p ps=77.985u w=76.465u l=1u
X11173 BAT GATE DVDD DVDD pfet_06v0 ad=58.0754p pd=77.935u as=58.0754p ps=77.935u w=76.41499u l=1u
X11174 DVDD GATE BAT DVDD pfet_06v0 ad=35.511p pd=48.245u as=35.511p ps=48.245u w=46.725u l=1u
X11175 BAT GATE DVDD DVDD pfet_06v0 ad=58.1134p pd=77.985u as=71.8771p ps=0.15481m w=76.465u l=1u
X11176 BAT GATE DVDD DVDD pfet_06v0 ad=58.1172p pd=77.99u as=71.8818p ps=0.15482m w=76.47u l=1u
X11177 BAT GATE DVDD DVDD pfet_06v0 ad=58.1552p pd=78.04u as=58.1552p ps=78.04u w=76.52u l=1u
X11178 BAT GATE DVDD DVDD pfet_06v0 ad=35.511p pd=48.245u as=43.9215p ps=95.32999u w=46.725u l=1u
X11179 DVDD GATE BAT DVDD pfet_06v0 ad=58.1134p pd=77.985u as=58.1134p ps=77.985u w=76.465u l=1u
X11180 BAT GATE DVDD DVDD pfet_06v0 ad=35.511p pd=48.245u as=35.511p ps=48.245u w=46.725u l=1u
X11181 DVDD GATE BAT DVDD pfet_06v0 ad=58.1134p pd=77.985u as=58.1134p ps=77.985u w=76.465u l=1u
X11182 BAT GATE DVDD DVDD pfet_06v0 ad=58.1134p pd=77.985u as=58.1134p ps=77.985u w=76.465u l=1u
X11183 DVDD GATE BAT DVDD pfet_06v0 ad=35.511p pd=48.245u as=35.511p ps=48.245u w=46.725u l=1u
X11184 DVDD GATE BAT DVDD pfet_06v0 ad=58.1134p pd=77.985u as=58.1134p ps=77.985u w=76.465u l=1u
X11185 DVDD GATE BAT DVDD pfet_06v0 ad=43.9215p pd=95.32999u as=35.511p ps=48.245u w=46.725u l=1u
X11186 DVDD GATE BAT DVDD pfet_06v0 ad=58.1134p pd=77.985u as=58.1134p ps=77.985u w=76.465u l=1u
X11187 DVDD GATE BAT DVDD pfet_06v0 ad=35.511p pd=48.245u as=35.511p ps=48.245u w=46.725u l=1u
X11188 DVDD GATE BAT DVDD pfet_06v0 ad=35.511p pd=48.245u as=35.511p ps=48.245u w=46.725u l=1u
X11189 DVDD GATE BAT DVDD pfet_06v0 ad=58.1096p pd=77.98u as=58.1096p ps=77.98u w=76.46u l=1u
X11190 BAT GATE DVDD DVDD pfet_06v0 ad=49.3848p pd=66.5u as=61.0812p ps=0.13184m w=64.98u l=1u
X11191 BAT GATE DVDD DVDD pfet_06v0 ad=58.1134p pd=77.985u as=71.8771p ps=0.15481m w=76.465u l=1u
X11192 BAT GATE DVDD DVDD pfet_06v0 ad=35.511p pd=48.245u as=35.511p ps=48.245u w=46.725u l=1u
X11193 BAT GATE DVDD DVDD pfet_06v0 ad=58.1134p pd=77.985u as=71.8771p ps=0.15481m w=76.465u l=1u
X11194 BAT GATE DVDD DVDD pfet_06v0 ad=35.511p pd=48.245u as=35.511p ps=48.245u w=46.725u l=1u
X11195 DVDD GATE BAT DVDD pfet_06v0 ad=58.1552p pd=78.04u as=58.1552p ps=78.04u w=76.52u l=1u
X11196 DVDD GATE BAT DVDD pfet_06v0 ad=35.511p pd=48.245u as=35.511p ps=48.245u w=46.725u l=1u
X11197 BAT GATE DVDD DVDD pfet_06v0 ad=35.511p pd=48.245u as=35.511p ps=48.245u w=46.725u l=1u
X11198 BAT GATE DVDD DVDD pfet_06v0 ad=58.1134p pd=77.985u as=58.1134p ps=77.985u w=76.465u l=1u
X11199 BAT GATE DVDD DVDD pfet_06v0 ad=35.511p pd=48.245u as=43.9215p ps=95.32999u w=46.725u l=1u
X11200 DVDD GATE BAT DVDD pfet_06v0 ad=49.3848p pd=66.5u as=49.3848p ps=66.5u w=64.98u l=1u
X11201 DVDD GATE BAT DVDD pfet_06v0 ad=35.511p pd=48.245u as=35.511p ps=48.245u w=46.725u l=1u
X11202 DVDD GATE BAT DVDD pfet_06v0 ad=58.1134p pd=77.985u as=58.1134p ps=77.985u w=76.465u l=1u
X11203 DVDD GATE BAT DVDD pfet_06v0 ad=35.511p pd=48.245u as=35.511p ps=48.245u w=46.725u l=1u
X11204 DVDD GATE BAT DVDD pfet_06v0 ad=35.511p pd=48.245u as=35.511p ps=48.245u w=46.725u l=1u
X11205 BAT GATE DVDD DVDD pfet_06v0 ad=58.1134p pd=77.985u as=58.1134p ps=77.985u w=76.465u l=1u
X11206 BAT GATE DVDD DVDD pfet_06v0 ad=35.511p pd=48.245u as=35.511p ps=48.245u w=46.725u l=1u
X11207 BAT GATE DVDD DVDD pfet_06v0 ad=35.511p pd=48.245u as=35.511p ps=48.245u w=46.725u l=1u
X11208 DVDD GATE BAT DVDD pfet_06v0 ad=49.3848p pd=66.5u as=49.3848p ps=66.5u w=64.98u l=1u
X11209 BAT GATE DVDD DVDD pfet_06v0 ad=35.511p pd=48.245u as=35.511p ps=48.245u w=46.725u l=1u
X11210 DVDD GATE BAT DVDD pfet_06v0 ad=58.1172p pd=77.99u as=58.1172p ps=77.99u w=76.47u l=1u
X11211 DVDD GATE BAT DVDD pfet_06v0 ad=35.511p pd=48.245u as=35.511p ps=48.245u w=46.725u l=1u
X11212 BAT GATE DVDD DVDD pfet_06v0 ad=35.511p pd=48.245u as=35.511p ps=48.245u w=46.725u l=1u
X11213 BAT GATE DVDD DVDD pfet_06v0 ad=58.1134p pd=77.985u as=58.1134p ps=77.985u w=76.465u l=1u
X11214 DVDD GATE BAT DVDD pfet_06v0 ad=43.9215p pd=95.32999u as=35.511p ps=48.245u w=46.725u l=1u
X11215 BAT GATE DVDD DVDD pfet_06v0 ad=58.1134p pd=77.985u as=71.8771p ps=0.15481m w=76.465u l=1u
X11216 DVDD GATE BAT DVDD pfet_06v0 ad=35.511p pd=48.245u as=35.511p ps=48.245u w=46.725u l=1u
X11217 DVDD GATE BAT DVDD pfet_06v0 ad=35.511p pd=48.245u as=35.511p ps=48.245u w=46.725u l=1u
X11218 DVDD GATE BAT DVDD pfet_06v0 ad=58.1134p pd=77.985u as=58.1134p ps=77.985u w=76.465u l=1u
X11219 BAT GATE DVDD DVDD pfet_06v0 ad=49.3848p pd=66.5u as=49.3848p ps=66.5u w=64.98u l=1u
X11220 DVDD GATE BAT DVDD pfet_06v0 ad=58.1134p pd=77.985u as=58.1134p ps=77.985u w=76.465u l=1u
X11221 BAT GATE DVDD DVDD pfet_06v0 ad=35.511p pd=48.245u as=35.511p ps=48.245u w=46.725u l=1u
X11222 DVDD GATE BAT DVDD pfet_06v0 ad=58.1134p pd=77.985u as=58.1134p ps=77.985u w=76.465u l=1u
X11223 DVDD GATE BAT DVDD pfet_06v0 ad=58.1096p pd=77.98u as=58.1096p ps=77.98u w=76.46u l=1u
X11224 BAT GATE DVDD DVDD pfet_06v0 ad=58.1096p pd=77.98u as=58.1096p ps=77.98u w=76.46u l=1u
X11225 BAT GATE DVDD DVDD pfet_06v0 ad=58.0754p pd=77.935u as=58.0754p ps=77.935u w=76.41499u l=1u
X11226 BAT GATE DVDD DVDD pfet_06v0 ad=49.3848p pd=66.5u as=61.0812p ps=0.13184m w=64.98u l=1u
X11227 BAT GATE DVDD DVDD pfet_06v0 ad=58.1134p pd=77.985u as=58.1134p ps=77.985u w=76.465u l=1u
X11228 BAT GATE DVDD DVDD pfet_06v0 ad=58.1096p pd=77.98u as=58.1096p ps=77.98u w=76.46u l=1u
X11229 DVDD GATE BAT DVDD pfet_06v0 ad=43.9215p pd=95.32999u as=35.511p ps=48.245u w=46.725u l=1u
X11230 BAT GATE DVDD DVDD pfet_06v0 ad=35.511p pd=48.245u as=35.511p ps=48.245u w=46.725u l=1u
X11231 BAT GATE DVDD DVDD pfet_06v0 ad=47.6862p pd=64.265u as=47.6862p ps=64.265u w=62.745u l=1u
X11232 BAT GATE DVDD DVDD pfet_06v0 ad=35.511p pd=48.245u as=35.511p ps=48.245u w=46.725u l=1u
X11233 BAT GATE DVDD DVDD pfet_06v0 ad=58.0754p pd=77.935u as=58.0754p ps=77.935u w=76.41499u l=1u
X11234 DVDD GATE BAT DVDD pfet_06v0 ad=35.511p pd=48.245u as=35.511p ps=48.245u w=46.725u l=1u
X11235 BAT GATE DVDD DVDD pfet_06v0 ad=58.0754p pd=77.935u as=58.0754p ps=77.935u w=76.41499u l=1u
X11236 DVDD GATE BAT DVDD pfet_06v0 ad=35.5072p pd=48.24u as=35.5072p ps=48.24u w=46.72u l=1u
X11237 DVDD GATE BAT DVDD pfet_06v0 ad=35.511p pd=48.245u as=35.511p ps=48.245u w=46.725u l=1u
X11238 DVDD GATE BAT DVDD pfet_06v0 ad=58.1552p pd=78.04u as=58.1552p ps=78.04u w=76.52u l=1u
X11239 BAT GATE DVDD DVDD pfet_06v0 ad=35.5072p pd=48.24u as=35.5072p ps=48.24u w=46.72u l=1u
X11240 DVDD GATE BAT DVDD pfet_06v0 ad=35.511p pd=48.245u as=35.511p ps=48.245u w=46.725u l=1u
X11241 BAT GATE DVDD DVDD pfet_06v0 ad=58.1134p pd=77.985u as=71.8771p ps=0.15481m w=76.465u l=1u
X11242 BAT GATE DVDD DVDD pfet_06v0 ad=58.1134p pd=77.985u as=58.1134p ps=77.985u w=76.465u l=1u
X11243 DVDD GATE BAT DVDD pfet_06v0 ad=49.3848p pd=66.5u as=49.3848p ps=66.5u w=64.98u l=1u
X11244 DVDD GATE BAT DVDD pfet_06v0 ad=58.1172p pd=77.99u as=58.1172p ps=77.99u w=76.47u l=1u
X11245 BAT GATE DVDD DVDD pfet_06v0 ad=35.511p pd=48.245u as=35.511p ps=48.245u w=46.725u l=1u
X11246 DVDD GATE BAT DVDD pfet_06v0 ad=43.9215p pd=95.32999u as=35.511p ps=48.245u w=46.725u l=1u
X11247 DVDD GATE BAT DVDD pfet_06v0 ad=71.8301p pd=0.15471m as=58.0754p ps=77.935u w=76.41499u l=1u
X11248 BAT GATE DVDD DVDD pfet_06v0 ad=35.511p pd=48.245u as=35.511p ps=48.245u w=46.725u l=1u
X11249 DVDD GATE BAT DVDD pfet_06v0 ad=35.511p pd=48.245u as=35.511p ps=48.245u w=46.725u l=1u
X11250 BAT GATE DVDD DVDD pfet_06v0 ad=35.511p pd=48.245u as=35.511p ps=48.245u w=46.725u l=1u
X11251 BAT GATE DVDD DVDD pfet_06v0 ad=47.6862p pd=64.265u as=47.6862p ps=64.265u w=62.745u l=1u
X11252 BAT GATE DVDD DVDD pfet_06v0 ad=58.1096p pd=77.98u as=58.1096p ps=77.98u w=76.46u l=1u
X11253 DVDD GATE BAT DVDD pfet_06v0 ad=35.511p pd=48.245u as=35.511p ps=48.245u w=46.725u l=1u
X11254 DVDD GATE BAT DVDD pfet_06v0 ad=35.511p pd=48.245u as=35.511p ps=48.245u w=46.725u l=1u
X11255 BAT GATE DVDD DVDD pfet_06v0 ad=58.1172p pd=77.99u as=58.1172p ps=77.99u w=76.47u l=1u
X11256 BAT GATE DVDD DVDD pfet_06v0 ad=58.1134p pd=77.985u as=58.1134p ps=77.985u w=76.465u l=1u
X11257 DVDD GATE BAT DVDD pfet_06v0 ad=49.3848p pd=66.5u as=49.3848p ps=66.5u w=64.98u l=1u
X11258 BAT GATE DVDD DVDD pfet_06v0 ad=35.5072p pd=48.24u as=43.9168p ps=95.32u w=46.72u l=1u
X11259 BAT GATE DVDD DVDD pfet_06v0 ad=58.1134p pd=77.985u as=58.1134p ps=77.985u w=76.465u l=1u
X11260 BAT GATE DVDD DVDD pfet_06v0 ad=58.1134p pd=77.985u as=71.8771p ps=0.15481m w=76.465u l=1u
X11261 DVDD GATE BAT DVDD pfet_06v0 ad=71.8771p pd=0.15481m as=58.1134p ps=77.985u w=76.465u l=1u
X11262 BAT GATE DVDD DVDD pfet_06v0 ad=58.0754p pd=77.935u as=71.8301p ps=0.15471m w=76.41499u l=1u
X11263 BAT GATE DVDD DVDD pfet_06v0 ad=35.511p pd=48.245u as=35.511p ps=48.245u w=46.725u l=1u
X11264 BAT GATE DVDD DVDD pfet_06v0 ad=58.1134p pd=77.985u as=58.1134p ps=77.985u w=76.465u l=1u
X11265 BAT GATE DVDD DVDD pfet_06v0 ad=49.3848p pd=66.5u as=49.3848p ps=66.5u w=64.98u l=1u
X11266 DVDD GATE BAT DVDD pfet_06v0 ad=35.511p pd=48.245u as=35.511p ps=48.245u w=46.725u l=1u
X11267 DVDD GATE BAT DVDD pfet_06v0 ad=49.3848p pd=66.5u as=49.3848p ps=66.5u w=64.98u l=1u
X11268 DVDD GATE BAT DVDD pfet_06v0 ad=35.511p pd=48.245u as=35.511p ps=48.245u w=46.725u l=1u
X11269 BAT GATE DVDD DVDD pfet_06v0 ad=58.0754p pd=77.935u as=58.0754p ps=77.935u w=76.41499u l=1u
X11270 BAT GATE DVDD DVDD pfet_06v0 ad=35.511p pd=48.245u as=35.511p ps=48.245u w=46.725u l=1u
X11271 BAT GATE DVDD DVDD pfet_06v0 ad=58.1552p pd=78.04u as=58.1552p ps=78.04u w=76.52u l=1u
X11272 BAT GATE DVDD DVDD pfet_06v0 ad=58.0754p pd=77.935u as=58.0754p ps=77.935u w=76.41499u l=1u
X11273 BAT GATE DVDD DVDD pfet_06v0 ad=58.1134p pd=77.985u as=58.1134p ps=77.985u w=76.465u l=1u
X11274 DVDD GATE BAT DVDD pfet_06v0 ad=35.511p pd=48.245u as=35.511p ps=48.245u w=46.725u l=1u
X11275 DVDD GATE BAT DVDD pfet_06v0 ad=58.0754p pd=77.935u as=58.0754p ps=77.935u w=76.41499u l=1u
X11276 DVDD GATE BAT DVDD pfet_06v0 ad=58.1552p pd=78.04u as=58.1552p ps=78.04u w=76.52u l=1u
X11277 BAT GATE DVDD DVDD pfet_06v0 ad=58.1134p pd=77.985u as=58.1134p ps=77.985u w=76.465u l=1u
X11278 BAT GATE DVDD DVDD pfet_06v0 ad=58.1134p pd=77.985u as=71.8771p ps=0.15481m w=76.465u l=1u
X11279 BAT GATE DVDD DVDD pfet_06v0 ad=47.6862p pd=64.265u as=58.9803p ps=0.12737m w=62.745u l=1u
X11280 BAT GATE DVDD DVDD pfet_06v0 ad=35.511p pd=48.245u as=35.511p ps=48.245u w=46.725u l=1u
X11281 DVDD GATE BAT DVDD pfet_06v0 ad=35.511p pd=48.245u as=35.511p ps=48.245u w=46.725u l=1u
X11282 BAT GATE DVDD DVDD pfet_06v0 ad=58.1134p pd=77.985u as=58.1134p ps=77.985u w=76.465u l=1u
X11283 BAT GATE DVDD DVDD pfet_06v0 ad=35.511p pd=48.245u as=35.511p ps=48.245u w=46.725u l=1u
X11284 DVDD GATE BAT DVDD pfet_06v0 ad=43.9215p pd=95.32999u as=35.511p ps=48.245u w=46.725u l=1u
X11285 DVDD GATE BAT DVDD pfet_06v0 ad=43.9215p pd=95.32999u as=35.511p ps=48.245u w=46.725u l=1u
X11286 BAT GATE DVDD DVDD pfet_06v0 ad=58.1134p pd=77.985u as=58.1134p ps=77.985u w=76.465u l=1u
X11287 BAT GATE DVDD DVDD pfet_06v0 ad=58.1172p pd=77.99u as=58.1172p ps=77.99u w=76.47u l=1u
X11288 DVDD GATE BAT DVDD pfet_06v0 ad=71.8771p pd=0.15481m as=58.1134p ps=77.985u w=76.465u l=1u
X11289 DVDD GATE BAT DVDD pfet_06v0 ad=47.6862p pd=64.265u as=47.6862p ps=64.265u w=62.745u l=1u
X11290 DVDD GATE BAT DVDD pfet_06v0 ad=58.1134p pd=77.985u as=58.1134p ps=77.985u w=76.465u l=1u
X11291 BAT GATE DVDD DVDD pfet_06v0 ad=35.511p pd=48.245u as=35.511p ps=48.245u w=46.725u l=1u
X11292 DVDD GATE BAT DVDD pfet_06v0 ad=58.1134p pd=77.985u as=58.1134p ps=77.985u w=76.465u l=1u
X11293 DVDD GATE BAT DVDD pfet_06v0 ad=58.1552p pd=78.04u as=58.1552p ps=78.04u w=76.52u l=1u
X11294 DVDD GATE BAT DVDD pfet_06v0 ad=58.1134p pd=77.985u as=58.1134p ps=77.985u w=76.465u l=1u
X11295 DVDD GATE BAT DVDD pfet_06v0 ad=43.9215p pd=95.32999u as=35.511p ps=48.245u w=46.725u l=1u
X11296 DVDD GATE BAT DVDD pfet_06v0 ad=35.5072p pd=48.24u as=35.5072p ps=48.24u w=46.72u l=1u
X11297 BAT GATE DVDD DVDD pfet_06v0 ad=35.511p pd=48.245u as=43.9215p ps=95.32999u w=46.725u l=1u
X11298 BAT GATE DVDD DVDD pfet_06v0 ad=58.1134p pd=77.985u as=58.1134p ps=77.985u w=76.465u l=1u
X11299 BAT GATE DVDD DVDD pfet_06v0 ad=58.1134p pd=77.985u as=58.1134p ps=77.985u w=76.465u l=1u
X11300 DVDD GATE BAT DVDD pfet_06v0 ad=43.9215p pd=95.32999u as=35.511p ps=48.245u w=46.725u l=1u
X11301 BAT GATE DVDD DVDD pfet_06v0 ad=35.511p pd=48.245u as=35.511p ps=48.245u w=46.725u l=1u
X11302 DVDD GATE BAT DVDD pfet_06v0 ad=71.8771p pd=0.15481m as=58.1134p ps=77.985u w=76.465u l=1u
X11303 BAT GATE DVDD DVDD pfet_06v0 ad=35.511p pd=48.245u as=35.511p ps=48.245u w=46.725u l=1u
X11304 DVDD GATE BAT DVDD pfet_06v0 ad=49.3848p pd=66.5u as=49.3848p ps=66.5u w=64.98u l=1u
X11305 BAT GATE DVDD DVDD pfet_06v0 ad=58.0754p pd=77.935u as=58.0754p ps=77.935u w=76.41499u l=1u
X11306 DVDD GATE BAT DVDD pfet_06v0 ad=35.511p pd=48.245u as=35.511p ps=48.245u w=46.725u l=1u
X11307 BAT GATE DVDD DVDD pfet_06v0 ad=35.511p pd=48.245u as=35.511p ps=48.245u w=46.725u l=1u
X11308 BAT GATE DVDD DVDD pfet_06v0 ad=35.511p pd=48.245u as=35.511p ps=48.245u w=46.725u l=1u
X11309 DVDD GATE BAT DVDD pfet_06v0 ad=58.9803p pd=0.12737m as=47.6862p ps=64.265u w=62.745u l=1u
X11310 DVDD GATE BAT DVDD pfet_06v0 ad=35.511p pd=48.245u as=35.511p ps=48.245u w=46.725u l=1u
X11311 BAT GATE DVDD DVDD pfet_06v0 ad=58.1134p pd=77.985u as=58.1134p ps=77.985u w=76.465u l=1u
X11312 BAT GATE DVDD DVDD pfet_06v0 ad=35.511p pd=48.245u as=35.511p ps=48.245u w=46.725u l=1u
X11313 DVDD GATE BAT DVDD pfet_06v0 ad=58.1134p pd=77.985u as=58.1134p ps=77.985u w=76.465u l=1u
X11314 BAT GATE DVDD DVDD pfet_06v0 ad=35.511p pd=48.245u as=43.9215p ps=95.32999u w=46.725u l=1u
X11315 DVDD GATE BAT DVDD pfet_06v0 ad=35.511p pd=48.245u as=35.511p ps=48.245u w=46.725u l=1u
X11316 BAT GATE DVDD DVDD pfet_06v0 ad=35.511p pd=48.245u as=35.511p ps=48.245u w=46.725u l=1u
X11317 BAT GATE DVDD DVDD pfet_06v0 ad=35.511p pd=48.245u as=35.511p ps=48.245u w=46.725u l=1u
X11318 DVDD GATE BAT DVDD pfet_06v0 ad=58.1134p pd=77.985u as=58.1134p ps=77.985u w=76.465u l=1u
X11319 DVDD GATE BAT DVDD pfet_06v0 ad=58.1552p pd=78.04u as=58.1552p ps=78.04u w=76.52u l=1u
X11320 DVDD GATE BAT DVDD pfet_06v0 ad=35.511p pd=48.245u as=35.511p ps=48.245u w=46.725u l=1u
X11321 DVDD GATE BAT DVDD pfet_06v0 ad=35.511p pd=48.245u as=35.511p ps=48.245u w=46.725u l=1u
X11322 DVDD GATE BAT DVDD pfet_06v0 ad=35.511p pd=48.245u as=35.511p ps=48.245u w=46.725u l=1u
X11323 BAT GATE DVDD DVDD pfet_06v0 ad=35.511p pd=48.245u as=35.511p ps=48.245u w=46.725u l=1u
X11324 BAT GATE DVDD DVDD pfet_06v0 ad=58.1134p pd=77.985u as=58.1134p ps=77.985u w=76.465u l=1u
X11325 BAT GATE DVDD DVDD pfet_06v0 ad=35.511p pd=48.245u as=43.9215p ps=95.32999u w=46.725u l=1u
X11326 DVDD GATE BAT DVDD pfet_06v0 ad=47.6862p pd=64.265u as=47.6862p ps=64.265u w=62.745u l=1u
X11327 DVDD GATE BAT DVDD pfet_06v0 ad=58.1134p pd=77.985u as=58.1134p ps=77.985u w=76.465u l=1u
X11328 DVDD GATE BAT DVDD pfet_06v0 ad=35.511p pd=48.245u as=35.511p ps=48.245u w=46.725u l=1u
X11329 BAT GATE DVDD DVDD pfet_06v0 ad=35.511p pd=48.245u as=35.511p ps=48.245u w=46.725u l=1u
X11330 BAT GATE DVDD DVDD pfet_06v0 ad=35.511p pd=48.245u as=35.511p ps=48.245u w=46.725u l=1u
X11331 BAT GATE DVDD DVDD pfet_06v0 ad=58.1552p pd=78.04u as=58.1552p ps=78.04u w=76.52u l=1u
X11332 DVDD GATE BAT DVDD pfet_06v0 ad=49.3848p pd=66.5u as=49.3848p ps=66.5u w=64.98u l=1u
X11333 DVDD GATE BAT DVDD pfet_06v0 ad=35.511p pd=48.245u as=35.511p ps=48.245u w=46.725u l=1u
X11334 DVDD GATE BAT DVDD pfet_06v0 ad=35.511p pd=48.245u as=35.511p ps=48.245u w=46.725u l=1u
X11335 BAT GATE DVDD DVDD pfet_06v0 ad=58.1134p pd=77.985u as=58.1134p ps=77.985u w=76.465u l=1u
X11336 BAT GATE DVDD DVDD pfet_06v0 ad=35.511p pd=48.245u as=43.9215p ps=95.32999u w=46.725u l=1u
X11337 DVDD GATE BAT DVDD pfet_06v0 ad=58.0754p pd=77.935u as=58.0754p ps=77.935u w=76.41499u l=1u
X11338 DVDD GATE BAT DVDD pfet_06v0 ad=35.511p pd=48.245u as=35.511p ps=48.245u w=46.725u l=1u
X11339 DVDD GATE BAT DVDD pfet_06v0 ad=58.1134p pd=77.985u as=58.1134p ps=77.985u w=76.465u l=1u
X11340 DVDD GATE BAT DVDD pfet_06v0 ad=35.511p pd=48.245u as=35.511p ps=48.245u w=46.725u l=1u
X11341 DVDD GATE BAT DVDD pfet_06v0 ad=58.0754p pd=77.935u as=58.0754p ps=77.935u w=76.41499u l=1u
X11342 DVDD GATE BAT DVDD pfet_06v0 ad=47.6862p pd=64.265u as=47.6862p ps=64.265u w=62.745u l=1u
X11343 DVDD GATE BAT DVDD pfet_06v0 ad=61.0812p pd=0.13184m as=49.3848p ps=66.5u w=64.98u l=1u
X11344 BAT GATE DVDD DVDD pfet_06v0 ad=58.1134p pd=77.985u as=58.1134p ps=77.985u w=76.465u l=1u
X11345 DVDD GATE BAT DVDD pfet_06v0 ad=58.1134p pd=77.985u as=58.1134p ps=77.985u w=76.465u l=1u
X11346 BAT GATE DVDD DVDD pfet_06v0 ad=35.511p pd=48.245u as=35.511p ps=48.245u w=46.725u l=1u
X11347 BAT GATE DVDD DVDD pfet_06v0 ad=58.1096p pd=77.98u as=58.1096p ps=77.98u w=76.46u l=1u
X11348 BAT GATE DVDD DVDD pfet_06v0 ad=35.511p pd=48.245u as=43.9215p ps=95.32999u w=46.725u l=1u
X11349 DVDD GATE BAT DVDD pfet_06v0 ad=58.1134p pd=77.985u as=58.1134p ps=77.985u w=76.465u l=1u
X11350 DVDD GATE BAT DVDD pfet_06v0 ad=47.6862p pd=64.265u as=47.6862p ps=64.265u w=62.745u l=1u
X11351 DVDD GATE BAT DVDD pfet_06v0 ad=58.1134p pd=77.985u as=58.1134p ps=77.985u w=76.465u l=1u
X11352 BAT GATE DVDD DVDD pfet_06v0 ad=58.1134p pd=77.985u as=58.1134p ps=77.985u w=76.465u l=1u
X11353 DVDD GATE BAT DVDD pfet_06v0 ad=35.511p pd=48.245u as=35.511p ps=48.245u w=46.725u l=1u
X11354 DVDD GATE BAT DVDD pfet_06v0 ad=58.1134p pd=77.985u as=58.1134p ps=77.985u w=76.465u l=1u
X11355 BAT GATE DVDD DVDD pfet_06v0 ad=49.3848p pd=66.5u as=61.0812p ps=0.13184m w=64.98u l=1u
X11356 DVDD GATE BAT DVDD pfet_06v0 ad=58.1134p pd=77.985u as=58.1134p ps=77.985u w=76.465u l=1u
X11357 BAT GATE DVDD DVDD pfet_06v0 ad=49.3848p pd=66.5u as=49.3848p ps=66.5u w=64.98u l=1u
X11358 BAT GATE DVDD DVDD pfet_06v0 ad=58.1134p pd=77.985u as=71.8771p ps=0.15481m w=76.465u l=1u
X11359 DVDD GATE BAT DVDD pfet_06v0 ad=58.1096p pd=77.98u as=58.1096p ps=77.98u w=76.46u l=1u
X11360 BAT GATE DVDD DVDD pfet_06v0 ad=58.1172p pd=77.99u as=58.1172p ps=77.99u w=76.47u l=1u
X11361 BAT GATE DVDD DVDD pfet_06v0 ad=35.5072p pd=48.24u as=35.5072p ps=48.24u w=46.72u l=1u
X11362 BAT GATE DVDD DVDD pfet_06v0 ad=35.5072p pd=48.24u as=35.5072p ps=48.24u w=46.72u l=1u
X11363 DVDD GATE BAT DVDD pfet_06v0 ad=58.1096p pd=77.98u as=58.1096p ps=77.98u w=76.46u l=1u
X11364 DVDD GATE BAT DVDD pfet_06v0 ad=58.1096p pd=77.98u as=58.1096p ps=77.98u w=76.46u l=1u
X11365 DVDD GATE BAT DVDD pfet_06v0 ad=35.511p pd=48.245u as=35.511p ps=48.245u w=46.725u l=1u
X11366 BAT GATE DVDD DVDD pfet_06v0 ad=35.511p pd=48.245u as=43.9215p ps=95.32999u w=46.725u l=1u
X11367 DVDD GATE BAT DVDD pfet_06v0 ad=58.1134p pd=77.985u as=58.1134p ps=77.985u w=76.465u l=1u
X11368 DVDD GATE BAT DVDD pfet_06v0 ad=58.1134p pd=77.985u as=58.1134p ps=77.985u w=76.465u l=1u
X11369 DVDD GATE BAT DVDD pfet_06v0 ad=43.9215p pd=95.32999u as=35.511p ps=48.245u w=46.725u l=1u
X11370 BAT GATE DVDD DVDD pfet_06v0 ad=35.511p pd=48.245u as=35.511p ps=48.245u w=46.725u l=1u
X11371 DVDD GATE BAT DVDD pfet_06v0 ad=61.0812p pd=0.13184m as=49.3848p ps=66.5u w=64.98u l=1u
X11372 DVDD GATE BAT DVDD pfet_06v0 ad=43.9215p pd=95.32999u as=35.511p ps=48.245u w=46.725u l=1u
X11373 DVDD GATE BAT DVDD pfet_06v0 ad=58.1552p pd=78.04u as=58.1552p ps=78.04u w=76.52u l=1u
X11374 DVDD GATE BAT DVDD pfet_06v0 ad=58.0754p pd=77.935u as=58.0754p ps=77.935u w=76.41499u l=1u
X11375 DVDD GATE BAT DVDD pfet_06v0 ad=35.5072p pd=48.24u as=35.5072p ps=48.24u w=46.72u l=1u
X11376 BAT GATE DVDD DVDD pfet_06v0 ad=35.511p pd=48.245u as=35.511p ps=48.245u w=46.725u l=1u
X11377 DVDD GATE BAT DVDD pfet_06v0 ad=58.1134p pd=77.985u as=58.1134p ps=77.985u w=76.465u l=1u
X11378 BAT GATE DVDD DVDD pfet_06v0 ad=58.1134p pd=77.985u as=58.1134p ps=77.985u w=76.465u l=1u
X11379 DVDD GATE BAT DVDD pfet_06v0 ad=35.511p pd=48.245u as=35.511p ps=48.245u w=46.725u l=1u
X11380 BAT GATE DVDD DVDD pfet_06v0 ad=58.1134p pd=77.985u as=58.1134p ps=77.985u w=76.465u l=1u
X11381 BAT GATE DVDD DVDD pfet_06v0 ad=35.511p pd=48.245u as=35.511p ps=48.245u w=46.725u l=1u
X11382 DVDD GATE BAT DVDD pfet_06v0 ad=58.1134p pd=77.985u as=58.1134p ps=77.985u w=76.465u l=1u
X11383 BAT GATE DVDD DVDD pfet_06v0 ad=35.511p pd=48.245u as=35.511p ps=48.245u w=46.725u l=1u
X11384 BAT GATE DVDD DVDD pfet_06v0 ad=58.1552p pd=78.04u as=58.1552p ps=78.04u w=76.52u l=1u
X11385 BAT GATE DVDD DVDD pfet_06v0 ad=58.1134p pd=77.985u as=58.1134p ps=77.985u w=76.465u l=1u
X11386 BAT GATE DVDD DVDD pfet_06v0 ad=35.511p pd=48.245u as=35.511p ps=48.245u w=46.725u l=1u
X11387 DVDD GATE BAT DVDD pfet_06v0 ad=58.1134p pd=77.985u as=58.1134p ps=77.985u w=76.465u l=1u
X11388 DVDD GATE BAT DVDD pfet_06v0 ad=71.8771p pd=0.15481m as=58.1134p ps=77.985u w=76.465u l=1u
X11389 BAT GATE DVDD DVDD pfet_06v0 ad=58.1134p pd=77.985u as=58.1134p ps=77.985u w=76.465u l=1u
X11390 BAT GATE DVDD DVDD pfet_06v0 ad=35.511p pd=48.245u as=35.511p ps=48.245u w=46.725u l=1u
X11391 DVDD GATE BAT DVDD pfet_06v0 ad=35.511p pd=48.245u as=35.511p ps=48.245u w=46.725u l=1u
X11392 BAT GATE DVDD DVDD pfet_06v0 ad=35.511p pd=48.245u as=35.511p ps=48.245u w=46.725u l=1u
X11393 DVDD GATE BAT DVDD pfet_06v0 ad=35.511p pd=48.245u as=35.511p ps=48.245u w=46.725u l=1u
X11394 BAT GATE DVDD DVDD pfet_06v0 ad=35.511p pd=48.245u as=35.511p ps=48.245u w=46.725u l=1u
X11395 DVDD GATE BAT DVDD pfet_06v0 ad=35.511p pd=48.245u as=35.511p ps=48.245u w=46.725u l=1u
X11396 DVDD GATE BAT DVDD pfet_06v0 ad=35.511p pd=48.245u as=35.511p ps=48.245u w=46.725u l=1u
X11397 BAT GATE DVDD DVDD pfet_06v0 ad=58.1134p pd=77.985u as=58.1134p ps=77.985u w=76.465u l=1u
X11398 BAT GATE DVDD DVDD pfet_06v0 ad=58.1134p pd=77.985u as=58.1134p ps=77.985u w=76.465u l=1u
X11399 DVDD GATE BAT DVDD pfet_06v0 ad=35.511p pd=48.245u as=35.511p ps=48.245u w=46.725u l=1u
X11400 DVDD GATE BAT DVDD pfet_06v0 ad=35.511p pd=48.245u as=35.511p ps=48.245u w=46.725u l=1u
X11401 BAT GATE DVDD DVDD pfet_06v0 ad=58.1134p pd=77.985u as=58.1134p ps=77.985u w=76.465u l=1u
X11402 DVDD GATE BAT DVDD pfet_06v0 ad=58.1552p pd=78.04u as=58.1552p ps=78.04u w=76.52u l=1u
X11403 BAT GATE DVDD DVDD pfet_06v0 ad=47.6862p pd=64.265u as=47.6862p ps=64.265u w=62.745u l=1u
X11404 DVDD GATE BAT DVDD pfet_06v0 ad=58.1134p pd=77.985u as=58.1134p ps=77.985u w=76.465u l=1u
X11405 BAT GATE DVDD DVDD pfet_06v0 ad=35.511p pd=48.245u as=35.511p ps=48.245u w=46.725u l=1u
X11406 DVDD GATE BAT DVDD pfet_06v0 ad=35.511p pd=48.245u as=35.511p ps=48.245u w=46.725u l=1u
X11407 BAT GATE DVDD DVDD pfet_06v0 ad=35.511p pd=48.245u as=35.511p ps=48.245u w=46.725u l=1u
X11408 BAT GATE DVDD DVDD pfet_06v0 ad=58.1552p pd=78.04u as=71.92879p ps=0.15492m w=76.52u l=1u
X11409 BAT GATE DVDD DVDD pfet_06v0 ad=58.1134p pd=77.985u as=58.1134p ps=77.985u w=76.465u l=1u
X11410 BAT GATE DVDD DVDD pfet_06v0 ad=58.1134p pd=77.985u as=71.8771p ps=0.15481m w=76.465u l=1u
X11411 BAT GATE DVDD DVDD pfet_06v0 ad=58.1172p pd=77.99u as=58.1172p ps=77.99u w=76.47u l=1u
X11412 DVDD GATE BAT DVDD pfet_06v0 ad=35.511p pd=48.245u as=35.511p ps=48.245u w=46.725u l=1u
X11413 BAT GATE DVDD DVDD pfet_06v0 ad=58.1134p pd=77.985u as=58.1134p ps=77.985u w=76.465u l=1u
X11414 BAT GATE DVDD DVDD pfet_06v0 ad=35.511p pd=48.245u as=43.9215p ps=95.32999u w=46.725u l=1u
X11415 DVDD GATE BAT DVDD pfet_06v0 ad=35.511p pd=48.245u as=35.511p ps=48.245u w=46.725u l=1u
X11416 BAT GATE DVDD DVDD pfet_06v0 ad=58.1134p pd=77.985u as=58.1134p ps=77.985u w=76.465u l=1u
X11417 BAT GATE DVDD DVDD pfet_06v0 ad=58.1134p pd=77.985u as=58.1134p ps=77.985u w=76.465u l=1u
X11418 BAT GATE DVDD DVDD pfet_06v0 ad=35.511p pd=48.245u as=35.511p ps=48.245u w=46.725u l=1u
X11419 DVDD GATE BAT DVDD pfet_06v0 ad=58.1134p pd=77.985u as=58.1134p ps=77.985u w=76.465u l=1u
X11420 DVDD GATE BAT DVDD pfet_06v0 ad=35.511p pd=48.245u as=35.511p ps=48.245u w=46.725u l=1u
X11421 BAT GATE DVDD DVDD pfet_06v0 ad=58.1134p pd=77.985u as=71.8771p ps=0.15481m w=76.465u l=1u
X11422 DVDD GATE BAT DVDD pfet_06v0 ad=35.511p pd=48.245u as=35.511p ps=48.245u w=46.725u l=1u
X11423 DVDD GATE BAT DVDD pfet_06v0 ad=43.9215p pd=95.32999u as=35.511p ps=48.245u w=46.725u l=1u
X11424 DVDD GATE BAT DVDD pfet_06v0 ad=58.1134p pd=77.985u as=58.1134p ps=77.985u w=76.465u l=1u
X11425 BAT GATE DVDD DVDD pfet_06v0 ad=35.511p pd=48.245u as=35.511p ps=48.245u w=46.725u l=1u
X11426 BAT GATE DVDD DVDD pfet_06v0 ad=35.511p pd=48.245u as=35.511p ps=48.245u w=46.725u l=1u
X11427 DVDD GATE BAT DVDD pfet_06v0 ad=58.1134p pd=77.985u as=58.1134p ps=77.985u w=76.465u l=1u
X11428 DVDD GATE BAT DVDD pfet_06v0 ad=35.511p pd=48.245u as=35.511p ps=48.245u w=46.725u l=1u
X11429 BAT GATE DVDD DVDD pfet_06v0 ad=35.511p pd=48.245u as=43.9215p ps=95.32999u w=46.725u l=1u
X11430 BAT GATE DVDD DVDD pfet_06v0 ad=49.3848p pd=66.5u as=49.3848p ps=66.5u w=64.98u l=1u
X11431 BAT GATE DVDD DVDD pfet_06v0 ad=58.0754p pd=77.935u as=58.0754p ps=77.935u w=76.41499u l=1u
X11432 DVDD GATE BAT DVDD pfet_06v0 ad=35.511p pd=48.245u as=35.511p ps=48.245u w=46.725u l=1u
X11433 BAT GATE DVDD DVDD pfet_06v0 ad=58.1134p pd=77.985u as=58.1134p ps=77.985u w=76.465u l=1u
X11434 BAT GATE DVDD DVDD pfet_06v0 ad=58.1552p pd=78.04u as=58.1552p ps=78.04u w=76.52u l=1u
X11435 DVDD GATE BAT DVDD pfet_06v0 ad=71.8771p pd=0.15481m as=58.1134p ps=77.985u w=76.465u l=1u
X11436 DVDD GATE BAT DVDD pfet_06v0 ad=71.8771p pd=0.15481m as=58.1134p ps=77.985u w=76.465u l=1u
X11437 BAT GATE DVDD DVDD pfet_06v0 ad=58.1134p pd=77.985u as=58.1134p ps=77.985u w=76.465u l=1u
X11438 DVDD GATE BAT DVDD pfet_06v0 ad=58.1134p pd=77.985u as=58.1134p ps=77.985u w=76.465u l=1u
X11439 DVDD GATE BAT DVDD pfet_06v0 ad=35.511p pd=48.245u as=35.511p ps=48.245u w=46.725u l=1u
X11440 BAT GATE DVDD DVDD pfet_06v0 ad=58.1134p pd=77.985u as=58.1134p ps=77.985u w=76.465u l=1u
X11441 DVDD GATE BAT DVDD pfet_06v0 ad=58.1096p pd=77.98u as=58.1096p ps=77.98u w=76.46u l=1u
X11442 BAT GATE DVDD DVDD pfet_06v0 ad=35.511p pd=48.245u as=35.511p ps=48.245u w=46.725u l=1u
X11443 DVDD GATE BAT DVDD pfet_06v0 ad=35.5072p pd=48.24u as=35.5072p ps=48.24u w=46.72u l=1u
X11444 DVDD GATE BAT DVDD pfet_06v0 ad=58.1134p pd=77.985u as=58.1134p ps=77.985u w=76.465u l=1u
X11445 BAT GATE DVDD DVDD pfet_06v0 ad=58.1134p pd=77.985u as=71.8771p ps=0.15481m w=76.465u l=1u
X11446 DVDD GATE BAT DVDD pfet_06v0 ad=58.9803p pd=0.12737m as=47.6862p ps=64.265u w=62.745u l=1u
X11447 BAT GATE DVDD DVDD pfet_06v0 ad=35.511p pd=48.245u as=35.511p ps=48.245u w=46.725u l=1u
X11448 DVDD GATE BAT DVDD pfet_06v0 ad=58.1134p pd=77.985u as=58.1134p ps=77.985u w=76.465u l=1u
X11449 DVDD GATE BAT DVDD pfet_06v0 ad=58.1134p pd=77.985u as=58.1134p ps=77.985u w=76.465u l=1u
X11450 BAT GATE DVDD DVDD pfet_06v0 ad=58.1096p pd=77.98u as=71.8724p ps=0.1548m w=76.46u l=1u
X11451 BAT GATE DVDD DVDD pfet_06v0 ad=35.511p pd=48.245u as=35.511p ps=48.245u w=46.725u l=1u
X11452 BAT GATE DVDD DVDD pfet_06v0 ad=58.1134p pd=77.985u as=58.1134p ps=77.985u w=76.465u l=1u
X11453 BAT GATE DVDD DVDD pfet_06v0 ad=47.6862p pd=64.265u as=47.6862p ps=64.265u w=62.745u l=1u
X11454 DVDD GATE BAT DVDD pfet_06v0 ad=35.511p pd=48.245u as=35.511p ps=48.245u w=46.725u l=1u
X11455 DVDD GATE BAT DVDD pfet_06v0 ad=35.5072p pd=48.24u as=35.5072p ps=48.24u w=46.72u l=1u
X11456 DVDD GATE BAT DVDD pfet_06v0 ad=58.0754p pd=77.935u as=58.0754p ps=77.935u w=76.41499u l=1u
X11457 DVDD GATE BAT DVDD pfet_06v0 ad=43.9215p pd=95.32999u as=35.511p ps=48.245u w=46.725u l=1u
X11458 DVDD GATE BAT DVDD pfet_06v0 ad=58.0754p pd=77.935u as=58.0754p ps=77.935u w=76.41499u l=1u
X11459 DVDD GATE BAT DVDD pfet_06v0 ad=35.511p pd=48.245u as=35.511p ps=48.245u w=46.725u l=1u
X11460 BAT GATE DVDD DVDD pfet_06v0 ad=35.511p pd=48.245u as=35.511p ps=48.245u w=46.725u l=1u
X11461 BAT GATE DVDD DVDD pfet_06v0 ad=35.511p pd=48.245u as=43.9215p ps=95.32999u w=46.725u l=1u
X11462 BAT GATE DVDD DVDD pfet_06v0 ad=35.511p pd=48.245u as=43.9215p ps=95.32999u w=46.725u l=1u
X11463 DVDD GATE BAT DVDD pfet_06v0 ad=43.9215p pd=95.32999u as=35.511p ps=48.245u w=46.725u l=1u
X11464 BAT GATE DVDD DVDD pfet_06v0 ad=58.1172p pd=77.99u as=71.8818p ps=0.15482m w=76.47u l=1u
X11465 BAT GATE DVDD DVDD pfet_06v0 ad=49.3848p pd=66.5u as=49.3848p ps=66.5u w=64.98u l=1u
X11466 DVDD GATE BAT DVDD pfet_06v0 ad=35.511p pd=48.245u as=35.511p ps=48.245u w=46.725u l=1u
X11467 BAT GATE DVDD DVDD pfet_06v0 ad=35.511p pd=48.245u as=35.511p ps=48.245u w=46.725u l=1u
X11468 BAT GATE DVDD DVDD pfet_06v0 ad=58.0754p pd=77.935u as=58.0754p ps=77.935u w=76.41499u l=1u
X11469 DVDD GATE BAT DVDD pfet_06v0 ad=71.8771p pd=0.15481m as=58.1134p ps=77.985u w=76.465u l=1u
X11470 BAT GATE DVDD DVDD pfet_06v0 ad=58.0754p pd=77.935u as=58.0754p ps=77.935u w=76.41499u l=1u
X11471 BAT GATE DVDD DVDD pfet_06v0 ad=35.511p pd=48.245u as=35.511p ps=48.245u w=46.725u l=1u
X11472 DVDD GATE BAT DVDD pfet_06v0 ad=47.6862p pd=64.265u as=47.6862p ps=64.265u w=62.745u l=1u
X11473 BAT GATE DVDD DVDD pfet_06v0 ad=58.1134p pd=77.985u as=58.1134p ps=77.985u w=76.465u l=1u
X11474 DVDD GATE BAT DVDD pfet_06v0 ad=35.511p pd=48.245u as=35.511p ps=48.245u w=46.725u l=1u
X11475 DVDD GATE BAT DVDD pfet_06v0 ad=35.511p pd=48.245u as=35.511p ps=48.245u w=46.725u l=1u
X11476 BAT GATE DVDD DVDD pfet_06v0 ad=58.1134p pd=77.985u as=71.8771p ps=0.15481m w=76.465u l=1u
X11477 DVDD GATE BAT DVDD pfet_06v0 ad=35.511p pd=48.245u as=35.511p ps=48.245u w=46.725u l=1u
X11478 DVDD GATE BAT DVDD pfet_06v0 ad=35.511p pd=48.245u as=35.511p ps=48.245u w=46.725u l=1u
X11479 BAT GATE DVDD DVDD pfet_06v0 ad=35.511p pd=48.245u as=43.9215p ps=95.32999u w=46.725u l=1u
X11480 DVDD GATE BAT DVDD pfet_06v0 ad=58.1134p pd=77.985u as=58.1134p ps=77.985u w=76.465u l=1u
X11481 DVDD GATE BAT DVDD pfet_06v0 ad=58.1172p pd=77.99u as=58.1172p ps=77.99u w=76.47u l=1u
X11482 BAT GATE DVDD DVDD pfet_06v0 ad=35.511p pd=48.245u as=35.511p ps=48.245u w=46.725u l=1u
X11483 DVDD GATE BAT DVDD pfet_06v0 ad=58.1134p pd=77.985u as=58.1134p ps=77.985u w=76.465u l=1u
X11484 DVDD GATE BAT DVDD pfet_06v0 ad=35.511p pd=48.245u as=35.511p ps=48.245u w=46.725u l=1u
X11485 DVDD GATE BAT DVDD pfet_06v0 ad=58.1096p pd=77.98u as=58.1096p ps=77.98u w=76.46u l=1u
X11486 BAT GATE DVDD DVDD pfet_06v0 ad=58.1134p pd=77.985u as=58.1134p ps=77.985u w=76.465u l=1u
X11487 BAT GATE DVDD DVDD pfet_06v0 ad=35.511p pd=48.245u as=35.511p ps=48.245u w=46.725u l=1u
X11488 BAT GATE DVDD DVDD pfet_06v0 ad=49.3848p pd=66.5u as=49.3848p ps=66.5u w=64.98u l=1u
X11489 BAT GATE DVDD DVDD pfet_06v0 ad=58.1134p pd=77.985u as=58.1134p ps=77.985u w=76.465u l=1u
X11490 BAT GATE DVDD DVDD pfet_06v0 ad=58.1134p pd=77.985u as=71.8771p ps=0.15481m w=76.465u l=1u
X11491 BAT GATE DVDD DVDD pfet_06v0 ad=58.1172p pd=77.99u as=58.1172p ps=77.99u w=76.47u l=1u
X11492 BAT GATE DVDD DVDD pfet_06v0 ad=58.1134p pd=77.985u as=58.1134p ps=77.985u w=76.465u l=1u
X11493 DVDD GATE BAT DVDD pfet_06v0 ad=35.511p pd=48.245u as=35.511p ps=48.245u w=46.725u l=1u
X11494 BAT GATE DVDD DVDD pfet_06v0 ad=58.1134p pd=77.985u as=58.1134p ps=77.985u w=76.465u l=1u
X11495 DVDD GATE BAT DVDD pfet_06v0 ad=35.511p pd=48.245u as=35.511p ps=48.245u w=46.725u l=1u
X11496 BAT GATE DVDD DVDD pfet_06v0 ad=35.511p pd=48.245u as=43.9215p ps=95.32999u w=46.725u l=1u
X11497 DVDD GATE BAT DVDD pfet_06v0 ad=35.511p pd=48.245u as=35.511p ps=48.245u w=46.725u l=1u
X11498 DVDD GATE BAT DVDD pfet_06v0 ad=35.5072p pd=48.24u as=35.5072p ps=48.24u w=46.72u l=1u
X11499 BAT GATE DVDD DVDD pfet_06v0 ad=35.511p pd=48.245u as=35.511p ps=48.245u w=46.725u l=1u
X11500 BAT GATE DVDD DVDD pfet_06v0 ad=49.3848p pd=66.5u as=49.3848p ps=66.5u w=64.98u l=1u
X11501 BAT GATE DVDD DVDD pfet_06v0 ad=35.511p pd=48.245u as=43.9215p ps=95.32999u w=46.725u l=1u
X11502 BAT GATE DVDD DVDD pfet_06v0 ad=58.1552p pd=78.04u as=58.1552p ps=78.04u w=76.52u l=1u
X11503 BAT GATE DVDD DVDD pfet_06v0 ad=58.1134p pd=77.985u as=58.1134p ps=77.985u w=76.465u l=1u
X11504 DVDD GATE BAT DVDD pfet_06v0 ad=43.9215p pd=95.32999u as=35.511p ps=48.245u w=46.725u l=1u
X11505 DVDD GATE BAT DVDD pfet_06v0 ad=35.511p pd=48.245u as=35.511p ps=48.245u w=46.725u l=1u
X11506 BAT GATE DVDD DVDD pfet_06v0 ad=35.511p pd=48.245u as=35.511p ps=48.245u w=46.725u l=1u
X11507 DVDD GATE BAT DVDD pfet_06v0 ad=35.511p pd=48.245u as=35.511p ps=48.245u w=46.725u l=1u
X11508 BAT GATE DVDD DVDD pfet_06v0 ad=35.511p pd=48.245u as=35.511p ps=48.245u w=46.725u l=1u
X11509 DVDD GATE BAT DVDD pfet_06v0 ad=58.1134p pd=77.985u as=58.1134p ps=77.985u w=76.465u l=1u
X11510 DVDD GATE BAT DVDD pfet_06v0 ad=35.511p pd=48.245u as=35.511p ps=48.245u w=46.725u l=1u
X11511 BAT GATE DVDD DVDD pfet_06v0 ad=58.0754p pd=77.935u as=58.0754p ps=77.935u w=76.41499u l=1u
X11512 DVDD GATE BAT DVDD pfet_06v0 ad=71.8771p pd=0.15481m as=58.1134p ps=77.985u w=76.465u l=1u
X11513 DVDD GATE BAT DVDD pfet_06v0 ad=35.511p pd=48.245u as=35.511p ps=48.245u w=46.725u l=1u
X11514 BAT GATE DVDD DVDD pfet_06v0 ad=47.6862p pd=64.265u as=47.6862p ps=64.265u w=62.745u l=1u
X11515 BAT GATE DVDD DVDD pfet_06v0 ad=58.1552p pd=78.04u as=71.92879p ps=0.15492m w=76.52u l=1u
X11516 DVDD GATE BAT DVDD pfet_06v0 ad=58.1134p pd=77.985u as=58.1134p ps=77.985u w=76.465u l=1u
X11517 BAT GATE DVDD DVDD pfet_06v0 ad=58.1134p pd=77.985u as=58.1134p ps=77.985u w=76.465u l=1u
X11518 DVDD GATE BAT DVDD pfet_06v0 ad=58.1134p pd=77.985u as=58.1134p ps=77.985u w=76.465u l=1u
X11519 DVDD GATE BAT DVDD pfet_06v0 ad=58.1134p pd=77.985u as=58.1134p ps=77.985u w=76.465u l=1u
X11520 BAT GATE DVDD DVDD pfet_06v0 ad=35.511p pd=48.245u as=35.511p ps=48.245u w=46.725u l=1u
X11521 DVDD GATE BAT DVDD pfet_06v0 ad=58.9803p pd=0.12737m as=47.6862p ps=64.265u w=62.745u l=1u
X11522 DVDD GATE BAT DVDD pfet_06v0 ad=58.1134p pd=77.985u as=58.1134p ps=77.985u w=76.465u l=1u
X11523 DVDD GATE BAT DVDD pfet_06v0 ad=43.9215p pd=95.32999u as=35.511p ps=48.245u w=46.725u l=1u
X11524 DVDD GATE BAT DVDD pfet_06v0 ad=58.1134p pd=77.985u as=58.1134p ps=77.985u w=76.465u l=1u
X11525 DVDD GATE BAT DVDD pfet_06v0 ad=35.511p pd=48.245u as=35.511p ps=48.245u w=46.725u l=1u
X11526 BAT GATE DVDD DVDD pfet_06v0 ad=49.3848p pd=66.5u as=49.3848p ps=66.5u w=64.98u l=1u
X11527 DVDD GATE BAT DVDD pfet_06v0 ad=58.1096p pd=77.98u as=58.1096p ps=77.98u w=76.46u l=1u
X11528 BAT GATE DVDD DVDD pfet_06v0 ad=35.511p pd=48.245u as=35.511p ps=48.245u w=46.725u l=1u
X11529 BAT GATE DVDD DVDD pfet_06v0 ad=35.511p pd=48.245u as=35.511p ps=48.245u w=46.725u l=1u
X11530 BAT GATE DVDD DVDD pfet_06v0 ad=58.1134p pd=77.985u as=58.1134p ps=77.985u w=76.465u l=1u
X11531 BAT GATE DVDD DVDD pfet_06v0 ad=58.1552p pd=78.04u as=71.92879p ps=0.15492m w=76.52u l=1u
X11532 DVDD GATE BAT DVDD pfet_06v0 ad=58.1552p pd=78.04u as=58.1552p ps=78.04u w=76.52u l=1u
X11533 BAT GATE DVDD DVDD pfet_06v0 ad=58.0754p pd=77.935u as=58.0754p ps=77.935u w=76.41499u l=1u
X11534 BAT GATE DVDD DVDD pfet_06v0 ad=58.1134p pd=77.985u as=58.1134p ps=77.985u w=76.465u l=1u
X11535 DVDD GATE BAT DVDD pfet_06v0 ad=49.3848p pd=66.5u as=49.3848p ps=66.5u w=64.98u l=1u
X11536 DVDD GATE BAT DVDD pfet_06v0 ad=35.511p pd=48.245u as=35.511p ps=48.245u w=46.725u l=1u
X11537 DVDD GATE BAT DVDD pfet_06v0 ad=35.511p pd=48.245u as=35.511p ps=48.245u w=46.725u l=1u
X11538 BAT GATE DVDD DVDD pfet_06v0 ad=58.1134p pd=77.985u as=71.8771p ps=0.15481m w=76.465u l=1u
X11539 BAT GATE DVDD DVDD pfet_06v0 ad=58.1134p pd=77.985u as=58.1134p ps=77.985u w=76.465u l=1u
X11540 DVDD GATE BAT DVDD pfet_06v0 ad=71.8301p pd=0.15471m as=58.0754p ps=77.935u w=76.41499u l=1u
X11541 BAT GATE DVDD DVDD pfet_06v0 ad=35.511p pd=48.245u as=35.511p ps=48.245u w=46.725u l=1u
X11542 DVDD GATE BAT DVDD pfet_06v0 ad=49.3848p pd=66.5u as=49.3848p ps=66.5u w=64.98u l=1u
X11543 BAT GATE DVDD DVDD pfet_06v0 ad=35.511p pd=48.245u as=35.511p ps=48.245u w=46.725u l=1u
X11544 DVDD GATE BAT DVDD pfet_06v0 ad=35.511p pd=48.245u as=35.511p ps=48.245u w=46.725u l=1u
X11545 BAT GATE DVDD DVDD pfet_06v0 ad=35.511p pd=48.245u as=35.511p ps=48.245u w=46.725u l=1u
X11546 BAT GATE DVDD DVDD pfet_06v0 ad=58.1134p pd=77.985u as=58.1134p ps=77.985u w=76.465u l=1u
X11547 BAT GATE DVDD DVDD pfet_06v0 ad=47.6862p pd=64.265u as=47.6862p ps=64.265u w=62.745u l=1u
X11548 BAT GATE DVDD DVDD pfet_06v0 ad=58.1134p pd=77.985u as=58.1134p ps=77.985u w=76.465u l=1u
X11549 DVDD GATE BAT DVDD pfet_06v0 ad=47.6862p pd=64.265u as=47.6862p ps=64.265u w=62.745u l=1u
X11550 BAT GATE DVDD DVDD pfet_06v0 ad=35.511p pd=48.245u as=35.511p ps=48.245u w=46.725u l=1u
X11551 DVDD GATE BAT DVDD pfet_06v0 ad=35.511p pd=48.245u as=35.511p ps=48.245u w=46.725u l=1u
X11552 BAT GATE DVDD DVDD pfet_06v0 ad=58.1134p pd=77.985u as=58.1134p ps=77.985u w=76.465u l=1u
X11553 DVDD GATE BAT DVDD pfet_06v0 ad=58.1134p pd=77.985u as=58.1134p ps=77.985u w=76.465u l=1u
X11554 BAT GATE DVDD DVDD pfet_06v0 ad=49.3848p pd=66.5u as=61.0812p ps=0.13184m w=64.98u l=1u
X11555 DVDD GATE BAT DVDD pfet_06v0 ad=35.511p pd=48.245u as=35.511p ps=48.245u w=46.725u l=1u
X11556 BAT GATE DVDD DVDD pfet_06v0 ad=35.511p pd=48.245u as=35.511p ps=48.245u w=46.725u l=1u
X11557 DVDD GATE BAT DVDD pfet_06v0 ad=71.8301p pd=0.15471m as=58.0754p ps=77.935u w=76.41499u l=1u
X11558 BAT GATE DVDD DVDD pfet_06v0 ad=58.1096p pd=77.98u as=58.1096p ps=77.98u w=76.46u l=1u
X11559 BAT GATE DVDD DVDD pfet_06v0 ad=58.1134p pd=77.985u as=58.1134p ps=77.985u w=76.465u l=1u
X11560 DVDD GATE BAT DVDD pfet_06v0 ad=35.511p pd=48.245u as=35.511p ps=48.245u w=46.725u l=1u
X11561 BAT GATE DVDD DVDD pfet_06v0 ad=58.0754p pd=77.935u as=58.0754p ps=77.935u w=76.41499u l=1u
X11562 BAT GATE DVDD DVDD pfet_06v0 ad=58.1096p pd=77.98u as=58.1096p ps=77.98u w=76.46u l=1u
X11563 BAT GATE DVDD DVDD pfet_06v0 ad=35.5072p pd=48.24u as=35.5072p ps=48.24u w=46.72u l=1u
X11564 DVDD GATE BAT DVDD pfet_06v0 ad=35.511p pd=48.245u as=35.511p ps=48.245u w=46.725u l=1u
X11565 BAT GATE DVDD DVDD pfet_06v0 ad=47.6862p pd=64.265u as=47.6862p ps=64.265u w=62.745u l=1u
X11566 BAT GATE DVDD DVDD pfet_06v0 ad=35.511p pd=48.245u as=35.511p ps=48.245u w=46.725u l=1u
X11567 BAT GATE DVDD DVDD pfet_06v0 ad=35.5072p pd=48.24u as=35.5072p ps=48.24u w=46.72u l=1u
X11568 DVDD GATE BAT DVDD pfet_06v0 ad=35.511p pd=48.245u as=35.511p ps=48.245u w=46.725u l=1u
X11569 BAT GATE DVDD DVDD pfet_06v0 ad=35.511p pd=48.245u as=35.511p ps=48.245u w=46.725u l=1u
X11570 DVDD GATE BAT DVDD pfet_06v0 ad=35.511p pd=48.245u as=35.511p ps=48.245u w=46.725u l=1u
X11571 DVDD GATE BAT DVDD pfet_06v0 ad=58.1134p pd=77.985u as=58.1134p ps=77.985u w=76.465u l=1u
X11572 BAT GATE DVDD DVDD pfet_06v0 ad=35.5072p pd=48.24u as=35.5072p ps=48.24u w=46.72u l=1u
X11573 BAT GATE DVDD DVDD pfet_06v0 ad=58.1134p pd=77.985u as=58.1134p ps=77.985u w=76.465u l=1u
X11574 BAT GATE DVDD DVDD pfet_06v0 ad=58.1134p pd=77.985u as=71.8771p ps=0.15481m w=76.465u l=1u
X11575 BAT GATE DVDD DVDD pfet_06v0 ad=35.511p pd=48.245u as=35.511p ps=48.245u w=46.725u l=1u
X11576 DVDD GATE BAT DVDD pfet_06v0 ad=47.6862p pd=64.265u as=47.6862p ps=64.265u w=62.745u l=1u
X11577 BAT GATE DVDD DVDD pfet_06v0 ad=35.511p pd=48.245u as=35.511p ps=48.245u w=46.725u l=1u
X11578 BAT GATE DVDD DVDD pfet_06v0 ad=58.1134p pd=77.985u as=58.1134p ps=77.985u w=76.465u l=1u
X11579 DVDD GATE BAT DVDD pfet_06v0 ad=58.0754p pd=77.935u as=58.0754p ps=77.935u w=76.41499u l=1u
X11580 BAT GATE DVDD DVDD pfet_06v0 ad=35.511p pd=48.245u as=35.511p ps=48.245u w=46.725u l=1u
X11581 BAT GATE DVDD DVDD pfet_06v0 ad=35.511p pd=48.245u as=35.511p ps=48.245u w=46.725u l=1u
X11582 BAT GATE DVDD DVDD pfet_06v0 ad=47.6862p pd=64.265u as=58.9803p ps=0.12737m w=62.745u l=1u
X11583 DVDD GATE BAT DVDD pfet_06v0 ad=58.1134p pd=77.985u as=58.1134p ps=77.985u w=76.465u l=1u
X11584 BAT GATE DVDD DVDD pfet_06v0 ad=47.6862p pd=64.265u as=47.6862p ps=64.265u w=62.745u l=1u
X11585 DVDD GATE BAT DVDD pfet_06v0 ad=35.5072p pd=48.24u as=35.5072p ps=48.24u w=46.72u l=1u
X11586 BAT GATE DVDD DVDD pfet_06v0 ad=58.1172p pd=77.99u as=58.1172p ps=77.99u w=76.47u l=1u
X11587 DVDD GATE BAT DVDD pfet_06v0 ad=35.511p pd=48.245u as=35.511p ps=48.245u w=46.725u l=1u
X11588 DVDD GATE BAT DVDD pfet_06v0 ad=49.3848p pd=66.5u as=49.3848p ps=66.5u w=64.98u l=1u
X11589 BAT GATE DVDD DVDD pfet_06v0 ad=58.1134p pd=77.985u as=58.1134p ps=77.985u w=76.465u l=1u
X11590 BAT GATE DVDD DVDD pfet_06v0 ad=58.1134p pd=77.985u as=58.1134p ps=77.985u w=76.465u l=1u
X11591 DVDD GATE BAT DVDD pfet_06v0 ad=58.1134p pd=77.985u as=58.1134p ps=77.985u w=76.465u l=1u
X11592 BAT GATE DVDD DVDD pfet_06v0 ad=35.511p pd=48.245u as=35.511p ps=48.245u w=46.725u l=1u
X11593 BAT GATE DVDD DVDD pfet_06v0 ad=58.1134p pd=77.985u as=71.8771p ps=0.15481m w=76.465u l=1u
X11594 DVDD GATE BAT DVDD pfet_06v0 ad=58.1134p pd=77.985u as=58.1134p ps=77.985u w=76.465u l=1u
X11595 DVDD GATE BAT DVDD pfet_06v0 ad=35.511p pd=48.245u as=35.511p ps=48.245u w=46.725u l=1u
X11596 BAT GATE DVDD DVDD pfet_06v0 ad=58.1134p pd=77.985u as=58.1134p ps=77.985u w=76.465u l=1u
X11597 DVDD GATE BAT DVDD pfet_06v0 ad=49.3848p pd=66.5u as=49.3848p ps=66.5u w=64.98u l=1u
X11598 BAT GATE DVDD DVDD pfet_06v0 ad=58.0754p pd=77.935u as=71.8301p ps=0.15471m w=76.41499u l=1u
X11599 BAT GATE DVDD DVDD pfet_06v0 ad=49.3848p pd=66.5u as=49.3848p ps=66.5u w=64.98u l=1u
X11600 DVDD GATE BAT DVDD pfet_06v0 ad=43.9215p pd=95.32999u as=35.511p ps=48.245u w=46.725u l=1u
X11601 DVDD GATE BAT DVDD pfet_06v0 ad=35.511p pd=48.245u as=35.511p ps=48.245u w=46.725u l=1u
X11602 BAT GATE DVDD DVDD pfet_06v0 ad=58.1552p pd=78.04u as=58.1552p ps=78.04u w=76.52u l=1u
X11603 BAT GATE DVDD DVDD pfet_06v0 ad=58.0754p pd=77.935u as=58.0754p ps=77.935u w=76.41499u l=1u
X11604 BAT GATE DVDD DVDD pfet_06v0 ad=35.511p pd=48.245u as=35.511p ps=48.245u w=46.725u l=1u
X11605 BAT GATE DVDD DVDD pfet_06v0 ad=35.511p pd=48.245u as=35.511p ps=48.245u w=46.725u l=1u
X11606 DVDD GATE BAT DVDD pfet_06v0 ad=58.1552p pd=78.04u as=58.1552p ps=78.04u w=76.52u l=1u
X11607 DVDD GATE BAT DVDD pfet_06v0 ad=58.1134p pd=77.985u as=58.1134p ps=77.985u w=76.465u l=1u
X11608 BAT GATE DVDD DVDD pfet_06v0 ad=58.1134p pd=77.985u as=58.1134p ps=77.985u w=76.465u l=1u
X11609 BAT GATE DVDD DVDD pfet_06v0 ad=58.1134p pd=77.985u as=71.8771p ps=0.15481m w=76.465u l=1u
X11610 BAT GATE DVDD DVDD pfet_06v0 ad=35.511p pd=48.245u as=35.511p ps=48.245u w=46.725u l=1u
X11611 BAT GATE DVDD DVDD pfet_06v0 ad=58.1134p pd=77.985u as=71.8771p ps=0.15481m w=76.465u l=1u
X11612 DVDD GATE BAT DVDD pfet_06v0 ad=35.511p pd=48.245u as=35.511p ps=48.245u w=46.725u l=1u
X11613 BAT GATE DVDD DVDD pfet_06v0 ad=58.1134p pd=77.985u as=71.8771p ps=0.15481m w=76.465u l=1u
X11614 DVDD GATE BAT DVDD pfet_06v0 ad=71.8771p pd=0.15481m as=58.1134p ps=77.985u w=76.465u l=1u
X11615 BAT GATE DVDD DVDD pfet_06v0 ad=35.511p pd=48.245u as=43.9215p ps=95.32999u w=46.725u l=1u
X11616 DVDD GATE BAT DVDD pfet_06v0 ad=43.9215p pd=95.32999u as=35.511p ps=48.245u w=46.725u l=1u
X11617 DVDD GATE BAT DVDD pfet_06v0 ad=35.511p pd=48.245u as=35.511p ps=48.245u w=46.725u l=1u
X11618 DVDD GATE BAT DVDD pfet_06v0 ad=35.511p pd=48.245u as=35.511p ps=48.245u w=46.725u l=1u
X11619 BAT GATE DVDD DVDD pfet_06v0 ad=58.1134p pd=77.985u as=58.1134p ps=77.985u w=76.465u l=1u
X11620 BAT GATE DVDD DVDD pfet_06v0 ad=58.1172p pd=77.99u as=58.1172p ps=77.99u w=76.47u l=1u
X11621 BAT GATE DVDD DVDD pfet_06v0 ad=35.511p pd=48.245u as=35.511p ps=48.245u w=46.725u l=1u
X11622 BAT GATE DVDD DVDD pfet_06v0 ad=35.511p pd=48.245u as=35.511p ps=48.245u w=46.725u l=1u
X11623 DVDD GATE BAT DVDD pfet_06v0 ad=58.1134p pd=77.985u as=58.1134p ps=77.985u w=76.465u l=1u
X11624 BAT GATE DVDD DVDD pfet_06v0 ad=35.511p pd=48.245u as=43.9215p ps=95.32999u w=46.725u l=1u
X11625 DVDD GATE BAT DVDD pfet_06v0 ad=58.1134p pd=77.985u as=58.1134p ps=77.985u w=76.465u l=1u
X11626 BAT GATE DVDD DVDD pfet_06v0 ad=58.1134p pd=77.985u as=58.1134p ps=77.985u w=76.465u l=1u
X11627 BAT GATE DVDD DVDD pfet_06v0 ad=35.511p pd=48.245u as=35.511p ps=48.245u w=46.725u l=1u
X11628 DVDD GATE BAT DVDD pfet_06v0 ad=58.1134p pd=77.985u as=58.1134p ps=77.985u w=76.465u l=1u
X11629 DVDD GATE BAT DVDD pfet_06v0 ad=49.3848p pd=66.5u as=49.3848p ps=66.5u w=64.98u l=1u
X11630 BAT GATE DVDD DVDD pfet_06v0 ad=58.1134p pd=77.985u as=58.1134p ps=77.985u w=76.465u l=1u
X11631 DVDD GATE BAT DVDD pfet_06v0 ad=35.511p pd=48.245u as=35.511p ps=48.245u w=46.725u l=1u
X11632 DVDD GATE BAT DVDD pfet_06v0 ad=61.0812p pd=0.13184m as=49.3848p ps=66.5u w=64.98u l=1u
X11633 BAT GATE DVDD DVDD pfet_06v0 ad=58.1134p pd=77.985u as=58.1134p ps=77.985u w=76.465u l=1u
X11634 DVDD GATE BAT DVDD pfet_06v0 ad=58.1134p pd=77.985u as=58.1134p ps=77.985u w=76.465u l=1u
X11635 BAT GATE DVDD DVDD pfet_06v0 ad=35.511p pd=48.245u as=35.511p ps=48.245u w=46.725u l=1u
X11636 DVDD GATE BAT DVDD pfet_06v0 ad=49.3848p pd=66.5u as=49.3848p ps=66.5u w=64.98u l=1u
X11637 BAT GATE DVDD DVDD pfet_06v0 ad=58.0754p pd=77.935u as=71.8301p ps=0.15471m w=76.41499u l=1u
X11638 DVDD GATE BAT DVDD pfet_06v0 ad=58.1134p pd=77.985u as=58.1134p ps=77.985u w=76.465u l=1u
X11639 DVDD GATE BAT DVDD pfet_06v0 ad=43.9215p pd=95.32999u as=35.511p ps=48.245u w=46.725u l=1u
X11640 BAT GATE DVDD DVDD pfet_06v0 ad=35.511p pd=48.245u as=35.511p ps=48.245u w=46.725u l=1u
X11641 DVDD GATE BAT DVDD pfet_06v0 ad=47.6862p pd=64.265u as=47.6862p ps=64.265u w=62.745u l=1u
X11642 DVDD GATE BAT DVDD pfet_06v0 ad=35.511p pd=48.245u as=35.511p ps=48.245u w=46.725u l=1u
X11643 BAT GATE DVDD DVDD pfet_06v0 ad=58.1134p pd=77.985u as=58.1134p ps=77.985u w=76.465u l=1u
X11644 BAT GATE DVDD DVDD pfet_06v0 ad=35.511p pd=48.245u as=35.511p ps=48.245u w=46.725u l=1u
X11645 BAT GATE DVDD DVDD pfet_06v0 ad=35.511p pd=48.245u as=35.511p ps=48.245u w=46.725u l=1u
X11646 BAT GATE DVDD DVDD pfet_06v0 ad=58.1552p pd=78.04u as=58.1552p ps=78.04u w=76.52u l=1u
X11647 DVDD GATE BAT DVDD pfet_06v0 ad=58.1134p pd=77.985u as=58.1134p ps=77.985u w=76.465u l=1u
X11648 DVDD GATE BAT DVDD pfet_06v0 ad=58.1096p pd=77.98u as=58.1096p ps=77.98u w=76.46u l=1u
X11649 DVDD GATE BAT DVDD pfet_06v0 ad=35.511p pd=48.245u as=35.511p ps=48.245u w=46.725u l=1u
X11650 BAT GATE DVDD DVDD pfet_06v0 ad=58.1172p pd=77.99u as=58.1172p ps=77.99u w=76.47u l=1u
X11651 BAT GATE DVDD DVDD pfet_06v0 ad=35.511p pd=48.245u as=43.9215p ps=95.32999u w=46.725u l=1u
X11652 BAT GATE DVDD DVDD pfet_06v0 ad=58.1134p pd=77.985u as=58.1134p ps=77.985u w=76.465u l=1u
X11653 DVDD GATE BAT DVDD pfet_06v0 ad=43.9215p pd=95.32999u as=35.511p ps=48.245u w=46.725u l=1u
X11654 DVDD GATE BAT DVDD pfet_06v0 ad=47.6862p pd=64.265u as=47.6862p ps=64.265u w=62.745u l=1u
X11655 DVDD GATE BAT DVDD pfet_06v0 ad=58.1134p pd=77.985u as=58.1134p ps=77.985u w=76.465u l=1u
X11656 DVDD GATE BAT DVDD pfet_06v0 ad=58.1134p pd=77.985u as=58.1134p ps=77.985u w=76.465u l=1u
X11657 BAT GATE DVDD DVDD pfet_06v0 ad=35.511p pd=48.245u as=35.511p ps=48.245u w=46.725u l=1u
X11658 DVDD GATE BAT DVDD pfet_06v0 ad=35.511p pd=48.245u as=35.511p ps=48.245u w=46.725u l=1u
X11659 DVDD GATE BAT DVDD pfet_06v0 ad=35.511p pd=48.245u as=35.511p ps=48.245u w=46.725u l=1u
X11660 DVDD GATE BAT DVDD pfet_06v0 ad=71.8771p pd=0.15481m as=58.1134p ps=77.985u w=76.465u l=1u
X11661 BAT GATE DVDD DVDD pfet_06v0 ad=58.1134p pd=77.985u as=71.8771p ps=0.15481m w=76.465u l=1u
X11662 DVDD GATE BAT DVDD pfet_06v0 ad=35.5072p pd=48.24u as=35.5072p ps=48.24u w=46.72u l=1u
X11663 DVDD GATE BAT DVDD pfet_06v0 ad=58.0754p pd=77.935u as=58.0754p ps=77.935u w=76.41499u l=1u
X11664 DVDD GATE BAT DVDD pfet_06v0 ad=58.1134p pd=77.985u as=58.1134p ps=77.985u w=76.465u l=1u
X11665 BAT GATE DVDD DVDD pfet_06v0 ad=58.1134p pd=77.985u as=58.1134p ps=77.985u w=76.465u l=1u
X11666 DVDD GATE BAT DVDD pfet_06v0 ad=58.0754p pd=77.935u as=58.0754p ps=77.935u w=76.41499u l=1u
X11667 DVDD GATE BAT DVDD pfet_06v0 ad=47.6862p pd=64.265u as=47.6862p ps=64.265u w=62.745u l=1u
X11668 BAT GATE DVDD DVDD pfet_06v0 ad=35.511p pd=48.245u as=35.511p ps=48.245u w=46.725u l=1u
X11669 DVDD GATE BAT DVDD pfet_06v0 ad=49.3848p pd=66.5u as=49.3848p ps=66.5u w=64.98u l=1u
X11670 BAT GATE DVDD DVDD pfet_06v0 ad=47.6862p pd=64.265u as=58.9803p ps=0.12737m w=62.745u l=1u
X11671 BAT GATE DVDD DVDD pfet_06v0 ad=35.511p pd=48.245u as=43.9215p ps=95.32999u w=46.725u l=1u
X11672 DVDD GATE BAT DVDD pfet_06v0 ad=35.5072p pd=48.24u as=35.5072p ps=48.24u w=46.72u l=1u
X11673 BAT GATE DVDD DVDD pfet_06v0 ad=35.511p pd=48.245u as=35.511p ps=48.245u w=46.725u l=1u
X11674 BAT GATE DVDD DVDD pfet_06v0 ad=58.1552p pd=78.04u as=58.1552p ps=78.04u w=76.52u l=1u
X11675 BAT GATE DVDD DVDD pfet_06v0 ad=58.1134p pd=77.985u as=71.8771p ps=0.15481m w=76.465u l=1u
X11676 BAT GATE DVDD DVDD pfet_06v0 ad=58.1096p pd=77.98u as=58.1096p ps=77.98u w=76.46u l=1u
X11677 BAT GATE DVDD DVDD pfet_06v0 ad=35.5072p pd=48.24u as=43.9168p ps=95.32u w=46.72u l=1u
X11678 DVDD GATE BAT DVDD pfet_06v0 ad=58.1134p pd=77.985u as=58.1134p ps=77.985u w=76.465u l=1u
X11679 DVDD GATE BAT DVDD pfet_06v0 ad=47.6862p pd=64.265u as=47.6862p ps=64.265u w=62.745u l=1u
X11680 DVDD GATE BAT DVDD pfet_06v0 ad=71.8771p pd=0.15481m as=58.1134p ps=77.985u w=76.465u l=1u
X11681 BAT GATE DVDD DVDD pfet_06v0 ad=58.1134p pd=77.985u as=58.1134p ps=77.985u w=76.465u l=1u
X11682 DVDD GATE BAT DVDD pfet_06v0 ad=58.1134p pd=77.985u as=58.1134p ps=77.985u w=76.465u l=1u
X11683 BAT GATE DVDD DVDD pfet_06v0 ad=49.3848p pd=66.5u as=49.3848p ps=66.5u w=64.98u l=1u
X11684 BAT GATE DVDD DVDD pfet_06v0 ad=58.1172p pd=77.99u as=58.1172p ps=77.99u w=76.47u l=1u
X11685 BAT GATE DVDD DVDD pfet_06v0 ad=35.5072p pd=48.24u as=35.5072p ps=48.24u w=46.72u l=1u
X11686 BAT GATE DVDD DVDD pfet_06v0 ad=35.511p pd=48.245u as=43.9215p ps=95.32999u w=46.725u l=1u
X11687 BAT GATE DVDD DVDD pfet_06v0 ad=35.5072p pd=48.24u as=35.5072p ps=48.24u w=46.72u l=1u
X11688 BAT GATE DVDD DVDD pfet_06v0 ad=58.1134p pd=77.985u as=58.1134p ps=77.985u w=76.465u l=1u
X11689 DVDD GATE BAT DVDD pfet_06v0 ad=58.1096p pd=77.98u as=58.1096p ps=77.98u w=76.46u l=1u
X11690 DVDD GATE BAT DVDD pfet_06v0 ad=35.511p pd=48.245u as=35.511p ps=48.245u w=46.725u l=1u
X11691 DVDD GATE BAT DVDD pfet_06v0 ad=71.8771p pd=0.15481m as=58.1134p ps=77.985u w=76.465u l=1u
X11692 DVDD GATE BAT DVDD pfet_06v0 ad=58.1134p pd=77.985u as=58.1134p ps=77.985u w=76.465u l=1u
X11693 DVDD GATE BAT DVDD pfet_06v0 ad=43.9215p pd=95.32999u as=35.511p ps=48.245u w=46.725u l=1u
X11694 BAT GATE DVDD DVDD pfet_06v0 ad=49.3848p pd=66.5u as=49.3848p ps=66.5u w=64.98u l=1u
X11695 DVDD GATE BAT DVDD pfet_06v0 ad=49.3848p pd=66.5u as=49.3848p ps=66.5u w=64.98u l=1u
X11696 BAT GATE DVDD DVDD pfet_06v0 ad=58.1134p pd=77.985u as=58.1134p ps=77.985u w=76.465u l=1u
X11697 DVDD GATE BAT DVDD pfet_06v0 ad=35.511p pd=48.245u as=35.511p ps=48.245u w=46.725u l=1u
X11698 BAT GATE DVDD DVDD pfet_06v0 ad=35.511p pd=48.245u as=35.511p ps=48.245u w=46.725u l=1u
X11699 DVDD GATE BAT DVDD pfet_06v0 ad=58.0754p pd=77.935u as=58.0754p ps=77.935u w=76.41499u l=1u
X11700 BAT GATE DVDD DVDD pfet_06v0 ad=35.511p pd=48.245u as=35.511p ps=48.245u w=46.725u l=1u
X11701 DVDD GATE BAT DVDD pfet_06v0 ad=35.511p pd=48.245u as=35.511p ps=48.245u w=46.725u l=1u
X11702 DVDD GATE BAT DVDD pfet_06v0 ad=71.8771p pd=0.15481m as=58.1134p ps=77.985u w=76.465u l=1u
X11703 DVDD GATE BAT DVDD pfet_06v0 ad=58.1134p pd=77.985u as=58.1134p ps=77.985u w=76.465u l=1u
X11704 BAT GATE DVDD DVDD pfet_06v0 ad=35.511p pd=48.245u as=43.9215p ps=95.32999u w=46.725u l=1u
X11705 DVDD GATE BAT DVDD pfet_06v0 ad=43.9215p pd=95.32999u as=35.511p ps=48.245u w=46.725u l=1u
X11706 DVDD GATE BAT DVDD pfet_06v0 ad=43.9215p pd=95.32999u as=35.511p ps=48.245u w=46.725u l=1u
X11707 DVDD GATE BAT DVDD pfet_06v0 ad=35.511p pd=48.245u as=35.511p ps=48.245u w=46.725u l=1u
X11708 DVDD GATE BAT DVDD pfet_06v0 ad=58.1172p pd=77.99u as=58.1172p ps=77.99u w=76.47u l=1u
X11709 BAT GATE DVDD DVDD pfet_06v0 ad=35.511p pd=48.245u as=35.511p ps=48.245u w=46.725u l=1u
X11710 DVDD GATE BAT DVDD pfet_06v0 ad=35.511p pd=48.245u as=35.511p ps=48.245u w=46.725u l=1u
X11711 BAT GATE DVDD DVDD pfet_06v0 ad=35.511p pd=48.245u as=35.511p ps=48.245u w=46.725u l=1u
X11712 BAT GATE DVDD DVDD pfet_06v0 ad=35.511p pd=48.245u as=35.511p ps=48.245u w=46.725u l=1u
X11713 BAT GATE DVDD DVDD pfet_06v0 ad=58.1552p pd=78.04u as=58.1552p ps=78.04u w=76.52u l=1u
X11714 BAT GATE DVDD DVDD pfet_06v0 ad=58.1134p pd=77.985u as=71.8771p ps=0.15481m w=76.465u l=1u
X11715 BAT GATE DVDD DVDD pfet_06v0 ad=35.511p pd=48.245u as=35.511p ps=48.245u w=46.725u l=1u
X11716 DVDD GATE BAT DVDD pfet_06v0 ad=58.1134p pd=77.985u as=58.1134p ps=77.985u w=76.465u l=1u
X11717 DVDD GATE BAT DVDD pfet_06v0 ad=35.511p pd=48.245u as=35.511p ps=48.245u w=46.725u l=1u
X11718 BAT GATE DVDD DVDD pfet_06v0 ad=58.1134p pd=77.985u as=58.1134p ps=77.985u w=76.465u l=1u
X11719 DVDD GATE BAT DVDD pfet_06v0 ad=35.511p pd=48.245u as=35.511p ps=48.245u w=46.725u l=1u
X11720 BAT GATE DVDD DVDD pfet_06v0 ad=35.511p pd=48.245u as=35.511p ps=48.245u w=46.725u l=1u
X11721 DVDD GATE BAT DVDD pfet_06v0 ad=35.511p pd=48.245u as=35.511p ps=48.245u w=46.725u l=1u
X11722 BAT GATE DVDD DVDD pfet_06v0 ad=35.511p pd=48.245u as=35.511p ps=48.245u w=46.725u l=1u
X11723 DVDD GATE BAT DVDD pfet_06v0 ad=71.8771p pd=0.15481m as=58.1134p ps=77.985u w=76.465u l=1u
X11724 BAT GATE DVDD DVDD pfet_06v0 ad=35.511p pd=48.245u as=35.511p ps=48.245u w=46.725u l=1u
X11725 DVDD GATE BAT DVDD pfet_06v0 ad=71.8771p pd=0.15481m as=58.1134p ps=77.985u w=76.465u l=1u
X11726 BAT GATE DVDD DVDD pfet_06v0 ad=49.3848p pd=66.5u as=49.3848p ps=66.5u w=64.98u l=1u
X11727 BAT GATE DVDD DVDD pfet_06v0 ad=49.3848p pd=66.5u as=49.3848p ps=66.5u w=64.98u l=1u
X11728 BAT GATE DVDD DVDD pfet_06v0 ad=58.1552p pd=78.04u as=58.1552p ps=78.04u w=76.52u l=1u
X11729 DVDD GATE BAT DVDD pfet_06v0 ad=58.1134p pd=77.985u as=58.1134p ps=77.985u w=76.465u l=1u
X11730 BAT GATE DVDD DVDD pfet_06v0 ad=58.1134p pd=77.985u as=71.8771p ps=0.15481m w=76.465u l=1u
X11731 DVDD GATE BAT DVDD pfet_06v0 ad=35.511p pd=48.245u as=35.511p ps=48.245u w=46.725u l=1u
X11732 DVDD GATE BAT DVDD pfet_06v0 ad=35.511p pd=48.245u as=35.511p ps=48.245u w=46.725u l=1u
X11733 BAT GATE DVDD DVDD pfet_06v0 ad=58.1134p pd=77.985u as=58.1134p ps=77.985u w=76.465u l=1u
X11734 DVDD GATE BAT DVDD pfet_06v0 ad=35.511p pd=48.245u as=35.511p ps=48.245u w=46.725u l=1u
X11735 DVDD GATE BAT DVDD pfet_06v0 ad=35.511p pd=48.245u as=35.511p ps=48.245u w=46.725u l=1u
X11736 BAT GATE DVDD DVDD pfet_06v0 ad=35.511p pd=48.245u as=35.511p ps=48.245u w=46.725u l=1u
X11737 BAT GATE DVDD DVDD pfet_06v0 ad=35.511p pd=48.245u as=35.511p ps=48.245u w=46.725u l=1u
X11738 BAT GATE DVDD DVDD pfet_06v0 ad=58.1134p pd=77.985u as=58.1134p ps=77.985u w=76.465u l=1u
X11739 DVDD GATE BAT DVDD pfet_06v0 ad=58.1552p pd=78.04u as=58.1552p ps=78.04u w=76.52u l=1u
X11740 BAT GATE DVDD DVDD pfet_06v0 ad=47.6862p pd=64.265u as=47.6862p ps=64.265u w=62.745u l=1u
X11741 DVDD GATE BAT DVDD pfet_06v0 ad=58.1134p pd=77.985u as=58.1134p ps=77.985u w=76.465u l=1u
X11742 BAT GATE DVDD DVDD pfet_06v0 ad=58.1134p pd=77.985u as=58.1134p ps=77.985u w=76.465u l=1u
X11743 DVDD GATE BAT DVDD pfet_06v0 ad=49.3848p pd=66.5u as=49.3848p ps=66.5u w=64.98u l=1u
X11744 DVDD GATE BAT DVDD pfet_06v0 ad=43.9215p pd=95.32999u as=35.511p ps=48.245u w=46.725u l=1u
X11745 BAT GATE DVDD DVDD pfet_06v0 ad=58.1134p pd=77.985u as=58.1134p ps=77.985u w=76.465u l=1u
X11746 BAT GATE DVDD DVDD pfet_06v0 ad=58.1172p pd=77.99u as=71.8818p ps=0.15482m w=76.47u l=1u
X11747 DVDD GATE BAT DVDD pfet_06v0 ad=35.511p pd=48.245u as=35.511p ps=48.245u w=46.725u l=1u
X11748 BAT GATE DVDD DVDD pfet_06v0 ad=58.1134p pd=77.985u as=58.1134p ps=77.985u w=76.465u l=1u
X11749 BAT GATE DVDD DVDD pfet_06v0 ad=47.6862p pd=64.265u as=47.6862p ps=64.265u w=62.745u l=1u
X11750 BAT GATE DVDD DVDD pfet_06v0 ad=58.1134p pd=77.985u as=58.1134p ps=77.985u w=76.465u l=1u
X11751 BAT GATE DVDD DVDD pfet_06v0 ad=58.1134p pd=77.985u as=58.1134p ps=77.985u w=76.465u l=1u
X11752 BAT GATE DVDD DVDD pfet_06v0 ad=35.511p pd=48.245u as=35.511p ps=48.245u w=46.725u l=1u
X11753 BAT GATE DVDD DVDD pfet_06v0 ad=35.511p pd=48.245u as=35.511p ps=48.245u w=46.725u l=1u
X11754 DVDD GATE BAT DVDD pfet_06v0 ad=35.511p pd=48.245u as=35.511p ps=48.245u w=46.725u l=1u
X11755 DVDD GATE BAT DVDD pfet_06v0 ad=58.1134p pd=77.985u as=58.1134p ps=77.985u w=76.465u l=1u
X11756 BAT GATE DVDD DVDD pfet_06v0 ad=58.1552p pd=78.04u as=71.92879p ps=0.15492m w=76.52u l=1u
X11757 BAT GATE DVDD DVDD pfet_06v0 ad=58.1096p pd=77.98u as=58.1096p ps=77.98u w=76.46u l=1u
X11758 DVDD GATE BAT DVDD pfet_06v0 ad=58.1134p pd=77.985u as=58.1134p ps=77.985u w=76.465u l=1u
X11759 BAT GATE DVDD DVDD pfet_06v0 ad=35.511p pd=48.245u as=35.511p ps=48.245u w=46.725u l=1u
X11760 BAT GATE DVDD DVDD pfet_06v0 ad=58.1096p pd=77.98u as=58.1096p ps=77.98u w=76.46u l=1u
X11761 BAT GATE DVDD DVDD pfet_06v0 ad=35.511p pd=48.245u as=35.511p ps=48.245u w=46.725u l=1u
X11762 DVDD GATE BAT DVDD pfet_06v0 ad=43.9168p pd=95.32u as=35.5072p ps=48.24u w=46.72u l=1u
X11763 BAT GATE DVDD DVDD pfet_06v0 ad=58.1134p pd=77.985u as=58.1134p ps=77.985u w=76.465u l=1u
X11764 BAT GATE DVDD DVDD pfet_06v0 ad=58.1134p pd=77.985u as=58.1134p ps=77.985u w=76.465u l=1u
X11765 DVDD GATE BAT DVDD pfet_06v0 ad=58.1134p pd=77.985u as=58.1134p ps=77.985u w=76.465u l=1u
X11766 BAT GATE DVDD DVDD pfet_06v0 ad=35.5072p pd=48.24u as=35.5072p ps=48.24u w=46.72u l=1u
X11767 DVDD GATE BAT DVDD pfet_06v0 ad=35.511p pd=48.245u as=35.511p ps=48.245u w=46.725u l=1u
X11768 BAT GATE DVDD DVDD pfet_06v0 ad=58.1552p pd=78.04u as=58.1552p ps=78.04u w=76.52u l=1u
X11769 DVDD GATE BAT DVDD pfet_06v0 ad=35.511p pd=48.245u as=35.511p ps=48.245u w=46.725u l=1u
X11770 BAT GATE DVDD DVDD pfet_06v0 ad=58.1134p pd=77.985u as=58.1134p ps=77.985u w=76.465u l=1u
X11771 BAT GATE DVDD DVDD pfet_06v0 ad=35.511p pd=48.245u as=35.511p ps=48.245u w=46.725u l=1u
X11772 DVDD GATE BAT DVDD pfet_06v0 ad=58.1134p pd=77.985u as=58.1134p ps=77.985u w=76.465u l=1u
X11773 BAT GATE DVDD DVDD pfet_06v0 ad=58.0754p pd=77.935u as=58.0754p ps=77.935u w=76.41499u l=1u
X11774 BAT GATE DVDD DVDD pfet_06v0 ad=58.1134p pd=77.985u as=58.1134p ps=77.985u w=76.465u l=1u
X11775 DVDD GATE BAT DVDD pfet_06v0 ad=71.8771p pd=0.15481m as=58.1134p ps=77.985u w=76.465u l=1u
X11776 DVDD GATE BAT DVDD pfet_06v0 ad=71.8771p pd=0.15481m as=58.1134p ps=77.985u w=76.465u l=1u
X11777 DVDD GATE BAT DVDD pfet_06v0 ad=58.1096p pd=77.98u as=58.1096p ps=77.98u w=76.46u l=1u
X11778 BAT GATE DVDD DVDD pfet_06v0 ad=35.511p pd=48.245u as=43.9215p ps=95.32999u w=46.725u l=1u
X11779 BAT GATE DVDD DVDD pfet_06v0 ad=58.1134p pd=77.985u as=58.1134p ps=77.985u w=76.465u l=1u
X11780 DVDD GATE BAT DVDD pfet_06v0 ad=58.1134p pd=77.985u as=58.1134p ps=77.985u w=76.465u l=1u
X11781 BAT GATE DVDD DVDD pfet_06v0 ad=35.511p pd=48.245u as=35.511p ps=48.245u w=46.725u l=1u
X11782 BAT GATE DVDD DVDD pfet_06v0 ad=47.6862p pd=64.265u as=58.9803p ps=0.12737m w=62.745u l=1u
X11783 DVDD GATE BAT DVDD pfet_06v0 ad=35.511p pd=48.245u as=35.511p ps=48.245u w=46.725u l=1u
X11784 DVDD GATE BAT DVDD pfet_06v0 ad=58.1134p pd=77.985u as=58.1134p ps=77.985u w=76.465u l=1u
X11785 DVDD GATE BAT DVDD pfet_06v0 ad=58.0754p pd=77.935u as=58.0754p ps=77.935u w=76.41499u l=1u
X11786 DVDD GATE BAT DVDD pfet_06v0 ad=35.511p pd=48.245u as=35.511p ps=48.245u w=46.725u l=1u
X11787 BAT GATE DVDD DVDD pfet_06v0 ad=35.511p pd=48.245u as=35.511p ps=48.245u w=46.725u l=1u
X11788 BAT GATE DVDD DVDD pfet_06v0 ad=35.511p pd=48.245u as=35.511p ps=48.245u w=46.725u l=1u
X11789 BAT GATE DVDD DVDD pfet_06v0 ad=47.6862p pd=64.265u as=47.6862p ps=64.265u w=62.745u l=1u
X11790 BAT GATE DVDD DVDD pfet_06v0 ad=35.511p pd=48.245u as=43.9215p ps=95.32999u w=46.725u l=1u
X11791 DVDD GATE BAT DVDD pfet_06v0 ad=35.511p pd=48.245u as=35.511p ps=48.245u w=46.725u l=1u
X11792 BAT GATE DVDD DVDD pfet_06v0 ad=35.511p pd=48.245u as=35.511p ps=48.245u w=46.725u l=1u
X11793 DVDD GATE BAT DVDD pfet_06v0 ad=58.1134p pd=77.985u as=58.1134p ps=77.985u w=76.465u l=1u
X11794 BAT GATE DVDD DVDD pfet_06v0 ad=58.0754p pd=77.935u as=58.0754p ps=77.935u w=76.41499u l=1u
X11795 DVDD GATE BAT DVDD pfet_06v0 ad=35.511p pd=48.245u as=35.511p ps=48.245u w=46.725u l=1u
X11796 BAT GATE DVDD DVDD pfet_06v0 ad=58.1134p pd=77.985u as=58.1134p ps=77.985u w=76.465u l=1u
X11797 DVDD GATE BAT DVDD pfet_06v0 ad=58.1134p pd=77.985u as=58.1134p ps=77.985u w=76.465u l=1u
X11798 DVDD GATE BAT DVDD pfet_06v0 ad=43.9215p pd=95.32999u as=35.511p ps=48.245u w=46.725u l=1u
X11799 BAT GATE DVDD DVDD pfet_06v0 ad=58.1134p pd=77.985u as=58.1134p ps=77.985u w=76.465u l=1u
X11800 BAT GATE DVDD DVDD pfet_06v0 ad=35.511p pd=48.245u as=35.511p ps=48.245u w=46.725u l=1u
X11801 DVDD GATE BAT DVDD pfet_06v0 ad=58.1172p pd=77.99u as=58.1172p ps=77.99u w=76.47u l=1u
X11802 DVDD GATE BAT DVDD pfet_06v0 ad=71.8771p pd=0.15481m as=58.1134p ps=77.985u w=76.465u l=1u
X11803 DVDD GATE BAT DVDD pfet_06v0 ad=35.511p pd=48.245u as=35.511p ps=48.245u w=46.725u l=1u
X11804 DVDD GATE BAT DVDD pfet_06v0 ad=71.8771p pd=0.15481m as=58.1134p ps=77.985u w=76.465u l=1u
X11805 DVDD GATE BAT DVDD pfet_06v0 ad=71.8771p pd=0.15481m as=58.1134p ps=77.985u w=76.465u l=1u
X11806 DVDD GATE BAT DVDD pfet_06v0 ad=58.1134p pd=77.985u as=58.1134p ps=77.985u w=76.465u l=1u
X11807 BAT GATE DVDD DVDD pfet_06v0 ad=35.511p pd=48.245u as=43.9215p ps=95.32999u w=46.725u l=1u
X11808 DVDD GATE BAT DVDD pfet_06v0 ad=71.8771p pd=0.15481m as=58.1134p ps=77.985u w=76.465u l=1u
X11809 DVDD GATE BAT DVDD pfet_06v0 ad=35.511p pd=48.245u as=35.511p ps=48.245u w=46.725u l=1u
X11810 BAT GATE DVDD DVDD pfet_06v0 ad=58.1134p pd=77.985u as=58.1134p ps=77.985u w=76.465u l=1u
X11811 DVDD GATE BAT DVDD pfet_06v0 ad=35.511p pd=48.245u as=35.511p ps=48.245u w=46.725u l=1u
X11812 BAT GATE DVDD DVDD pfet_06v0 ad=49.3848p pd=66.5u as=49.3848p ps=66.5u w=64.98u l=1u
X11813 BAT GATE DVDD DVDD pfet_06v0 ad=58.1172p pd=77.99u as=58.1172p ps=77.99u w=76.47u l=1u
X11814 BAT GATE DVDD DVDD pfet_06v0 ad=58.1134p pd=77.985u as=58.1134p ps=77.985u w=76.465u l=1u
X11815 DVDD GATE BAT DVDD pfet_06v0 ad=35.511p pd=48.245u as=35.511p ps=48.245u w=46.725u l=1u
X11816 DVDD GATE BAT DVDD pfet_06v0 ad=35.511p pd=48.245u as=35.511p ps=48.245u w=46.725u l=1u
X11817 BAT GATE DVDD DVDD pfet_06v0 ad=49.3848p pd=66.5u as=49.3848p ps=66.5u w=64.98u l=1u
X11818 BAT GATE DVDD DVDD pfet_06v0 ad=35.511p pd=48.245u as=35.511p ps=48.245u w=46.725u l=1u
X11819 BAT GATE DVDD DVDD pfet_06v0 ad=58.1552p pd=78.04u as=58.1552p ps=78.04u w=76.52u l=1u
X11820 DVDD GATE BAT DVDD pfet_06v0 ad=61.0812p pd=0.13184m as=49.3848p ps=66.5u w=64.98u l=1u
X11821 BAT GATE DVDD DVDD pfet_06v0 ad=58.1134p pd=77.985u as=58.1134p ps=77.985u w=76.465u l=1u
X11822 DVDD GATE BAT DVDD pfet_06v0 ad=35.511p pd=48.245u as=35.511p ps=48.245u w=46.725u l=1u
X11823 BAT GATE DVDD DVDD pfet_06v0 ad=58.1134p pd=77.985u as=58.1134p ps=77.985u w=76.465u l=1u
X11824 DVDD GATE BAT DVDD pfet_06v0 ad=58.1552p pd=78.04u as=58.1552p ps=78.04u w=76.52u l=1u
X11825 BAT GATE DVDD DVDD pfet_06v0 ad=35.511p pd=48.245u as=43.9215p ps=95.32999u w=46.725u l=1u
X11826 BAT GATE DVDD DVDD pfet_06v0 ad=35.511p pd=48.245u as=43.9215p ps=95.32999u w=46.725u l=1u
X11827 BAT GATE DVDD DVDD pfet_06v0 ad=35.511p pd=48.245u as=35.511p ps=48.245u w=46.725u l=1u
X11828 DVDD GATE BAT DVDD pfet_06v0 ad=35.511p pd=48.245u as=35.511p ps=48.245u w=46.725u l=1u
X11829 DVDD GATE BAT DVDD pfet_06v0 ad=71.8301p pd=0.15471m as=58.0754p ps=77.935u w=76.41499u l=1u
X11830 BAT GATE DVDD DVDD pfet_06v0 ad=35.511p pd=48.245u as=35.511p ps=48.245u w=46.725u l=1u
X11831 DVDD GATE BAT DVDD pfet_06v0 ad=58.1134p pd=77.985u as=58.1134p ps=77.985u w=76.465u l=1u
X11832 DVDD GATE BAT DVDD pfet_06v0 ad=35.511p pd=48.245u as=35.511p ps=48.245u w=46.725u l=1u
X11833 DVDD GATE BAT DVDD pfet_06v0 ad=58.1134p pd=77.985u as=58.1134p ps=77.985u w=76.465u l=1u
X11834 DVDD GATE BAT DVDD pfet_06v0 ad=71.92879p pd=0.15492m as=58.1552p ps=78.04u w=76.52u l=1u
X11835 BAT GATE DVDD DVDD pfet_06v0 ad=58.1134p pd=77.985u as=58.1134p ps=77.985u w=76.465u l=1u
X11836 BAT GATE DVDD DVDD pfet_06v0 ad=58.1552p pd=78.04u as=58.1552p ps=78.04u w=76.52u l=1u
X11837 DVDD GATE BAT DVDD pfet_06v0 ad=58.1134p pd=77.985u as=58.1134p ps=77.985u w=76.465u l=1u
X11838 DVDD GATE BAT DVDD pfet_06v0 ad=58.1134p pd=77.985u as=58.1134p ps=77.985u w=76.465u l=1u
X11839 BAT GATE DVDD DVDD pfet_06v0 ad=58.1134p pd=77.985u as=58.1134p ps=77.985u w=76.465u l=1u
X11840 BAT GATE DVDD DVDD pfet_06v0 ad=35.511p pd=48.245u as=35.511p ps=48.245u w=46.725u l=1u
X11841 DVDD GATE BAT DVDD pfet_06v0 ad=43.9215p pd=95.32999u as=35.511p ps=48.245u w=46.725u l=1u
X11842 DVDD GATE BAT DVDD pfet_06v0 ad=58.1134p pd=77.985u as=58.1134p ps=77.985u w=76.465u l=1u
X11843 DVDD GATE BAT DVDD pfet_06v0 ad=35.511p pd=48.245u as=35.511p ps=48.245u w=46.725u l=1u
X11844 DVDD GATE BAT DVDD pfet_06v0 ad=58.1134p pd=77.985u as=58.1134p ps=77.985u w=76.465u l=1u
X11845 DVDD GATE BAT DVDD pfet_06v0 ad=35.511p pd=48.245u as=35.511p ps=48.245u w=46.725u l=1u
X11846 BAT GATE DVDD DVDD pfet_06v0 ad=49.3848p pd=66.5u as=49.3848p ps=66.5u w=64.98u l=1u
X11847 DVDD GATE BAT DVDD pfet_06v0 ad=58.1096p pd=77.98u as=58.1096p ps=77.98u w=76.46u l=1u
X11848 BAT GATE DVDD DVDD pfet_06v0 ad=35.511p pd=48.245u as=35.511p ps=48.245u w=46.725u l=1u
X11849 BAT GATE DVDD DVDD pfet_06v0 ad=35.511p pd=48.245u as=35.511p ps=48.245u w=46.725u l=1u
X11850 BAT GATE DVDD DVDD pfet_06v0 ad=58.0754p pd=77.935u as=58.0754p ps=77.935u w=76.41499u l=1u
X11851 DVDD GATE BAT DVDD pfet_06v0 ad=35.511p pd=48.245u as=35.511p ps=48.245u w=46.725u l=1u
X11852 BAT GATE DVDD DVDD pfet_06v0 ad=49.3848p pd=66.5u as=49.3848p ps=66.5u w=64.98u l=1u
X11853 DVDD GATE BAT DVDD pfet_06v0 ad=58.1096p pd=77.98u as=58.1096p ps=77.98u w=76.46u l=1u
X11854 DVDD GATE BAT DVDD pfet_06v0 ad=35.511p pd=48.245u as=35.511p ps=48.245u w=46.725u l=1u
X11855 BAT GATE DVDD DVDD pfet_06v0 ad=35.511p pd=48.245u as=35.511p ps=48.245u w=46.725u l=1u
X11856 BAT GATE DVDD DVDD pfet_06v0 ad=58.1096p pd=77.98u as=71.8724p ps=0.1548m w=76.46u l=1u
X11857 BAT GATE DVDD DVDD pfet_06v0 ad=35.511p pd=48.245u as=43.9215p ps=95.32999u w=46.725u l=1u
X11858 DVDD GATE BAT DVDD pfet_06v0 ad=49.3848p pd=66.5u as=49.3848p ps=66.5u w=64.98u l=1u
X11859 BAT GATE DVDD DVDD pfet_06v0 ad=35.511p pd=48.245u as=35.511p ps=48.245u w=46.725u l=1u
X11860 DVDD GATE BAT DVDD pfet_06v0 ad=58.1172p pd=77.99u as=58.1172p ps=77.99u w=76.47u l=1u
X11861 DVDD GATE BAT DVDD pfet_06v0 ad=71.8301p pd=0.15471m as=58.0754p ps=77.935u w=76.41499u l=1u
X11862 BAT GATE DVDD DVDD pfet_06v0 ad=35.511p pd=48.245u as=35.511p ps=48.245u w=46.725u l=1u
X11863 BAT GATE DVDD DVDD pfet_06v0 ad=47.6862p pd=64.265u as=47.6862p ps=64.265u w=62.745u l=1u
X11864 BAT GATE DVDD DVDD pfet_06v0 ad=58.1134p pd=77.985u as=71.8771p ps=0.15481m w=76.465u l=1u
X11865 BAT GATE DVDD DVDD pfet_06v0 ad=58.1134p pd=77.985u as=71.8771p ps=0.15481m w=76.465u l=1u
X11866 DVDD GATE BAT DVDD pfet_06v0 ad=58.1134p pd=77.985u as=58.1134p ps=77.985u w=76.465u l=1u
X11867 BAT GATE DVDD DVDD pfet_06v0 ad=35.511p pd=48.245u as=35.511p ps=48.245u w=46.725u l=1u
X11868 DVDD GATE BAT DVDD pfet_06v0 ad=35.511p pd=48.245u as=35.511p ps=48.245u w=46.725u l=1u
X11869 DVDD GATE BAT DVDD pfet_06v0 ad=58.1134p pd=77.985u as=58.1134p ps=77.985u w=76.465u l=1u
X11870 BAT GATE DVDD DVDD pfet_06v0 ad=35.511p pd=48.245u as=35.511p ps=48.245u w=46.725u l=1u
X11871 DVDD GATE BAT DVDD pfet_06v0 ad=58.1172p pd=77.99u as=58.1172p ps=77.99u w=76.47u l=1u
X11872 DVDD GATE BAT DVDD pfet_06v0 ad=35.511p pd=48.245u as=35.511p ps=48.245u w=46.725u l=1u
X11873 BAT GATE DVDD DVDD pfet_06v0 ad=58.1134p pd=77.985u as=58.1134p ps=77.985u w=76.465u l=1u
X11874 BAT GATE DVDD DVDD pfet_06v0 ad=35.511p pd=48.245u as=35.511p ps=48.245u w=46.725u l=1u
X11875 DVDD GATE BAT DVDD pfet_06v0 ad=58.0754p pd=77.935u as=58.0754p ps=77.935u w=76.41499u l=1u
X11876 DVDD GATE BAT DVDD pfet_06v0 ad=35.511p pd=48.245u as=35.511p ps=48.245u w=46.725u l=1u
X11877 DVDD GATE BAT DVDD pfet_06v0 ad=43.9215p pd=95.32999u as=35.511p ps=48.245u w=46.725u l=1u
X11878 BAT GATE DVDD DVDD pfet_06v0 ad=58.1096p pd=77.98u as=58.1096p ps=77.98u w=76.46u l=1u
X11879 BAT GATE DVDD DVDD pfet_06v0 ad=58.0754p pd=77.935u as=58.0754p ps=77.935u w=76.41499u l=1u
X11880 BAT GATE DVDD DVDD pfet_06v0 ad=58.1096p pd=77.98u as=58.1096p ps=77.98u w=76.46u l=1u
X11881 BAT GATE DVDD DVDD pfet_06v0 ad=58.1134p pd=77.985u as=71.8771p ps=0.15481m w=76.465u l=1u
X11882 DVDD GATE BAT DVDD pfet_06v0 ad=49.3848p pd=66.5u as=49.3848p ps=66.5u w=64.98u l=1u
X11883 DVDD GATE BAT DVDD pfet_06v0 ad=71.8818p pd=0.15482m as=58.1172p ps=77.99u w=76.47u l=1u
X11884 DVDD GATE BAT DVDD pfet_06v0 ad=43.9215p pd=95.32999u as=35.511p ps=48.245u w=46.725u l=1u
X11885 DVDD GATE BAT DVDD pfet_06v0 ad=35.511p pd=48.245u as=35.511p ps=48.245u w=46.725u l=1u
X11886 BAT GATE DVDD DVDD pfet_06v0 ad=35.511p pd=48.245u as=35.511p ps=48.245u w=46.725u l=1u
X11887 BAT GATE DVDD DVDD pfet_06v0 ad=35.5072p pd=48.24u as=35.5072p ps=48.24u w=46.72u l=1u
X11888 BAT GATE DVDD DVDD pfet_06v0 ad=58.1134p pd=77.985u as=58.1134p ps=77.985u w=76.465u l=1u
X11889 DVDD GATE BAT DVDD pfet_06v0 ad=43.9215p pd=95.32999u as=35.511p ps=48.245u w=46.725u l=1u
X11890 DVDD GATE BAT DVDD pfet_06v0 ad=58.1552p pd=78.04u as=58.1552p ps=78.04u w=76.52u l=1u
X11891 DVDD GATE BAT DVDD pfet_06v0 ad=35.511p pd=48.245u as=35.511p ps=48.245u w=46.725u l=1u
X11892 BAT GATE DVDD DVDD pfet_06v0 ad=58.1134p pd=77.985u as=58.1134p ps=77.985u w=76.465u l=1u
X11893 DVDD GATE BAT DVDD pfet_06v0 ad=71.8771p pd=0.15481m as=58.1134p ps=77.985u w=76.465u l=1u
X11894 BAT GATE DVDD DVDD pfet_06v0 ad=35.5072p pd=48.24u as=35.5072p ps=48.24u w=46.72u l=1u
X11895 BAT GATE DVDD DVDD pfet_06v0 ad=58.0754p pd=77.935u as=58.0754p ps=77.935u w=76.41499u l=1u
X11896 DVDD GATE BAT DVDD pfet_06v0 ad=47.6862p pd=64.265u as=47.6862p ps=64.265u w=62.745u l=1u
X11897 BAT GATE DVDD DVDD pfet_06v0 ad=35.511p pd=48.245u as=43.9215p ps=95.32999u w=46.725u l=1u
X11898 BAT GATE DVDD DVDD pfet_06v0 ad=58.1134p pd=77.985u as=58.1134p ps=77.985u w=76.465u l=1u
X11899 DVDD GATE BAT DVDD pfet_06v0 ad=58.0754p pd=77.935u as=58.0754p ps=77.935u w=76.41499u l=1u
X11900 DVDD GATE BAT DVDD pfet_06v0 ad=71.92879p pd=0.15492m as=58.1552p ps=78.04u w=76.52u l=1u
X11901 BAT GATE DVDD DVDD pfet_06v0 ad=35.511p pd=48.245u as=43.9215p ps=95.32999u w=46.725u l=1u
X11902 BAT GATE DVDD DVDD pfet_06v0 ad=35.511p pd=48.245u as=35.511p ps=48.245u w=46.725u l=1u
X11903 DVDD GATE BAT DVDD pfet_06v0 ad=58.1134p pd=77.985u as=58.1134p ps=77.985u w=76.465u l=1u
X11904 BAT GATE DVDD DVDD pfet_06v0 ad=58.1134p pd=77.985u as=71.8771p ps=0.15481m w=76.465u l=1u
X11905 DVDD GATE BAT DVDD pfet_06v0 ad=58.9803p pd=0.12737m as=47.6862p ps=64.265u w=62.745u l=1u
X11906 DVDD GATE BAT DVDD pfet_06v0 ad=35.511p pd=48.245u as=35.511p ps=48.245u w=46.725u l=1u
X11907 BAT GATE DVDD DVDD pfet_06v0 ad=58.1134p pd=77.985u as=58.1134p ps=77.985u w=76.465u l=1u
X11908 DVDD GATE BAT DVDD pfet_06v0 ad=35.5072p pd=48.24u as=35.5072p ps=48.24u w=46.72u l=1u
X11909 BAT GATE DVDD DVDD pfet_06v0 ad=58.1172p pd=77.99u as=58.1172p ps=77.99u w=76.47u l=1u
X11910 DVDD GATE BAT DVDD pfet_06v0 ad=58.1134p pd=77.985u as=58.1134p ps=77.985u w=76.465u l=1u
X11911 BAT GATE DVDD DVDD pfet_06v0 ad=58.1134p pd=77.985u as=58.1134p ps=77.985u w=76.465u l=1u
X11912 BAT GATE DVDD DVDD pfet_06v0 ad=58.1134p pd=77.985u as=58.1134p ps=77.985u w=76.465u l=1u
X11913 DVDD GATE BAT DVDD pfet_06v0 ad=49.3848p pd=66.5u as=49.3848p ps=66.5u w=64.98u l=1u
X11914 BAT GATE DVDD DVDD pfet_06v0 ad=58.1134p pd=77.985u as=58.1134p ps=77.985u w=76.465u l=1u
X11915 BAT GATE DVDD DVDD pfet_06v0 ad=35.511p pd=48.245u as=43.9215p ps=95.32999u w=46.725u l=1u
X11916 BAT GATE DVDD DVDD pfet_06v0 ad=58.1134p pd=77.985u as=71.8771p ps=0.15481m w=76.465u l=1u
X11917 DVDD GATE BAT DVDD pfet_06v0 ad=58.1134p pd=77.985u as=58.1134p ps=77.985u w=76.465u l=1u
X11918 DVDD GATE BAT DVDD pfet_06v0 ad=49.3848p pd=66.5u as=49.3848p ps=66.5u w=64.98u l=1u
X11919 DVDD GATE BAT DVDD pfet_06v0 ad=58.1134p pd=77.985u as=58.1134p ps=77.985u w=76.465u l=1u
X11920 DVDD GATE BAT DVDD pfet_06v0 ad=35.511p pd=48.245u as=35.511p ps=48.245u w=46.725u l=1u
X11921 DVDD GATE BAT DVDD pfet_06v0 ad=35.511p pd=48.245u as=35.511p ps=48.245u w=46.725u l=1u
X11922 DVDD GATE BAT DVDD pfet_06v0 ad=43.9215p pd=95.32999u as=35.511p ps=48.245u w=46.725u l=1u
X11923 BAT GATE DVDD DVDD pfet_06v0 ad=58.1552p pd=78.04u as=58.1552p ps=78.04u w=76.52u l=1u
X11924 DVDD GATE BAT DVDD pfet_06v0 ad=58.1552p pd=78.04u as=58.1552p ps=78.04u w=76.52u l=1u
X11925 DVDD GATE BAT DVDD pfet_06v0 ad=58.1134p pd=77.985u as=58.1134p ps=77.985u w=76.465u l=1u
X11926 BAT GATE DVDD DVDD pfet_06v0 ad=35.511p pd=48.245u as=35.511p ps=48.245u w=46.725u l=1u
X11927 DVDD GATE BAT DVDD pfet_06v0 ad=58.1552p pd=78.04u as=58.1552p ps=78.04u w=76.52u l=1u
X11928 BAT GATE DVDD DVDD pfet_06v0 ad=35.511p pd=48.245u as=35.511p ps=48.245u w=46.725u l=1u
X11929 BAT GATE DVDD DVDD pfet_06v0 ad=35.511p pd=48.245u as=35.511p ps=48.245u w=46.725u l=1u
X11930 DVDD GATE BAT DVDD pfet_06v0 ad=35.511p pd=48.245u as=35.511p ps=48.245u w=46.725u l=1u
X11931 DVDD GATE BAT DVDD pfet_06v0 ad=58.1134p pd=77.985u as=58.1134p ps=77.985u w=76.465u l=1u
X11932 DVDD GATE BAT DVDD pfet_06v0 ad=35.511p pd=48.245u as=35.511p ps=48.245u w=46.725u l=1u
X11933 DVDD GATE BAT DVDD pfet_06v0 ad=35.511p pd=48.245u as=35.511p ps=48.245u w=46.725u l=1u
X11934 BAT GATE DVDD DVDD pfet_06v0 ad=58.1134p pd=77.985u as=71.8771p ps=0.15481m w=76.465u l=1u
X11935 DVDD GATE BAT DVDD pfet_06v0 ad=43.9215p pd=95.32999u as=35.511p ps=48.245u w=46.725u l=1u
X11936 BAT GATE DVDD DVDD pfet_06v0 ad=35.511p pd=48.245u as=35.511p ps=48.245u w=46.725u l=1u
X11937 BAT GATE DVDD DVDD pfet_06v0 ad=35.511p pd=48.245u as=35.511p ps=48.245u w=46.725u l=1u
X11938 BAT GATE DVDD DVDD pfet_06v0 ad=35.511p pd=48.245u as=35.511p ps=48.245u w=46.725u l=1u
X11939 BAT GATE DVDD DVDD pfet_06v0 ad=58.1552p pd=78.04u as=58.1552p ps=78.04u w=76.52u l=1u
X11940 DVDD GATE BAT DVDD pfet_06v0 ad=58.1134p pd=77.985u as=58.1134p ps=77.985u w=76.465u l=1u
X11941 DVDD GATE BAT DVDD pfet_06v0 ad=58.1552p pd=78.04u as=58.1552p ps=78.04u w=76.52u l=1u
X11942 DVDD GATE BAT DVDD pfet_06v0 ad=58.9803p pd=0.12737m as=47.6862p ps=64.265u w=62.745u l=1u
X11943 DVDD GATE BAT DVDD pfet_06v0 ad=58.1134p pd=77.985u as=58.1134p ps=77.985u w=76.465u l=1u
X11944 DVDD GATE BAT DVDD pfet_06v0 ad=35.511p pd=48.245u as=35.511p ps=48.245u w=46.725u l=1u
X11945 BAT GATE DVDD DVDD pfet_06v0 ad=58.1134p pd=77.985u as=58.1134p ps=77.985u w=76.465u l=1u
X11946 BAT GATE DVDD DVDD pfet_06v0 ad=35.511p pd=48.245u as=35.511p ps=48.245u w=46.725u l=1u
X11947 BAT GATE DVDD DVDD pfet_06v0 ad=35.511p pd=48.245u as=35.511p ps=48.245u w=46.725u l=1u
X11948 DVDD GATE BAT DVDD pfet_06v0 ad=58.1134p pd=77.985u as=58.1134p ps=77.985u w=76.465u l=1u
X11949 BAT GATE DVDD DVDD pfet_06v0 ad=58.1134p pd=77.985u as=58.1134p ps=77.985u w=76.465u l=1u
X11950 BAT GATE DVDD DVDD pfet_06v0 ad=58.1134p pd=77.985u as=58.1134p ps=77.985u w=76.465u l=1u
X11951 DVDD GATE BAT DVDD pfet_06v0 ad=35.511p pd=48.245u as=35.511p ps=48.245u w=46.725u l=1u
X11952 DVDD GATE BAT DVDD pfet_06v0 ad=49.3848p pd=66.5u as=49.3848p ps=66.5u w=64.98u l=1u
X11953 BAT GATE DVDD DVDD pfet_06v0 ad=58.1134p pd=77.985u as=58.1134p ps=77.985u w=76.465u l=1u
X11954 DVDD GATE BAT DVDD pfet_06v0 ad=71.8724p pd=0.1548m as=58.1096p ps=77.98u w=76.46u l=1u
X11955 DVDD GATE BAT DVDD pfet_06v0 ad=58.1172p pd=77.99u as=58.1172p ps=77.99u w=76.47u l=1u
X11956 DVDD GATE BAT DVDD pfet_06v0 ad=49.3848p pd=66.5u as=49.3848p ps=66.5u w=64.98u l=1u
X11957 DVDD GATE BAT DVDD pfet_06v0 ad=58.1134p pd=77.985u as=58.1134p ps=77.985u w=76.465u l=1u
X11958 BAT GATE DVDD DVDD pfet_06v0 ad=35.511p pd=48.245u as=43.9215p ps=95.32999u w=46.725u l=1u
X11959 BAT GATE DVDD DVDD pfet_06v0 ad=35.511p pd=48.245u as=43.9215p ps=95.32999u w=46.725u l=1u
X11960 DVDD GATE BAT DVDD pfet_06v0 ad=35.511p pd=48.245u as=35.511p ps=48.245u w=46.725u l=1u
X11961 BAT GATE DVDD DVDD pfet_06v0 ad=58.1096p pd=77.98u as=58.1096p ps=77.98u w=76.46u l=1u
X11962 DVDD GATE BAT DVDD pfet_06v0 ad=47.6862p pd=64.265u as=47.6862p ps=64.265u w=62.745u l=1u
X11963 DVDD GATE BAT DVDD pfet_06v0 ad=43.9215p pd=95.32999u as=35.511p ps=48.245u w=46.725u l=1u
X11964 BAT GATE DVDD DVDD pfet_06v0 ad=35.511p pd=48.245u as=35.511p ps=48.245u w=46.725u l=1u
X11965 DVDD GATE BAT DVDD pfet_06v0 ad=43.9168p pd=95.32u as=35.5072p ps=48.24u w=46.72u l=1u
X11966 BAT GATE DVDD DVDD pfet_06v0 ad=35.511p pd=48.245u as=35.511p ps=48.245u w=46.725u l=1u
X11967 BAT GATE DVDD DVDD pfet_06v0 ad=35.511p pd=48.245u as=35.511p ps=48.245u w=46.725u l=1u
X11968 DVDD GATE BAT DVDD pfet_06v0 ad=58.1134p pd=77.985u as=58.1134p ps=77.985u w=76.465u l=1u
X11969 DVDD GATE BAT DVDD pfet_06v0 ad=58.1134p pd=77.985u as=58.1134p ps=77.985u w=76.465u l=1u
X11970 BAT GATE DVDD DVDD pfet_06v0 ad=58.1172p pd=77.99u as=58.1172p ps=77.99u w=76.47u l=1u
X11971 DVDD GATE BAT DVDD pfet_06v0 ad=35.511p pd=48.245u as=35.511p ps=48.245u w=46.725u l=1u
X11972 DVDD GATE BAT DVDD pfet_06v0 ad=35.511p pd=48.245u as=35.511p ps=48.245u w=46.725u l=1u
X11973 DVDD GATE BAT DVDD pfet_06v0 ad=43.9215p pd=95.32999u as=35.511p ps=48.245u w=46.725u l=1u
X11974 DVDD GATE BAT DVDD pfet_06v0 ad=47.6862p pd=64.265u as=47.6862p ps=64.265u w=62.745u l=1u
X11975 BAT GATE DVDD DVDD pfet_06v0 ad=58.1134p pd=77.985u as=58.1134p ps=77.985u w=76.465u l=1u
X11976 DVDD GATE BAT DVDD pfet_06v0 ad=43.9215p pd=95.32999u as=35.511p ps=48.245u w=46.725u l=1u
X11977 BAT GATE DVDD DVDD pfet_06v0 ad=35.511p pd=48.245u as=35.511p ps=48.245u w=46.725u l=1u
X11978 BAT GATE DVDD DVDD pfet_06v0 ad=35.5072p pd=48.24u as=35.5072p ps=48.24u w=46.72u l=1u
X11979 DVDD GATE BAT DVDD pfet_06v0 ad=47.6862p pd=64.265u as=47.6862p ps=64.265u w=62.745u l=1u
X11980 DVDD GATE BAT DVDD pfet_06v0 ad=58.1134p pd=77.985u as=58.1134p ps=77.985u w=76.465u l=1u
X11981 BAT GATE DVDD DVDD pfet_06v0 ad=35.511p pd=48.245u as=35.511p ps=48.245u w=46.725u l=1u
X11982 BAT GATE DVDD DVDD pfet_06v0 ad=35.511p pd=48.245u as=35.511p ps=48.245u w=46.725u l=1u
X11983 DVDD GATE BAT DVDD pfet_06v0 ad=35.5072p pd=48.24u as=35.5072p ps=48.24u w=46.72u l=1u
X11984 DVDD GATE BAT DVDD pfet_06v0 ad=58.1134p pd=77.985u as=58.1134p ps=77.985u w=76.465u l=1u
X11985 BAT GATE DVDD DVDD pfet_06v0 ad=58.1134p pd=77.985u as=71.8771p ps=0.15481m w=76.465u l=1u
X11986 DVDD GATE BAT DVDD pfet_06v0 ad=58.0754p pd=77.935u as=58.0754p ps=77.935u w=76.41499u l=1u
X11987 DVDD GATE BAT DVDD pfet_06v0 ad=58.1134p pd=77.985u as=58.1134p ps=77.985u w=76.465u l=1u
X11988 DVDD GATE BAT DVDD pfet_06v0 ad=49.3848p pd=66.5u as=49.3848p ps=66.5u w=64.98u l=1u
X11989 DVDD GATE BAT DVDD pfet_06v0 ad=58.0754p pd=77.935u as=58.0754p ps=77.935u w=76.41499u l=1u
X11990 BAT GATE DVDD DVDD pfet_06v0 ad=35.511p pd=48.245u as=43.9215p ps=95.32999u w=46.725u l=1u
X11991 DVDD GATE BAT DVDD pfet_06v0 ad=35.511p pd=48.245u as=35.511p ps=48.245u w=46.725u l=1u
X11992 BAT GATE DVDD DVDD pfet_06v0 ad=35.511p pd=48.245u as=35.511p ps=48.245u w=46.725u l=1u
X11993 BAT GATE DVDD DVDD pfet_06v0 ad=35.511p pd=48.245u as=35.511p ps=48.245u w=46.725u l=1u
X11994 BAT GATE DVDD DVDD pfet_06v0 ad=58.1552p pd=78.04u as=58.1552p ps=78.04u w=76.52u l=1u
X11995 BAT GATE DVDD DVDD pfet_06v0 ad=58.1134p pd=77.985u as=58.1134p ps=77.985u w=76.465u l=1u
X11996 DVDD GATE BAT DVDD pfet_06v0 ad=43.9215p pd=95.32999u as=35.511p ps=48.245u w=46.725u l=1u
X11997 DVDD GATE BAT DVDD pfet_06v0 ad=58.1134p pd=77.985u as=58.1134p ps=77.985u w=76.465u l=1u
X11998 BAT GATE DVDD DVDD pfet_06v0 ad=35.511p pd=48.245u as=35.511p ps=48.245u w=46.725u l=1u
X11999 DVDD GATE BAT DVDD pfet_06v0 ad=43.9215p pd=95.32999u as=35.511p ps=48.245u w=46.725u l=1u
X12000 BAT GATE DVDD DVDD pfet_06v0 ad=58.1172p pd=77.99u as=71.8818p ps=0.15482m w=76.47u l=1u
X12001 BAT GATE DVDD DVDD pfet_06v0 ad=35.511p pd=48.245u as=35.511p ps=48.245u w=46.725u l=1u
X12002 DVDD GATE BAT DVDD pfet_06v0 ad=35.511p pd=48.245u as=35.511p ps=48.245u w=46.725u l=1u
X12003 BAT GATE DVDD DVDD pfet_06v0 ad=58.1134p pd=77.985u as=58.1134p ps=77.985u w=76.465u l=1u
X12004 DVDD GATE BAT DVDD pfet_06v0 ad=43.9215p pd=95.32999u as=35.511p ps=48.245u w=46.725u l=1u
X12005 BAT GATE DVDD DVDD pfet_06v0 ad=35.5072p pd=48.24u as=35.5072p ps=48.24u w=46.72u l=1u
X12006 BAT GATE DVDD DVDD pfet_06v0 ad=49.3848p pd=66.5u as=49.3848p ps=66.5u w=64.98u l=1u
X12007 DVDD GATE BAT DVDD pfet_06v0 ad=58.1134p pd=77.985u as=58.1134p ps=77.985u w=76.465u l=1u
X12008 BAT GATE DVDD DVDD pfet_06v0 ad=58.1134p pd=77.985u as=58.1134p ps=77.985u w=76.465u l=1u
X12009 DVDD GATE BAT DVDD pfet_06v0 ad=49.3848p pd=66.5u as=49.3848p ps=66.5u w=64.98u l=1u
X12010 BAT GATE DVDD DVDD pfet_06v0 ad=58.1134p pd=77.985u as=71.8771p ps=0.15481m w=76.465u l=1u
X12011 DVDD GATE BAT DVDD pfet_06v0 ad=35.511p pd=48.245u as=35.511p ps=48.245u w=46.725u l=1u
X12012 BAT GATE DVDD DVDD pfet_06v0 ad=49.3848p pd=66.5u as=49.3848p ps=66.5u w=64.98u l=1u
X12013 DVDD GATE BAT DVDD pfet_06v0 ad=58.0754p pd=77.935u as=58.0754p ps=77.935u w=76.41499u l=1u
X12014 DVDD GATE BAT DVDD pfet_06v0 ad=35.511p pd=48.245u as=35.511p ps=48.245u w=46.725u l=1u
X12015 BAT GATE DVDD DVDD pfet_06v0 ad=35.511p pd=48.245u as=35.511p ps=48.245u w=46.725u l=1u
X12016 BAT GATE DVDD DVDD pfet_06v0 ad=58.1552p pd=78.04u as=58.1552p ps=78.04u w=76.52u l=1u
X12017 DVDD GATE BAT DVDD pfet_06v0 ad=58.1134p pd=77.985u as=58.1134p ps=77.985u w=76.465u l=1u
X12018 BAT GATE DVDD DVDD pfet_06v0 ad=58.1134p pd=77.985u as=58.1134p ps=77.985u w=76.465u l=1u
X12019 DVDD GATE BAT DVDD pfet_06v0 ad=35.511p pd=48.245u as=35.511p ps=48.245u w=46.725u l=1u
X12020 DVDD GATE BAT DVDD pfet_06v0 ad=35.511p pd=48.245u as=35.511p ps=48.245u w=46.725u l=1u
X12021 DVDD GATE BAT DVDD pfet_06v0 ad=35.511p pd=48.245u as=35.511p ps=48.245u w=46.725u l=1u
X12022 BAT GATE DVDD DVDD pfet_06v0 ad=35.511p pd=48.245u as=35.511p ps=48.245u w=46.725u l=1u
X12023 BAT GATE DVDD DVDD pfet_06v0 ad=58.1134p pd=77.985u as=58.1134p ps=77.985u w=76.465u l=1u
X12024 DVDD GATE BAT DVDD pfet_06v0 ad=43.9215p pd=95.32999u as=35.511p ps=48.245u w=46.725u l=1u
X12025 BAT GATE DVDD DVDD pfet_06v0 ad=35.511p pd=48.245u as=35.511p ps=48.245u w=46.725u l=1u
X12026 BAT GATE DVDD DVDD pfet_06v0 ad=58.1134p pd=77.985u as=58.1134p ps=77.985u w=76.465u l=1u
X12027 BAT GATE DVDD DVDD pfet_06v0 ad=35.511p pd=48.245u as=35.511p ps=48.245u w=46.725u l=1u
X12028 DVDD GATE BAT DVDD pfet_06v0 ad=35.511p pd=48.245u as=35.511p ps=48.245u w=46.725u l=1u
X12029 DVDD GATE BAT DVDD pfet_06v0 ad=71.8301p pd=0.15471m as=58.0754p ps=77.935u w=76.41499u l=1u
X12030 BAT GATE DVDD DVDD pfet_06v0 ad=58.1134p pd=77.985u as=58.1134p ps=77.985u w=76.465u l=1u
X12031 DVDD GATE BAT DVDD pfet_06v0 ad=58.1134p pd=77.985u as=58.1134p ps=77.985u w=76.465u l=1u
X12032 BAT GATE DVDD DVDD pfet_06v0 ad=47.6862p pd=64.265u as=47.6862p ps=64.265u w=62.745u l=1u
X12033 BAT GATE DVDD DVDD pfet_06v0 ad=58.1134p pd=77.985u as=58.1134p ps=77.985u w=76.465u l=1u
X12034 BAT GATE DVDD DVDD pfet_06v0 ad=58.1134p pd=77.985u as=58.1134p ps=77.985u w=76.465u l=1u
X12035 DVDD GATE BAT DVDD pfet_06v0 ad=35.511p pd=48.245u as=35.511p ps=48.245u w=46.725u l=1u
X12036 BAT GATE DVDD DVDD pfet_06v0 ad=35.511p pd=48.245u as=43.9215p ps=95.32999u w=46.725u l=1u
X12037 BAT GATE DVDD DVDD pfet_06v0 ad=35.511p pd=48.245u as=43.9215p ps=95.32999u w=46.725u l=1u
X12038 BAT GATE DVDD DVDD pfet_06v0 ad=35.511p pd=48.245u as=35.511p ps=48.245u w=46.725u l=1u
X12039 BAT GATE DVDD DVDD pfet_06v0 ad=35.511p pd=48.245u as=35.511p ps=48.245u w=46.725u l=1u
X12040 BAT GATE DVDD DVDD pfet_06v0 ad=58.1552p pd=78.04u as=71.92879p ps=0.15492m w=76.52u l=1u
X12041 DVDD GATE BAT DVDD pfet_06v0 ad=58.1134p pd=77.985u as=58.1134p ps=77.985u w=76.465u l=1u
X12042 BAT GATE DVDD DVDD pfet_06v0 ad=35.511p pd=48.245u as=35.511p ps=48.245u w=46.725u l=1u
X12043 DVDD GATE BAT DVDD pfet_06v0 ad=58.1134p pd=77.985u as=58.1134p ps=77.985u w=76.465u l=1u
X12044 DVDD GATE BAT DVDD pfet_06v0 ad=58.1134p pd=77.985u as=58.1134p ps=77.985u w=76.465u l=1u
X12045 BAT GATE DVDD DVDD pfet_06v0 ad=35.511p pd=48.245u as=35.511p ps=48.245u w=46.725u l=1u
X12046 BAT GATE DVDD DVDD pfet_06v0 ad=58.1134p pd=77.985u as=58.1134p ps=77.985u w=76.465u l=1u
X12047 DVDD GATE BAT DVDD pfet_06v0 ad=58.1134p pd=77.985u as=58.1134p ps=77.985u w=76.465u l=1u
X12048 BAT GATE DVDD DVDD pfet_06v0 ad=58.0754p pd=77.935u as=58.0754p ps=77.935u w=76.41499u l=1u
X12049 BAT GATE DVDD DVDD pfet_06v0 ad=47.6862p pd=64.265u as=47.6862p ps=64.265u w=62.745u l=1u
X12050 DVDD GATE BAT DVDD pfet_06v0 ad=35.511p pd=48.245u as=35.511p ps=48.245u w=46.725u l=1u
X12051 BAT GATE DVDD DVDD pfet_06v0 ad=58.1134p pd=77.985u as=71.8771p ps=0.15481m w=76.465u l=1u
X12052 BAT GATE DVDD DVDD pfet_06v0 ad=58.1134p pd=77.985u as=58.1134p ps=77.985u w=76.465u l=1u
X12053 DVDD GATE BAT DVDD pfet_06v0 ad=49.3848p pd=66.5u as=49.3848p ps=66.5u w=64.98u l=1u
X12054 DVDD GATE BAT DVDD pfet_06v0 ad=35.511p pd=48.245u as=35.511p ps=48.245u w=46.725u l=1u
X12055 BAT GATE DVDD DVDD pfet_06v0 ad=35.5072p pd=48.24u as=35.5072p ps=48.24u w=46.72u l=1u
X12056 DVDD GATE BAT DVDD pfet_06v0 ad=43.9215p pd=95.32999u as=35.511p ps=48.245u w=46.725u l=1u
X12057 BAT GATE DVDD DVDD pfet_06v0 ad=58.1134p pd=77.985u as=58.1134p ps=77.985u w=76.465u l=1u
X12058 DVDD GATE BAT DVDD pfet_06v0 ad=71.8724p pd=0.1548m as=58.1096p ps=77.98u w=76.46u l=1u
X12059 DVDD GATE BAT DVDD pfet_06v0 ad=35.511p pd=48.245u as=35.511p ps=48.245u w=46.725u l=1u
X12060 BAT GATE DVDD DVDD pfet_06v0 ad=58.1134p pd=77.985u as=58.1134p ps=77.985u w=76.465u l=1u
X12061 DVDD GATE BAT DVDD pfet_06v0 ad=35.511p pd=48.245u as=35.511p ps=48.245u w=46.725u l=1u
X12062 BAT GATE DVDD DVDD pfet_06v0 ad=47.6862p pd=64.265u as=47.6862p ps=64.265u w=62.745u l=1u
X12063 BAT GATE DVDD DVDD pfet_06v0 ad=35.511p pd=48.245u as=35.511p ps=48.245u w=46.725u l=1u
X12064 BAT GATE DVDD DVDD pfet_06v0 ad=58.1134p pd=77.985u as=58.1134p ps=77.985u w=76.465u l=1u
X12065 DVDD GATE BAT DVDD pfet_06v0 ad=71.8771p pd=0.15481m as=58.1134p ps=77.985u w=76.465u l=1u
X12066 DVDD GATE BAT DVDD pfet_06v0 ad=43.9168p pd=95.32u as=35.5072p ps=48.24u w=46.72u l=1u
X12067 BAT GATE DVDD DVDD pfet_06v0 ad=35.511p pd=48.245u as=35.511p ps=48.245u w=46.725u l=1u
X12068 BAT GATE DVDD DVDD pfet_06v0 ad=35.511p pd=48.245u as=35.511p ps=48.245u w=46.725u l=1u
X12069 DVDD GATE BAT DVDD pfet_06v0 ad=35.5072p pd=48.24u as=35.5072p ps=48.24u w=46.72u l=1u
X12070 DVDD GATE BAT DVDD pfet_06v0 ad=43.9215p pd=95.32999u as=35.511p ps=48.245u w=46.725u l=1u
X12071 BAT GATE DVDD DVDD pfet_06v0 ad=58.1096p pd=77.98u as=58.1096p ps=77.98u w=76.46u l=1u
X12072 BAT GATE DVDD DVDD pfet_06v0 ad=58.1134p pd=77.985u as=58.1134p ps=77.985u w=76.465u l=1u
X12073 BAT GATE DVDD DVDD pfet_06v0 ad=35.5072p pd=48.24u as=43.9168p ps=95.32u w=46.72u l=1u
X12074 DVDD GATE BAT DVDD pfet_06v0 ad=35.511p pd=48.245u as=35.511p ps=48.245u w=46.725u l=1u
X12075 BAT GATE DVDD DVDD pfet_06v0 ad=58.1134p pd=77.985u as=58.1134p ps=77.985u w=76.465u l=1u
X12076 DVDD GATE BAT DVDD pfet_06v0 ad=35.511p pd=48.245u as=35.511p ps=48.245u w=46.725u l=1u
X12077 DVDD GATE BAT DVDD pfet_06v0 ad=35.511p pd=48.245u as=35.511p ps=48.245u w=46.725u l=1u
X12078 BAT GATE DVDD DVDD pfet_06v0 ad=58.1552p pd=78.04u as=58.1552p ps=78.04u w=76.52u l=1u
X12079 DVDD GATE BAT DVDD pfet_06v0 ad=35.511p pd=48.245u as=35.511p ps=48.245u w=46.725u l=1u
X12080 DVDD GATE BAT DVDD pfet_06v0 ad=35.511p pd=48.245u as=35.511p ps=48.245u w=46.725u l=1u
X12081 DVDD GATE BAT DVDD pfet_06v0 ad=71.8301p pd=0.15471m as=58.0754p ps=77.935u w=76.41499u l=1u
X12082 BAT GATE DVDD DVDD pfet_06v0 ad=58.1134p pd=77.985u as=58.1134p ps=77.985u w=76.465u l=1u
X12083 BAT GATE DVDD DVDD pfet_06v0 ad=58.1172p pd=77.99u as=58.1172p ps=77.99u w=76.47u l=1u
X12084 BAT GATE DVDD DVDD pfet_06v0 ad=58.1134p pd=77.985u as=58.1134p ps=77.985u w=76.465u l=1u
X12085 DVDD GATE BAT DVDD pfet_06v0 ad=35.511p pd=48.245u as=35.511p ps=48.245u w=46.725u l=1u
X12086 BAT GATE DVDD DVDD pfet_06v0 ad=58.1134p pd=77.985u as=58.1134p ps=77.985u w=76.465u l=1u
X12087 BAT GATE DVDD DVDD pfet_06v0 ad=35.511p pd=48.245u as=35.511p ps=48.245u w=46.725u l=1u
X12088 BAT GATE DVDD DVDD pfet_06v0 ad=35.511p pd=48.245u as=35.511p ps=48.245u w=46.725u l=1u
X12089 DVDD GATE BAT DVDD pfet_06v0 ad=71.8724p pd=0.1548m as=58.1096p ps=77.98u w=76.46u l=1u
X12090 DVDD GATE BAT DVDD pfet_06v0 ad=35.511p pd=48.245u as=35.511p ps=48.245u w=46.725u l=1u
X12091 DVDD GATE BAT DVDD pfet_06v0 ad=58.1134p pd=77.985u as=58.1134p ps=77.985u w=76.465u l=1u
X12092 BAT GATE DVDD DVDD pfet_06v0 ad=58.0754p pd=77.935u as=58.0754p ps=77.935u w=76.41499u l=1u
X12093 BAT GATE DVDD DVDD pfet_06v0 ad=58.1134p pd=77.985u as=58.1134p ps=77.985u w=76.465u l=1u
X12094 DVDD GATE BAT DVDD pfet_06v0 ad=58.1096p pd=77.98u as=58.1096p ps=77.98u w=76.46u l=1u
X12095 DVDD GATE BAT DVDD pfet_06v0 ad=43.9215p pd=95.32999u as=35.511p ps=48.245u w=46.725u l=1u
X12096 DVDD GATE BAT DVDD pfet_06v0 ad=43.9215p pd=95.32999u as=35.511p ps=48.245u w=46.725u l=1u
X12097 DVDD GATE BAT DVDD pfet_06v0 ad=58.1134p pd=77.985u as=58.1134p ps=77.985u w=76.465u l=1u
X12098 DVDD GATE BAT DVDD pfet_06v0 ad=43.9215p pd=95.32999u as=35.511p ps=48.245u w=46.725u l=1u
X12099 BAT GATE DVDD DVDD pfet_06v0 ad=35.511p pd=48.245u as=35.511p ps=48.245u w=46.725u l=1u
X12100 BAT GATE DVDD DVDD pfet_06v0 ad=58.1172p pd=77.99u as=58.1172p ps=77.99u w=76.47u l=1u
X12101 BAT GATE DVDD DVDD pfet_06v0 ad=35.511p pd=48.245u as=35.511p ps=48.245u w=46.725u l=1u
X12102 DVDD GATE BAT DVDD pfet_06v0 ad=71.8771p pd=0.15481m as=58.1134p ps=77.985u w=76.465u l=1u
X12103 DVDD GATE BAT DVDD pfet_06v0 ad=43.9215p pd=95.32999u as=35.511p ps=48.245u w=46.725u l=1u
X12104 DVDD GATE BAT DVDD pfet_06v0 ad=43.9168p pd=95.32u as=35.5072p ps=48.24u w=46.72u l=1u
X12105 DVDD GATE BAT DVDD pfet_06v0 ad=58.1134p pd=77.985u as=58.1134p ps=77.985u w=76.465u l=1u
X12106 DVDD GATE BAT DVDD pfet_06v0 ad=35.511p pd=48.245u as=35.511p ps=48.245u w=46.725u l=1u
X12107 BAT GATE DVDD DVDD pfet_06v0 ad=35.511p pd=48.245u as=35.511p ps=48.245u w=46.725u l=1u
X12108 BAT GATE DVDD DVDD pfet_06v0 ad=58.1552p pd=78.04u as=58.1552p ps=78.04u w=76.52u l=1u
X12109 BAT GATE DVDD DVDD pfet_06v0 ad=35.511p pd=48.245u as=35.511p ps=48.245u w=46.725u l=1u
X12110 DVDD GATE BAT DVDD pfet_06v0 ad=35.511p pd=48.245u as=35.511p ps=48.245u w=46.725u l=1u
X12111 BAT GATE DVDD DVDD pfet_06v0 ad=35.511p pd=48.245u as=43.9215p ps=95.32999u w=46.725u l=1u
X12112 BAT GATE DVDD DVDD pfet_06v0 ad=35.511p pd=48.245u as=35.511p ps=48.245u w=46.725u l=1u
X12113 DVDD GATE BAT DVDD pfet_06v0 ad=43.9215p pd=95.32999u as=35.511p ps=48.245u w=46.725u l=1u
X12114 DVDD GATE BAT DVDD pfet_06v0 ad=49.3848p pd=66.5u as=49.3848p ps=66.5u w=64.98u l=1u
X12115 DVDD GATE BAT DVDD pfet_06v0 ad=58.0754p pd=77.935u as=58.0754p ps=77.935u w=76.41499u l=1u
X12116 DVDD GATE BAT DVDD pfet_06v0 ad=58.1552p pd=78.04u as=58.1552p ps=78.04u w=76.52u l=1u
X12117 DVDD GATE BAT DVDD pfet_06v0 ad=58.1134p pd=77.985u as=58.1134p ps=77.985u w=76.465u l=1u
X12118 BAT GATE DVDD DVDD pfet_06v0 ad=35.511p pd=48.245u as=35.511p ps=48.245u w=46.725u l=1u
X12119 DVDD GATE BAT DVDD pfet_06v0 ad=35.511p pd=48.245u as=35.511p ps=48.245u w=46.725u l=1u
X12120 BAT GATE DVDD DVDD pfet_06v0 ad=47.6862p pd=64.265u as=58.9803p ps=0.12737m w=62.745u l=1u
X12121 BAT GATE DVDD DVDD pfet_06v0 ad=35.511p pd=48.245u as=35.511p ps=48.245u w=46.725u l=1u
X12122 DVDD GATE BAT DVDD pfet_06v0 ad=58.1134p pd=77.985u as=58.1134p ps=77.985u w=76.465u l=1u
X12123 BAT GATE DVDD DVDD pfet_06v0 ad=58.1552p pd=78.04u as=58.1552p ps=78.04u w=76.52u l=1u
X12124 DVDD GATE BAT DVDD pfet_06v0 ad=58.9803p pd=0.12737m as=47.6862p ps=64.265u w=62.745u l=1u
X12125 BAT GATE DVDD DVDD pfet_06v0 ad=58.1134p pd=77.985u as=58.1134p ps=77.985u w=76.465u l=1u
X12126 DVDD GATE BAT DVDD pfet_06v0 ad=58.1134p pd=77.985u as=58.1134p ps=77.985u w=76.465u l=1u
X12127 BAT GATE DVDD DVDD pfet_06v0 ad=58.1134p pd=77.985u as=71.8771p ps=0.15481m w=76.465u l=1u
X12128 BAT GATE DVDD DVDD pfet_06v0 ad=49.3848p pd=66.5u as=49.3848p ps=66.5u w=64.98u l=1u
X12129 DVDD GATE BAT DVDD pfet_06v0 ad=58.1134p pd=77.985u as=58.1134p ps=77.985u w=76.465u l=1u
X12130 DVDD GATE BAT DVDD pfet_06v0 ad=58.1134p pd=77.985u as=58.1134p ps=77.985u w=76.465u l=1u
X12131 DVDD GATE BAT DVDD pfet_06v0 ad=58.1134p pd=77.985u as=58.1134p ps=77.985u w=76.465u l=1u
X12132 DVDD GATE BAT DVDD pfet_06v0 ad=58.1134p pd=77.985u as=58.1134p ps=77.985u w=76.465u l=1u
X12133 DVDD GATE BAT DVDD pfet_06v0 ad=58.1172p pd=77.99u as=58.1172p ps=77.99u w=76.47u l=1u
X12134 DVDD GATE BAT DVDD pfet_06v0 ad=58.1134p pd=77.985u as=58.1134p ps=77.985u w=76.465u l=1u
X12135 DVDD GATE BAT DVDD pfet_06v0 ad=58.1134p pd=77.985u as=58.1134p ps=77.985u w=76.465u l=1u
X12136 DVDD GATE BAT DVDD pfet_06v0 ad=43.9215p pd=95.32999u as=35.511p ps=48.245u w=46.725u l=1u
X12137 BAT GATE DVDD DVDD pfet_06v0 ad=35.511p pd=48.245u as=35.511p ps=48.245u w=46.725u l=1u
X12138 DVDD GATE BAT DVDD pfet_06v0 ad=58.1134p pd=77.985u as=58.1134p ps=77.985u w=76.465u l=1u
X12139 BAT GATE DVDD DVDD pfet_06v0 ad=58.1134p pd=77.985u as=58.1134p ps=77.985u w=76.465u l=1u
X12140 BAT GATE DVDD DVDD pfet_06v0 ad=58.1172p pd=77.99u as=58.1172p ps=77.99u w=76.47u l=1u
X12141 BAT GATE DVDD DVDD pfet_06v0 ad=58.1134p pd=77.985u as=58.1134p ps=77.985u w=76.465u l=1u
X12142 DVDD GATE BAT DVDD pfet_06v0 ad=58.1552p pd=78.04u as=58.1552p ps=78.04u w=76.52u l=1u
X12143 DVDD GATE BAT DVDD pfet_06v0 ad=71.8771p pd=0.15481m as=58.1134p ps=77.985u w=76.465u l=1u
X12144 DVDD GATE BAT DVDD pfet_06v0 ad=49.3848p pd=66.5u as=49.3848p ps=66.5u w=64.98u l=1u
X12145 BAT GATE DVDD DVDD pfet_06v0 ad=58.1134p pd=77.985u as=58.1134p ps=77.985u w=76.465u l=1u
X12146 DVDD GATE BAT DVDD pfet_06v0 ad=35.511p pd=48.245u as=35.511p ps=48.245u w=46.725u l=1u
X12147 DVDD GATE BAT DVDD pfet_06v0 ad=71.8724p pd=0.1548m as=58.1096p ps=77.98u w=76.46u l=1u
X12148 BAT GATE DVDD DVDD pfet_06v0 ad=58.1134p pd=77.985u as=58.1134p ps=77.985u w=76.465u l=1u
X12149 BAT GATE DVDD DVDD pfet_06v0 ad=35.511p pd=48.245u as=35.511p ps=48.245u w=46.725u l=1u
X12150 DVDD GATE BAT DVDD pfet_06v0 ad=35.511p pd=48.245u as=35.511p ps=48.245u w=46.725u l=1u
X12151 DVDD GATE BAT DVDD pfet_06v0 ad=71.8771p pd=0.15481m as=58.1134p ps=77.985u w=76.465u l=1u
X12152 BAT GATE DVDD DVDD pfet_06v0 ad=58.1134p pd=77.985u as=58.1134p ps=77.985u w=76.465u l=1u
X12153 DVDD GATE BAT DVDD pfet_06v0 ad=35.511p pd=48.245u as=35.511p ps=48.245u w=46.725u l=1u
X12154 DVDD GATE BAT DVDD pfet_06v0 ad=58.1552p pd=78.04u as=58.1552p ps=78.04u w=76.52u l=1u
X12155 BAT GATE DVDD DVDD pfet_06v0 ad=58.1134p pd=77.985u as=58.1134p ps=77.985u w=76.465u l=1u
X12156 BAT GATE DVDD DVDD pfet_06v0 ad=35.511p pd=48.245u as=35.511p ps=48.245u w=46.725u l=1u
X12157 BAT GATE DVDD DVDD pfet_06v0 ad=58.1552p pd=78.04u as=71.92879p ps=0.15492m w=76.52u l=1u
X12158 BAT GATE DVDD DVDD pfet_06v0 ad=35.511p pd=48.245u as=35.511p ps=48.245u w=46.725u l=1u
X12159 DVDD GATE BAT DVDD pfet_06v0 ad=58.1134p pd=77.985u as=58.1134p ps=77.985u w=76.465u l=1u
X12160 BAT GATE DVDD DVDD pfet_06v0 ad=35.511p pd=48.245u as=43.9215p ps=95.32999u w=46.725u l=1u
X12161 DVDD GATE BAT DVDD pfet_06v0 ad=35.511p pd=48.245u as=35.511p ps=48.245u w=46.725u l=1u
X12162 BAT GATE DVDD DVDD pfet_06v0 ad=58.1134p pd=77.985u as=58.1134p ps=77.985u w=76.465u l=1u
X12163 DVDD GATE BAT DVDD pfet_06v0 ad=58.1134p pd=77.985u as=58.1134p ps=77.985u w=76.465u l=1u
X12164 DVDD GATE BAT DVDD pfet_06v0 ad=35.511p pd=48.245u as=35.511p ps=48.245u w=46.725u l=1u
X12165 BAT GATE DVDD DVDD pfet_06v0 ad=58.1096p pd=77.98u as=58.1096p ps=77.98u w=76.46u l=1u
X12166 BAT GATE DVDD DVDD pfet_06v0 ad=49.3848p pd=66.5u as=61.0812p ps=0.13184m w=64.98u l=1u
X12167 DVDD GATE BAT DVDD pfet_06v0 ad=58.1096p pd=77.98u as=58.1096p ps=77.98u w=76.46u l=1u
X12168 DVDD GATE BAT DVDD pfet_06v0 ad=43.9215p pd=95.32999u as=35.511p ps=48.245u w=46.725u l=1u
X12169 BAT GATE DVDD DVDD pfet_06v0 ad=35.511p pd=48.245u as=35.511p ps=48.245u w=46.725u l=1u
X12170 BAT GATE DVDD DVDD pfet_06v0 ad=58.0754p pd=77.935u as=58.0754p ps=77.935u w=76.41499u l=1u
X12171 DVDD GATE BAT DVDD pfet_06v0 ad=35.511p pd=48.245u as=35.511p ps=48.245u w=46.725u l=1u
X12172 BAT GATE DVDD DVDD pfet_06v0 ad=58.1134p pd=77.985u as=58.1134p ps=77.985u w=76.465u l=1u
X12173 DVDD GATE BAT DVDD pfet_06v0 ad=58.1134p pd=77.985u as=58.1134p ps=77.985u w=76.465u l=1u
X12174 DVDD GATE BAT DVDD pfet_06v0 ad=35.511p pd=48.245u as=35.511p ps=48.245u w=46.725u l=1u
X12175 BAT GATE DVDD DVDD pfet_06v0 ad=49.3848p pd=66.5u as=49.3848p ps=66.5u w=64.98u l=1u
X12176 DVDD GATE BAT DVDD pfet_06v0 ad=43.9215p pd=95.32999u as=35.511p ps=48.245u w=46.725u l=1u
X12177 BAT GATE DVDD DVDD pfet_06v0 ad=35.511p pd=48.245u as=43.9215p ps=95.32999u w=46.725u l=1u
X12178 DVDD GATE BAT DVDD pfet_06v0 ad=58.1134p pd=77.985u as=58.1134p ps=77.985u w=76.465u l=1u
X12179 DVDD GATE BAT DVDD pfet_06v0 ad=47.6862p pd=64.265u as=47.6862p ps=64.265u w=62.745u l=1u
X12180 BAT GATE DVDD DVDD pfet_06v0 ad=35.511p pd=48.245u as=35.511p ps=48.245u w=46.725u l=1u
X12181 DVDD GATE BAT DVDD pfet_06v0 ad=58.1172p pd=77.99u as=58.1172p ps=77.99u w=76.47u l=1u
X12182 DVDD GATE BAT DVDD pfet_06v0 ad=35.511p pd=48.245u as=35.511p ps=48.245u w=46.725u l=1u
X12183 DVDD GATE BAT DVDD pfet_06v0 ad=43.9215p pd=95.32999u as=35.511p ps=48.245u w=46.725u l=1u
X12184 BAT GATE DVDD DVDD pfet_06v0 ad=35.511p pd=48.245u as=35.511p ps=48.245u w=46.725u l=1u
X12185 BAT GATE DVDD DVDD pfet_06v0 ad=58.1134p pd=77.985u as=58.1134p ps=77.985u w=76.465u l=1u
X12186 DVDD GATE BAT DVDD pfet_06v0 ad=71.8301p pd=0.15471m as=58.0754p ps=77.935u w=76.41499u l=1u
X12187 DVDD GATE BAT DVDD pfet_06v0 ad=43.9215p pd=95.32999u as=35.511p ps=48.245u w=46.725u l=1u
X12188 BAT GATE DVDD DVDD pfet_06v0 ad=47.6862p pd=64.265u as=47.6862p ps=64.265u w=62.745u l=1u
X12189 DVDD GATE BAT DVDD pfet_06v0 ad=58.1134p pd=77.985u as=58.1134p ps=77.985u w=76.465u l=1u
X12190 BAT GATE DVDD DVDD pfet_06v0 ad=35.511p pd=48.245u as=35.511p ps=48.245u w=46.725u l=1u
X12191 BAT GATE DVDD DVDD pfet_06v0 ad=58.1134p pd=77.985u as=58.1134p ps=77.985u w=76.465u l=1u
X12192 DVDD GATE BAT DVDD pfet_06v0 ad=58.1134p pd=77.985u as=58.1134p ps=77.985u w=76.465u l=1u
X12193 BAT GATE DVDD DVDD pfet_06v0 ad=35.511p pd=48.245u as=35.511p ps=48.245u w=46.725u l=1u
X12194 BAT GATE DVDD DVDD pfet_06v0 ad=35.511p pd=48.245u as=43.9215p ps=95.32999u w=46.725u l=1u
X12195 DVDD GATE BAT DVDD pfet_06v0 ad=35.511p pd=48.245u as=35.511p ps=48.245u w=46.725u l=1u
X12196 DVDD GATE BAT DVDD pfet_06v0 ad=58.1172p pd=77.99u as=58.1172p ps=77.99u w=76.47u l=1u
X12197 DVDD GATE BAT DVDD pfet_06v0 ad=35.511p pd=48.245u as=35.511p ps=48.245u w=46.725u l=1u
X12198 BAT GATE DVDD DVDD pfet_06v0 ad=35.511p pd=48.245u as=35.511p ps=48.245u w=46.725u l=1u
X12199 BAT GATE DVDD DVDD pfet_06v0 ad=58.1134p pd=77.985u as=58.1134p ps=77.985u w=76.465u l=1u
X12200 DVDD GATE BAT DVDD pfet_06v0 ad=58.0754p pd=77.935u as=58.0754p ps=77.935u w=76.41499u l=1u
X12201 DVDD GATE BAT DVDD pfet_06v0 ad=35.511p pd=48.245u as=35.511p ps=48.245u w=46.725u l=1u
X12202 BAT GATE DVDD DVDD pfet_06v0 ad=35.511p pd=48.245u as=35.511p ps=48.245u w=46.725u l=1u
X12203 BAT GATE DVDD DVDD pfet_06v0 ad=58.1096p pd=77.98u as=58.1096p ps=77.98u w=76.46u l=1u
X12204 DVDD GATE BAT DVDD pfet_06v0 ad=58.1172p pd=77.99u as=58.1172p ps=77.99u w=76.47u l=1u
X12205 BAT GATE DVDD DVDD pfet_06v0 ad=35.511p pd=48.245u as=35.511p ps=48.245u w=46.725u l=1u
X12206 DVDD GATE BAT DVDD pfet_06v0 ad=71.8771p pd=0.15481m as=58.1134p ps=77.985u w=76.465u l=1u
X12207 DVDD GATE BAT DVDD pfet_06v0 ad=49.3848p pd=66.5u as=49.3848p ps=66.5u w=64.98u l=1u
X12208 DVDD GATE BAT DVDD pfet_06v0 ad=58.1172p pd=77.99u as=58.1172p ps=77.99u w=76.47u l=1u
X12209 DVDD GATE BAT DVDD pfet_06v0 ad=43.9168p pd=95.32u as=35.5072p ps=48.24u w=46.72u l=1u
X12210 DVDD GATE BAT DVDD pfet_06v0 ad=35.511p pd=48.245u as=35.511p ps=48.245u w=46.725u l=1u
X12211 BAT GATE DVDD DVDD pfet_06v0 ad=35.511p pd=48.245u as=35.511p ps=48.245u w=46.725u l=1u
X12212 DVDD GATE BAT DVDD pfet_06v0 ad=35.511p pd=48.245u as=35.511p ps=48.245u w=46.725u l=1u
X12213 BAT GATE DVDD DVDD pfet_06v0 ad=58.1134p pd=77.985u as=71.8771p ps=0.15481m w=76.465u l=1u
X12214 BAT GATE DVDD DVDD pfet_06v0 ad=35.511p pd=48.245u as=35.511p ps=48.245u w=46.725u l=1u
X12215 BAT GATE DVDD DVDD pfet_06v0 ad=35.5072p pd=48.24u as=35.5072p ps=48.24u w=46.72u l=1u
X12216 BAT GATE DVDD DVDD pfet_06v0 ad=58.1134p pd=77.985u as=58.1134p ps=77.985u w=76.465u l=1u
X12217 DVDD GATE BAT DVDD pfet_06v0 ad=35.511p pd=48.245u as=35.511p ps=48.245u w=46.725u l=1u
X12218 DVDD GATE BAT DVDD pfet_06v0 ad=35.511p pd=48.245u as=35.511p ps=48.245u w=46.725u l=1u
X12219 DVDD GATE BAT DVDD pfet_06v0 ad=58.1552p pd=78.04u as=58.1552p ps=78.04u w=76.52u l=1u
X12220 DVDD GATE BAT DVDD pfet_06v0 ad=58.1134p pd=77.985u as=58.1134p ps=77.985u w=76.465u l=1u
X12221 BAT GATE DVDD DVDD pfet_06v0 ad=58.1134p pd=77.985u as=71.8771p ps=0.15481m w=76.465u l=1u
X12222 BAT GATE DVDD DVDD pfet_06v0 ad=58.0754p pd=77.935u as=71.8301p ps=0.15471m w=76.41499u l=1u
X12223 BAT GATE DVDD DVDD pfet_06v0 ad=58.1552p pd=78.04u as=58.1552p ps=78.04u w=76.52u l=1u
X12224 BAT GATE DVDD DVDD pfet_06v0 ad=58.1134p pd=77.985u as=58.1134p ps=77.985u w=76.465u l=1u
X12225 BAT GATE DVDD DVDD pfet_06v0 ad=35.511p pd=48.245u as=35.511p ps=48.245u w=46.725u l=1u
X12226 BAT GATE DVDD DVDD pfet_06v0 ad=35.511p pd=48.245u as=35.511p ps=48.245u w=46.725u l=1u
X12227 DVDD GATE BAT DVDD pfet_06v0 ad=43.9215p pd=95.32999u as=35.511p ps=48.245u w=46.725u l=1u
X12228 BAT GATE DVDD DVDD pfet_06v0 ad=58.1134p pd=77.985u as=58.1134p ps=77.985u w=76.465u l=1u
X12229 DVDD GATE BAT DVDD pfet_06v0 ad=58.1552p pd=78.04u as=58.1552p ps=78.04u w=76.52u l=1u
X12230 BAT GATE DVDD DVDD pfet_06v0 ad=35.511p pd=48.245u as=35.511p ps=48.245u w=46.725u l=1u
X12231 DVDD GATE BAT DVDD pfet_06v0 ad=58.1552p pd=78.04u as=58.1552p ps=78.04u w=76.52u l=1u
X12232 DVDD GATE BAT DVDD pfet_06v0 ad=35.511p pd=48.245u as=35.511p ps=48.245u w=46.725u l=1u
X12233 BAT GATE DVDD DVDD pfet_06v0 ad=58.1134p pd=77.985u as=71.8771p ps=0.15481m w=76.465u l=1u
X12234 BAT GATE DVDD DVDD pfet_06v0 ad=58.1172p pd=77.99u as=58.1172p ps=77.99u w=76.47u l=1u
X12235 DVDD GATE BAT DVDD pfet_06v0 ad=58.0754p pd=77.935u as=58.0754p ps=77.935u w=76.41499u l=1u
X12236 BAT GATE DVDD DVDD pfet_06v0 ad=58.1134p pd=77.985u as=58.1134p ps=77.985u w=76.465u l=1u
X12237 DVDD GATE BAT DVDD pfet_06v0 ad=35.511p pd=48.245u as=35.511p ps=48.245u w=46.725u l=1u
X12238 BAT GATE DVDD DVDD pfet_06v0 ad=58.1134p pd=77.985u as=58.1134p ps=77.985u w=76.465u l=1u
X12239 BAT GATE DVDD DVDD pfet_06v0 ad=35.511p pd=48.245u as=35.511p ps=48.245u w=46.725u l=1u
X12240 BAT GATE DVDD DVDD pfet_06v0 ad=58.1134p pd=77.985u as=58.1134p ps=77.985u w=76.465u l=1u
X12241 BAT GATE DVDD DVDD pfet_06v0 ad=58.1134p pd=77.985u as=58.1134p ps=77.985u w=76.465u l=1u
X12242 DVDD GATE BAT DVDD pfet_06v0 ad=58.1134p pd=77.985u as=58.1134p ps=77.985u w=76.465u l=1u
X12243 DVDD GATE BAT DVDD pfet_06v0 ad=49.3848p pd=66.5u as=49.3848p ps=66.5u w=64.98u l=1u
X12244 BAT GATE DVDD DVDD pfet_06v0 ad=49.3848p pd=66.5u as=49.3848p ps=66.5u w=64.98u l=1u
X12245 BAT GATE DVDD DVDD pfet_06v0 ad=58.0754p pd=77.935u as=58.0754p ps=77.935u w=76.41499u l=1u
X12246 DVDD GATE BAT DVDD pfet_06v0 ad=35.511p pd=48.245u as=35.511p ps=48.245u w=46.725u l=1u
X12247 DVDD GATE BAT DVDD pfet_06v0 ad=58.1552p pd=78.04u as=58.1552p ps=78.04u w=76.52u l=1u
X12248 BAT GATE DVDD DVDD pfet_06v0 ad=58.1552p pd=78.04u as=58.1552p ps=78.04u w=76.52u l=1u
X12249 DVDD GATE BAT DVDD pfet_06v0 ad=58.1134p pd=77.985u as=58.1134p ps=77.985u w=76.465u l=1u
X12250 BAT GATE DVDD DVDD pfet_06v0 ad=35.511p pd=48.245u as=43.9215p ps=95.32999u w=46.725u l=1u
X12251 BAT GATE DVDD DVDD pfet_06v0 ad=58.0754p pd=77.935u as=71.8301p ps=0.15471m w=76.41499u l=1u
X12252 BAT GATE DVDD DVDD pfet_06v0 ad=35.511p pd=48.245u as=35.511p ps=48.245u w=46.725u l=1u
X12253 BAT GATE DVDD DVDD pfet_06v0 ad=58.1096p pd=77.98u as=58.1096p ps=77.98u w=76.46u l=1u
X12254 DVDD GATE BAT DVDD pfet_06v0 ad=35.511p pd=48.245u as=35.511p ps=48.245u w=46.725u l=1u
X12255 DVDD GATE BAT DVDD pfet_06v0 ad=35.511p pd=48.245u as=35.511p ps=48.245u w=46.725u l=1u
X12256 DVDD GATE BAT DVDD pfet_06v0 ad=35.511p pd=48.245u as=35.511p ps=48.245u w=46.725u l=1u
X12257 DVDD GATE BAT DVDD pfet_06v0 ad=58.1134p pd=77.985u as=58.1134p ps=77.985u w=76.465u l=1u
X12258 BAT GATE DVDD DVDD pfet_06v0 ad=35.511p pd=48.245u as=35.511p ps=48.245u w=46.725u l=1u
X12259 BAT GATE DVDD DVDD pfet_06v0 ad=58.1552p pd=78.04u as=58.1552p ps=78.04u w=76.52u l=1u
X12260 DVDD GATE BAT DVDD pfet_06v0 ad=58.1134p pd=77.985u as=58.1134p ps=77.985u w=76.465u l=1u
X12261 BAT GATE DVDD DVDD pfet_06v0 ad=35.511p pd=48.245u as=35.511p ps=48.245u w=46.725u l=1u
X12262 DVDD GATE BAT DVDD pfet_06v0 ad=47.6862p pd=64.265u as=47.6862p ps=64.265u w=62.745u l=1u
X12263 DVDD GATE BAT DVDD pfet_06v0 ad=58.1134p pd=77.985u as=58.1134p ps=77.985u w=76.465u l=1u
X12264 DVDD GATE BAT DVDD pfet_06v0 ad=35.511p pd=48.245u as=35.511p ps=48.245u w=46.725u l=1u
X12265 BAT GATE DVDD DVDD pfet_06v0 ad=58.1134p pd=77.985u as=58.1134p ps=77.985u w=76.465u l=1u
X12266 BAT GATE DVDD DVDD pfet_06v0 ad=35.511p pd=48.245u as=35.511p ps=48.245u w=46.725u l=1u
X12267 BAT GATE DVDD DVDD pfet_06v0 ad=58.1172p pd=77.99u as=58.1172p ps=77.99u w=76.47u l=1u
X12268 BAT GATE DVDD DVDD pfet_06v0 ad=58.1134p pd=77.985u as=58.1134p ps=77.985u w=76.465u l=1u
X12269 BAT GATE DVDD DVDD pfet_06v0 ad=58.1172p pd=77.99u as=58.1172p ps=77.99u w=76.47u l=1u
X12270 DVDD GATE BAT DVDD pfet_06v0 ad=35.511p pd=48.245u as=35.511p ps=48.245u w=46.725u l=1u
X12271 BAT GATE DVDD DVDD pfet_06v0 ad=35.511p pd=48.245u as=35.511p ps=48.245u w=46.725u l=1u
X12272 DVDD GATE BAT DVDD pfet_06v0 ad=58.1134p pd=77.985u as=58.1134p ps=77.985u w=76.465u l=1u
X12273 DVDD GATE BAT DVDD pfet_06v0 ad=49.3848p pd=66.5u as=49.3848p ps=66.5u w=64.98u l=1u
X12274 BAT GATE DVDD DVDD pfet_06v0 ad=35.511p pd=48.245u as=35.511p ps=48.245u w=46.725u l=1u
X12275 DVDD GATE BAT DVDD pfet_06v0 ad=58.1096p pd=77.98u as=58.1096p ps=77.98u w=76.46u l=1u
X12276 DVDD GATE BAT DVDD pfet_06v0 ad=58.1134p pd=77.985u as=58.1134p ps=77.985u w=76.465u l=1u
X12277 DVDD GATE BAT DVDD pfet_06v0 ad=35.511p pd=48.245u as=35.511p ps=48.245u w=46.725u l=1u
X12278 BAT GATE DVDD DVDD pfet_06v0 ad=58.1096p pd=77.98u as=71.8724p ps=0.1548m w=76.46u l=1u
X12279 DVDD GATE BAT DVDD pfet_06v0 ad=71.8818p pd=0.15482m as=58.1172p ps=77.99u w=76.47u l=1u
X12280 BAT GATE DVDD DVDD pfet_06v0 ad=35.511p pd=48.245u as=43.9215p ps=95.32999u w=46.725u l=1u
X12281 DVDD GATE BAT DVDD pfet_06v0 ad=35.5072p pd=48.24u as=35.5072p ps=48.24u w=46.72u l=1u
X12282 DVDD GATE BAT DVDD pfet_06v0 ad=58.1134p pd=77.985u as=58.1134p ps=77.985u w=76.465u l=1u
X12283 DVDD GATE BAT DVDD pfet_06v0 ad=43.9215p pd=95.32999u as=35.511p ps=48.245u w=46.725u l=1u
X12284 BAT GATE DVDD DVDD pfet_06v0 ad=35.511p pd=48.245u as=35.511p ps=48.245u w=46.725u l=1u
X12285 BAT GATE DVDD DVDD pfet_06v0 ad=35.511p pd=48.245u as=35.511p ps=48.245u w=46.725u l=1u
X12286 BAT GATE DVDD DVDD pfet_06v0 ad=35.511p pd=48.245u as=35.511p ps=48.245u w=46.725u l=1u
X12287 DVDD GATE BAT DVDD pfet_06v0 ad=58.1134p pd=77.985u as=58.1134p ps=77.985u w=76.465u l=1u
X12288 BAT GATE DVDD DVDD pfet_06v0 ad=58.1134p pd=77.985u as=71.8771p ps=0.15481m w=76.465u l=1u
X12289 DVDD GATE BAT DVDD pfet_06v0 ad=58.1134p pd=77.985u as=58.1134p ps=77.985u w=76.465u l=1u
X12290 BAT GATE DVDD DVDD pfet_06v0 ad=58.1172p pd=77.99u as=71.8818p ps=0.15482m w=76.47u l=1u
X12291 DVDD GATE BAT DVDD pfet_06v0 ad=71.8771p pd=0.15481m as=58.1134p ps=77.985u w=76.465u l=1u
X12292 BAT GATE DVDD DVDD pfet_06v0 ad=58.0754p pd=77.935u as=58.0754p ps=77.935u w=76.41499u l=1u
X12293 DVDD GATE BAT DVDD pfet_06v0 ad=35.511p pd=48.245u as=35.511p ps=48.245u w=46.725u l=1u
X12294 DVDD GATE BAT DVDD pfet_06v0 ad=35.511p pd=48.245u as=35.511p ps=48.245u w=46.725u l=1u
X12295 DVDD GATE BAT DVDD pfet_06v0 ad=47.6862p pd=64.265u as=47.6862p ps=64.265u w=62.745u l=1u
X12296 BAT GATE DVDD DVDD pfet_06v0 ad=58.1134p pd=77.985u as=58.1134p ps=77.985u w=76.465u l=1u
X12297 BAT GATE DVDD DVDD pfet_06v0 ad=58.1134p pd=77.985u as=58.1134p ps=77.985u w=76.465u l=1u
X12298 BAT GATE DVDD DVDD pfet_06v0 ad=35.511p pd=48.245u as=35.511p ps=48.245u w=46.725u l=1u
X12299 DVDD GATE BAT DVDD pfet_06v0 ad=35.511p pd=48.245u as=35.511p ps=48.245u w=46.725u l=1u
X12300 BAT GATE DVDD DVDD pfet_06v0 ad=35.5072p pd=48.24u as=35.5072p ps=48.24u w=46.72u l=1u
X12301 DVDD GATE BAT DVDD pfet_06v0 ad=58.1134p pd=77.985u as=58.1134p ps=77.985u w=76.465u l=1u
X12302 BAT GATE DVDD DVDD pfet_06v0 ad=35.5072p pd=48.24u as=35.5072p ps=48.24u w=46.72u l=1u
X12303 DVDD GATE BAT DVDD pfet_06v0 ad=58.1134p pd=77.985u as=58.1134p ps=77.985u w=76.465u l=1u
X12304 BAT GATE DVDD DVDD pfet_06v0 ad=58.1172p pd=77.99u as=71.8818p ps=0.15482m w=76.47u l=1u
X12305 DVDD GATE BAT DVDD pfet_06v0 ad=58.1134p pd=77.985u as=58.1134p ps=77.985u w=76.465u l=1u
X12306 BAT GATE DVDD DVDD pfet_06v0 ad=58.1134p pd=77.985u as=58.1134p ps=77.985u w=76.465u l=1u
X12307 DVDD GATE BAT DVDD pfet_06v0 ad=35.511p pd=48.245u as=35.511p ps=48.245u w=46.725u l=1u
X12308 DVDD GATE BAT DVDD pfet_06v0 ad=58.1552p pd=78.04u as=58.1552p ps=78.04u w=76.52u l=1u
X12309 DVDD GATE BAT DVDD pfet_06v0 ad=35.511p pd=48.245u as=35.511p ps=48.245u w=46.725u l=1u
X12310 BAT GATE DVDD DVDD pfet_06v0 ad=35.511p pd=48.245u as=43.9215p ps=95.32999u w=46.725u l=1u
X12311 BAT GATE DVDD DVDD pfet_06v0 ad=58.1552p pd=78.04u as=58.1552p ps=78.04u w=76.52u l=1u
X12312 BAT GATE DVDD DVDD pfet_06v0 ad=58.1134p pd=77.985u as=58.1134p ps=77.985u w=76.465u l=1u
X12313 DVDD GATE BAT DVDD pfet_06v0 ad=58.1134p pd=77.985u as=58.1134p ps=77.985u w=76.465u l=1u
X12314 BAT GATE DVDD DVDD pfet_06v0 ad=35.511p pd=48.245u as=43.9215p ps=95.32999u w=46.725u l=1u
X12315 BAT GATE DVDD DVDD pfet_06v0 ad=58.1134p pd=77.985u as=71.8771p ps=0.15481m w=76.465u l=1u
X12316 BAT GATE DVDD DVDD pfet_06v0 ad=58.1134p pd=77.985u as=58.1134p ps=77.985u w=76.465u l=1u
X12317 BAT GATE DVDD DVDD pfet_06v0 ad=35.511p pd=48.245u as=35.511p ps=48.245u w=46.725u l=1u
X12318 BAT GATE DVDD DVDD pfet_06v0 ad=58.0754p pd=77.935u as=58.0754p ps=77.935u w=76.41499u l=1u
X12319 DVDD GATE BAT DVDD pfet_06v0 ad=58.1172p pd=77.99u as=58.1172p ps=77.99u w=76.47u l=1u
X12320 DVDD GATE BAT DVDD pfet_06v0 ad=35.511p pd=48.245u as=35.511p ps=48.245u w=46.725u l=1u
X12321 BAT GATE DVDD DVDD pfet_06v0 ad=58.1134p pd=77.985u as=58.1134p ps=77.985u w=76.465u l=1u
X12322 BAT GATE DVDD DVDD pfet_06v0 ad=58.1552p pd=78.04u as=58.1552p ps=78.04u w=76.52u l=1u
X12323 DVDD GATE BAT DVDD pfet_06v0 ad=58.1172p pd=77.99u as=58.1172p ps=77.99u w=76.47u l=1u
X12324 BAT GATE DVDD DVDD pfet_06v0 ad=35.511p pd=48.245u as=35.511p ps=48.245u w=46.725u l=1u
X12325 DVDD GATE BAT DVDD pfet_06v0 ad=58.1134p pd=77.985u as=58.1134p ps=77.985u w=76.465u l=1u
X12326 DVDD GATE BAT DVDD pfet_06v0 ad=35.511p pd=48.245u as=35.511p ps=48.245u w=46.725u l=1u
X12327 DVDD GATE BAT DVDD pfet_06v0 ad=58.1552p pd=78.04u as=58.1552p ps=78.04u w=76.52u l=1u
X12328 BAT GATE DVDD DVDD pfet_06v0 ad=49.3848p pd=66.5u as=49.3848p ps=66.5u w=64.98u l=1u
X12329 DVDD GATE BAT DVDD pfet_06v0 ad=58.1134p pd=77.985u as=58.1134p ps=77.985u w=76.465u l=1u
X12330 BAT GATE DVDD DVDD pfet_06v0 ad=58.1134p pd=77.985u as=58.1134p ps=77.985u w=76.465u l=1u
X12331 BAT GATE DVDD DVDD pfet_06v0 ad=58.1134p pd=77.985u as=58.1134p ps=77.985u w=76.465u l=1u
X12332 DVDD GATE BAT DVDD pfet_06v0 ad=35.511p pd=48.245u as=35.511p ps=48.245u w=46.725u l=1u
X12333 BAT GATE DVDD DVDD pfet_06v0 ad=49.3848p pd=66.5u as=49.3848p ps=66.5u w=64.98u l=1u
X12334 DVDD GATE BAT DVDD pfet_06v0 ad=58.0754p pd=77.935u as=58.0754p ps=77.935u w=76.41499u l=1u
X12335 BAT GATE DVDD DVDD pfet_06v0 ad=58.1134p pd=77.985u as=58.1134p ps=77.985u w=76.465u l=1u
X12336 DVDD GATE BAT DVDD pfet_06v0 ad=49.3848p pd=66.5u as=49.3848p ps=66.5u w=64.98u l=1u
X12337 DVDD GATE BAT DVDD pfet_06v0 ad=35.511p pd=48.245u as=35.511p ps=48.245u w=46.725u l=1u
X12338 DVDD GATE BAT DVDD pfet_06v0 ad=35.511p pd=48.245u as=35.511p ps=48.245u w=46.725u l=1u
X12339 DVDD GATE BAT DVDD pfet_06v0 ad=35.511p pd=48.245u as=35.511p ps=48.245u w=46.725u l=1u
X12340 BAT GATE DVDD DVDD pfet_06v0 ad=35.511p pd=48.245u as=35.511p ps=48.245u w=46.725u l=1u
X12341 BAT GATE DVDD DVDD pfet_06v0 ad=58.1134p pd=77.985u as=58.1134p ps=77.985u w=76.465u l=1u
X12342 BAT GATE DVDD DVDD pfet_06v0 ad=35.511p pd=48.245u as=35.511p ps=48.245u w=46.725u l=1u
X12343 BAT GATE DVDD DVDD pfet_06v0 ad=58.1134p pd=77.985u as=58.1134p ps=77.985u w=76.465u l=1u
X12344 DVDD GATE BAT DVDD pfet_06v0 ad=58.1552p pd=78.04u as=58.1552p ps=78.04u w=76.52u l=1u
X12345 DVDD GATE BAT DVDD pfet_06v0 ad=35.511p pd=48.245u as=35.511p ps=48.245u w=46.725u l=1u
X12346 DVDD GATE BAT DVDD pfet_06v0 ad=58.0754p pd=77.935u as=58.0754p ps=77.935u w=76.41499u l=1u
X12347 BAT GATE DVDD DVDD pfet_06v0 ad=58.1134p pd=77.985u as=58.1134p ps=77.985u w=76.465u l=1u
X12348 BAT GATE DVDD DVDD pfet_06v0 ad=47.6862p pd=64.265u as=47.6862p ps=64.265u w=62.745u l=1u
X12349 DVDD GATE BAT DVDD pfet_06v0 ad=35.511p pd=48.245u as=35.511p ps=48.245u w=46.725u l=1u
X12350 BAT GATE DVDD DVDD pfet_06v0 ad=58.1134p pd=77.985u as=58.1134p ps=77.985u w=76.465u l=1u
X12351 DVDD GATE BAT DVDD pfet_06v0 ad=58.1134p pd=77.985u as=58.1134p ps=77.985u w=76.465u l=1u
X12352 DVDD GATE BAT DVDD pfet_06v0 ad=71.8771p pd=0.15481m as=58.1134p ps=77.985u w=76.465u l=1u
X12353 BAT GATE DVDD DVDD pfet_06v0 ad=35.511p pd=48.245u as=43.9215p ps=95.32999u w=46.725u l=1u
X12354 DVDD GATE BAT DVDD pfet_06v0 ad=35.511p pd=48.245u as=35.511p ps=48.245u w=46.725u l=1u
X12355 DVDD GATE BAT DVDD pfet_06v0 ad=58.1134p pd=77.985u as=58.1134p ps=77.985u w=76.465u l=1u
X12356 BAT GATE DVDD DVDD pfet_06v0 ad=35.511p pd=48.245u as=43.9215p ps=95.32999u w=46.725u l=1u
X12357 BAT GATE DVDD DVDD pfet_06v0 ad=58.1134p pd=77.985u as=58.1134p ps=77.985u w=76.465u l=1u
X12358 BAT GATE DVDD DVDD pfet_06v0 ad=58.1134p pd=77.985u as=58.1134p ps=77.985u w=76.465u l=1u
X12359 DVDD GATE BAT DVDD pfet_06v0 ad=58.1134p pd=77.985u as=58.1134p ps=77.985u w=76.465u l=1u
X12360 BAT GATE DVDD DVDD pfet_06v0 ad=58.0754p pd=77.935u as=58.0754p ps=77.935u w=76.41499u l=1u
X12361 DVDD GATE BAT DVDD pfet_06v0 ad=35.511p pd=48.245u as=35.511p ps=48.245u w=46.725u l=1u
X12362 BAT GATE DVDD DVDD pfet_06v0 ad=49.3848p pd=66.5u as=49.3848p ps=66.5u w=64.98u l=1u
X12363 BAT GATE DVDD DVDD pfet_06v0 ad=35.511p pd=48.245u as=35.511p ps=48.245u w=46.725u l=1u
X12364 BAT GATE DVDD DVDD pfet_06v0 ad=58.0754p pd=77.935u as=58.0754p ps=77.935u w=76.41499u l=1u
X12365 BAT GATE DVDD DVDD pfet_06v0 ad=35.511p pd=48.245u as=35.511p ps=48.245u w=46.725u l=1u
X12366 DVDD GATE BAT DVDD pfet_06v0 ad=35.511p pd=48.245u as=35.511p ps=48.245u w=46.725u l=1u
X12367 DVDD GATE BAT DVDD pfet_06v0 ad=35.511p pd=48.245u as=35.511p ps=48.245u w=46.725u l=1u
X12368 DVDD GATE BAT DVDD pfet_06v0 ad=35.511p pd=48.245u as=35.511p ps=48.245u w=46.725u l=1u
X12369 DVDD GATE BAT DVDD pfet_06v0 ad=43.9215p pd=95.32999u as=35.511p ps=48.245u w=46.725u l=1u
X12370 BAT GATE DVDD DVDD pfet_06v0 ad=58.1134p pd=77.985u as=71.8771p ps=0.15481m w=76.465u l=1u
X12371 DVDD GATE BAT DVDD pfet_06v0 ad=35.511p pd=48.245u as=35.511p ps=48.245u w=46.725u l=1u
X12372 BAT GATE DVDD DVDD pfet_06v0 ad=58.1134p pd=77.985u as=71.8771p ps=0.15481m w=76.465u l=1u
X12373 BAT GATE DVDD DVDD pfet_06v0 ad=58.1134p pd=77.985u as=71.8771p ps=0.15481m w=76.465u l=1u
X12374 BAT GATE DVDD DVDD pfet_06v0 ad=35.511p pd=48.245u as=35.511p ps=48.245u w=46.725u l=1u
X12375 DVDD GATE BAT DVDD pfet_06v0 ad=58.1134p pd=77.985u as=58.1134p ps=77.985u w=76.465u l=1u
X12376 DVDD GATE BAT DVDD pfet_06v0 ad=71.8771p pd=0.15481m as=58.1134p ps=77.985u w=76.465u l=1u
X12377 BAT GATE DVDD DVDD pfet_06v0 ad=35.511p pd=48.245u as=35.511p ps=48.245u w=46.725u l=1u
X12378 DVDD GATE BAT DVDD pfet_06v0 ad=71.8724p pd=0.1548m as=58.1096p ps=77.98u w=76.46u l=1u
X12379 BAT GATE DVDD DVDD pfet_06v0 ad=35.511p pd=48.245u as=43.9215p ps=95.32999u w=46.725u l=1u
X12380 DVDD GATE BAT DVDD pfet_06v0 ad=58.0754p pd=77.935u as=58.0754p ps=77.935u w=76.41499u l=1u
X12381 BAT GATE DVDD DVDD pfet_06v0 ad=35.511p pd=48.245u as=43.9215p ps=95.32999u w=46.725u l=1u
X12382 DVDD GATE BAT DVDD pfet_06v0 ad=43.9215p pd=95.32999u as=35.511p ps=48.245u w=46.725u l=1u
X12383 DVDD GATE BAT DVDD pfet_06v0 ad=35.5072p pd=48.24u as=35.5072p ps=48.24u w=46.72u l=1u
X12384 DVDD GATE BAT DVDD pfet_06v0 ad=35.511p pd=48.245u as=35.511p ps=48.245u w=46.725u l=1u
X12385 BAT GATE DVDD DVDD pfet_06v0 ad=58.1096p pd=77.98u as=58.1096p ps=77.98u w=76.46u l=1u
X12386 BAT GATE DVDD DVDD pfet_06v0 ad=35.511p pd=48.245u as=35.511p ps=48.245u w=46.725u l=1u
X12387 BAT GATE DVDD DVDD pfet_06v0 ad=35.511p pd=48.245u as=35.511p ps=48.245u w=46.725u l=1u
X12388 BAT GATE DVDD DVDD pfet_06v0 ad=58.1134p pd=77.985u as=58.1134p ps=77.985u w=76.465u l=1u
X12389 DVDD GATE BAT DVDD pfet_06v0 ad=61.0812p pd=0.13184m as=49.3848p ps=66.5u w=64.98u l=1u
X12390 DVDD GATE BAT DVDD pfet_06v0 ad=35.511p pd=48.245u as=35.511p ps=48.245u w=46.725u l=1u
X12391 DVDD GATE BAT DVDD pfet_06v0 ad=58.1134p pd=77.985u as=58.1134p ps=77.985u w=76.465u l=1u
X12392 DVDD GATE BAT DVDD pfet_06v0 ad=35.511p pd=48.245u as=35.511p ps=48.245u w=46.725u l=1u
X12393 BAT GATE DVDD DVDD pfet_06v0 ad=49.3848p pd=66.5u as=49.3848p ps=66.5u w=64.98u l=1u
X12394 BAT GATE DVDD DVDD pfet_06v0 ad=35.511p pd=48.245u as=35.511p ps=48.245u w=46.725u l=1u
X12395 BAT GATE DVDD DVDD pfet_06v0 ad=35.511p pd=48.245u as=35.511p ps=48.245u w=46.725u l=1u
X12396 DVDD GATE BAT DVDD pfet_06v0 ad=35.511p pd=48.245u as=35.511p ps=48.245u w=46.725u l=1u
X12397 BAT GATE DVDD DVDD pfet_06v0 ad=35.511p pd=48.245u as=35.511p ps=48.245u w=46.725u l=1u
X12398 DVDD GATE BAT DVDD pfet_06v0 ad=58.1134p pd=77.985u as=58.1134p ps=77.985u w=76.465u l=1u
X12399 DVDD GATE BAT DVDD pfet_06v0 ad=58.1552p pd=78.04u as=58.1552p ps=78.04u w=76.52u l=1u
X12400 DVDD GATE BAT DVDD pfet_06v0 ad=35.511p pd=48.245u as=35.511p ps=48.245u w=46.725u l=1u
X12401 DVDD GATE BAT DVDD pfet_06v0 ad=58.0754p pd=77.935u as=58.0754p ps=77.935u w=76.41499u l=1u
X12402 BAT GATE DVDD DVDD pfet_06v0 ad=58.1134p pd=77.985u as=71.8771p ps=0.15481m w=76.465u l=1u
X12403 BAT GATE DVDD DVDD pfet_06v0 ad=58.1134p pd=77.985u as=71.8771p ps=0.15481m w=76.465u l=1u
X12404 DVDD GATE BAT DVDD pfet_06v0 ad=58.1096p pd=77.98u as=58.1096p ps=77.98u w=76.46u l=1u
X12405 DVDD GATE BAT DVDD pfet_06v0 ad=58.1134p pd=77.985u as=58.1134p ps=77.985u w=76.465u l=1u
X12406 BAT GATE DVDD DVDD pfet_06v0 ad=58.0754p pd=77.935u as=58.0754p ps=77.935u w=76.41499u l=1u
X12407 DVDD GATE BAT DVDD pfet_06v0 ad=35.511p pd=48.245u as=35.511p ps=48.245u w=46.725u l=1u
X12408 DVDD GATE BAT DVDD pfet_06v0 ad=35.511p pd=48.245u as=35.511p ps=48.245u w=46.725u l=1u
X12409 BAT GATE DVDD DVDD pfet_06v0 ad=35.511p pd=48.245u as=35.511p ps=48.245u w=46.725u l=1u
X12410 DVDD GATE BAT DVDD pfet_06v0 ad=71.8771p pd=0.15481m as=58.1134p ps=77.985u w=76.465u l=1u
X12411 BAT GATE DVDD DVDD pfet_06v0 ad=58.1172p pd=77.99u as=58.1172p ps=77.99u w=76.47u l=1u
X12412 DVDD GATE BAT DVDD pfet_06v0 ad=58.1134p pd=77.985u as=58.1134p ps=77.985u w=76.465u l=1u
X12413 DVDD GATE BAT DVDD pfet_06v0 ad=58.1134p pd=77.985u as=58.1134p ps=77.985u w=76.465u l=1u
X12414 DVDD GATE BAT DVDD pfet_06v0 ad=35.5072p pd=48.24u as=35.5072p ps=48.24u w=46.72u l=1u
X12415 DVDD GATE BAT DVDD pfet_06v0 ad=58.1134p pd=77.985u as=58.1134p ps=77.985u w=76.465u l=1u
X12416 DVDD GATE BAT DVDD pfet_06v0 ad=35.511p pd=48.245u as=35.511p ps=48.245u w=46.725u l=1u
X12417 DVDD GATE BAT DVDD pfet_06v0 ad=35.5072p pd=48.24u as=35.5072p ps=48.24u w=46.72u l=1u
X12418 BAT GATE DVDD DVDD pfet_06v0 ad=58.1552p pd=78.04u as=58.1552p ps=78.04u w=76.52u l=1u
X12419 DVDD GATE BAT DVDD pfet_06v0 ad=58.1134p pd=77.985u as=58.1134p ps=77.985u w=76.465u l=1u
X12420 DVDD GATE BAT DVDD pfet_06v0 ad=35.511p pd=48.245u as=35.511p ps=48.245u w=46.725u l=1u
X12421 BAT GATE DVDD DVDD pfet_06v0 ad=35.511p pd=48.245u as=35.511p ps=48.245u w=46.725u l=1u
X12422 DVDD GATE BAT DVDD pfet_06v0 ad=35.511p pd=48.245u as=35.511p ps=48.245u w=46.725u l=1u
X12423 DVDD GATE BAT DVDD pfet_06v0 ad=58.1552p pd=78.04u as=58.1552p ps=78.04u w=76.52u l=1u
X12424 DVDD GATE BAT DVDD pfet_06v0 ad=58.1134p pd=77.985u as=58.1134p ps=77.985u w=76.465u l=1u
X12425 BAT GATE DVDD DVDD pfet_06v0 ad=35.511p pd=48.245u as=35.511p ps=48.245u w=46.725u l=1u
X12426 BAT GATE DVDD DVDD pfet_06v0 ad=58.1134p pd=77.985u as=58.1134p ps=77.985u w=76.465u l=1u
X12427 DVDD GATE BAT DVDD pfet_06v0 ad=35.511p pd=48.245u as=35.511p ps=48.245u w=46.725u l=1u
X12428 DVDD GATE BAT DVDD pfet_06v0 ad=35.511p pd=48.245u as=35.511p ps=48.245u w=46.725u l=1u
X12429 DVDD GATE BAT DVDD pfet_06v0 ad=58.1134p pd=77.985u as=58.1134p ps=77.985u w=76.465u l=1u
X12430 DVDD GATE BAT DVDD pfet_06v0 ad=47.6862p pd=64.265u as=47.6862p ps=64.265u w=62.745u l=1u
X12431 DVDD GATE BAT DVDD pfet_06v0 ad=35.511p pd=48.245u as=35.511p ps=48.245u w=46.725u l=1u
X12432 DVDD GATE BAT DVDD pfet_06v0 ad=71.8771p pd=0.15481m as=58.1134p ps=77.985u w=76.465u l=1u
X12433 BAT GATE DVDD DVDD pfet_06v0 ad=49.3848p pd=66.5u as=49.3848p ps=66.5u w=64.98u l=1u
X12434 BAT GATE DVDD DVDD pfet_06v0 ad=35.511p pd=48.245u as=43.9215p ps=95.32999u w=46.725u l=1u
X12435 BAT GATE DVDD DVDD pfet_06v0 ad=35.511p pd=48.245u as=35.511p ps=48.245u w=46.725u l=1u
X12436 DVDD GATE BAT DVDD pfet_06v0 ad=58.1134p pd=77.985u as=58.1134p ps=77.985u w=76.465u l=1u
X12437 DVDD GATE BAT DVDD pfet_06v0 ad=58.1134p pd=77.985u as=58.1134p ps=77.985u w=76.465u l=1u
X12438 DVDD GATE BAT DVDD pfet_06v0 ad=58.1172p pd=77.99u as=58.1172p ps=77.99u w=76.47u l=1u
X12439 DVDD GATE BAT DVDD pfet_06v0 ad=58.1134p pd=77.985u as=58.1134p ps=77.985u w=76.465u l=1u
X12440 DVDD GATE BAT DVDD pfet_06v0 ad=35.511p pd=48.245u as=35.511p ps=48.245u w=46.725u l=1u
X12441 BAT GATE DVDD DVDD pfet_06v0 ad=58.1134p pd=77.985u as=58.1134p ps=77.985u w=76.465u l=1u
X12442 DVDD GATE BAT DVDD pfet_06v0 ad=43.9215p pd=95.32999u as=35.511p ps=48.245u w=46.725u l=1u
X12443 BAT GATE DVDD DVDD pfet_06v0 ad=35.511p pd=48.245u as=35.511p ps=48.245u w=46.725u l=1u
X12444 BAT GATE DVDD DVDD pfet_06v0 ad=58.1172p pd=77.99u as=71.8818p ps=0.15482m w=76.47u l=1u
X12445 BAT GATE DVDD DVDD pfet_06v0 ad=49.3848p pd=66.5u as=49.3848p ps=66.5u w=64.98u l=1u
X12446 BAT GATE DVDD DVDD pfet_06v0 ad=58.0754p pd=77.935u as=71.8301p ps=0.15471m w=76.41499u l=1u
X12447 DVDD GATE BAT DVDD pfet_06v0 ad=58.1552p pd=78.04u as=58.1552p ps=78.04u w=76.52u l=1u
X12448 DVDD GATE BAT DVDD pfet_06v0 ad=49.3848p pd=66.5u as=49.3848p ps=66.5u w=64.98u l=1u
X12449 BAT GATE DVDD DVDD pfet_06v0 ad=58.1134p pd=77.985u as=71.8771p ps=0.15481m w=76.465u l=1u
X12450 DVDD GATE BAT DVDD pfet_06v0 ad=58.1096p pd=77.98u as=58.1096p ps=77.98u w=76.46u l=1u
X12451 DVDD GATE BAT DVDD pfet_06v0 ad=43.9215p pd=95.32999u as=35.511p ps=48.245u w=46.725u l=1u
X12452 DVDD GATE BAT DVDD pfet_06v0 ad=58.1096p pd=77.98u as=58.1096p ps=77.98u w=76.46u l=1u
X12453 DVDD GATE BAT DVDD pfet_06v0 ad=71.8771p pd=0.15481m as=58.1134p ps=77.985u w=76.465u l=1u
X12454 DVDD GATE BAT DVDD pfet_06v0 ad=58.1134p pd=77.985u as=58.1134p ps=77.985u w=76.465u l=1u
X12455 BAT GATE DVDD DVDD pfet_06v0 ad=35.511p pd=48.245u as=35.511p ps=48.245u w=46.725u l=1u
X12456 DVDD GATE BAT DVDD pfet_06v0 ad=58.1552p pd=78.04u as=58.1552p ps=78.04u w=76.52u l=1u
X12457 DVDD GATE BAT DVDD pfet_06v0 ad=35.511p pd=48.245u as=35.511p ps=48.245u w=46.725u l=1u
X12458 DVDD GATE BAT DVDD pfet_06v0 ad=71.8771p pd=0.15481m as=58.1134p ps=77.985u w=76.465u l=1u
X12459 DVDD GATE BAT DVDD pfet_06v0 ad=58.1552p pd=78.04u as=58.1552p ps=78.04u w=76.52u l=1u
X12460 DVDD GATE BAT DVDD pfet_06v0 ad=58.0754p pd=77.935u as=58.0754p ps=77.935u w=76.41499u l=1u
X12461 BAT GATE DVDD DVDD pfet_06v0 ad=35.511p pd=48.245u as=35.511p ps=48.245u w=46.725u l=1u
X12462 BAT GATE DVDD DVDD pfet_06v0 ad=35.511p pd=48.245u as=35.511p ps=48.245u w=46.725u l=1u
X12463 DVDD GATE BAT DVDD pfet_06v0 ad=35.511p pd=48.245u as=35.511p ps=48.245u w=46.725u l=1u
X12464 DVDD GATE BAT DVDD pfet_06v0 ad=35.5072p pd=48.24u as=35.5072p ps=48.24u w=46.72u l=1u
X12465 DVDD GATE BAT DVDD pfet_06v0 ad=58.1172p pd=77.99u as=58.1172p ps=77.99u w=76.47u l=1u
X12466 BAT GATE DVDD DVDD pfet_06v0 ad=35.511p pd=48.245u as=35.511p ps=48.245u w=46.725u l=1u
X12467 DVDD GATE BAT DVDD pfet_06v0 ad=58.1134p pd=77.985u as=58.1134p ps=77.985u w=76.465u l=1u
X12468 DVDD GATE BAT DVDD pfet_06v0 ad=35.511p pd=48.245u as=35.511p ps=48.245u w=46.725u l=1u
X12469 DVDD GATE BAT DVDD pfet_06v0 ad=58.1172p pd=77.99u as=58.1172p ps=77.99u w=76.47u l=1u
X12470 DVDD GATE BAT DVDD pfet_06v0 ad=71.8301p pd=0.15471m as=58.0754p ps=77.935u w=76.41499u l=1u
X12471 BAT GATE DVDD DVDD pfet_06v0 ad=49.3848p pd=66.5u as=61.0812p ps=0.13184m w=64.98u l=1u
X12472 DVDD GATE BAT DVDD pfet_06v0 ad=58.1134p pd=77.985u as=58.1134p ps=77.985u w=76.465u l=1u
X12473 BAT GATE DVDD DVDD pfet_06v0 ad=58.1096p pd=77.98u as=58.1096p ps=77.98u w=76.46u l=1u
X12474 BAT GATE DVDD DVDD pfet_06v0 ad=58.1096p pd=77.98u as=58.1096p ps=77.98u w=76.46u l=1u
X12475 DVDD GATE BAT DVDD pfet_06v0 ad=35.511p pd=48.245u as=35.511p ps=48.245u w=46.725u l=1u
X12476 BAT GATE DVDD DVDD pfet_06v0 ad=35.511p pd=48.245u as=35.511p ps=48.245u w=46.725u l=1u
X12477 DVDD GATE BAT DVDD pfet_06v0 ad=35.511p pd=48.245u as=35.511p ps=48.245u w=46.725u l=1u
X12478 BAT GATE DVDD DVDD pfet_06v0 ad=58.1134p pd=77.985u as=58.1134p ps=77.985u w=76.465u l=1u
X12479 BAT GATE DVDD DVDD pfet_06v0 ad=35.511p pd=48.245u as=43.9215p ps=95.32999u w=46.725u l=1u
X12480 BAT GATE DVDD DVDD pfet_06v0 ad=58.0754p pd=77.935u as=71.8301p ps=0.15471m w=76.41499u l=1u
X12481 BAT GATE DVDD DVDD pfet_06v0 ad=35.511p pd=48.245u as=35.511p ps=48.245u w=46.725u l=1u
X12482 BAT GATE DVDD DVDD pfet_06v0 ad=58.1134p pd=77.985u as=58.1134p ps=77.985u w=76.465u l=1u
X12483 DVDD GATE BAT DVDD pfet_06v0 ad=58.1172p pd=77.99u as=58.1172p ps=77.99u w=76.47u l=1u
X12484 DVDD GATE BAT DVDD pfet_06v0 ad=58.1134p pd=77.985u as=58.1134p ps=77.985u w=76.465u l=1u
X12485 DVDD GATE BAT DVDD pfet_06v0 ad=71.92879p pd=0.15492m as=58.1552p ps=78.04u w=76.52u l=1u
X12486 BAT GATE DVDD DVDD pfet_06v0 ad=49.3848p pd=66.5u as=49.3848p ps=66.5u w=64.98u l=1u
X12487 DVDD GATE BAT DVDD pfet_06v0 ad=35.511p pd=48.245u as=35.511p ps=48.245u w=46.725u l=1u
X12488 DVDD GATE BAT DVDD pfet_06v0 ad=71.8771p pd=0.15481m as=58.1134p ps=77.985u w=76.465u l=1u
X12489 BAT GATE DVDD DVDD pfet_06v0 ad=58.0754p pd=77.935u as=58.0754p ps=77.935u w=76.41499u l=1u
X12490 DVDD GATE BAT DVDD pfet_06v0 ad=35.511p pd=48.245u as=35.511p ps=48.245u w=46.725u l=1u
X12491 BAT GATE DVDD DVDD pfet_06v0 ad=58.1096p pd=77.98u as=58.1096p ps=77.98u w=76.46u l=1u
X12492 DVDD GATE BAT DVDD pfet_06v0 ad=35.511p pd=48.245u as=35.511p ps=48.245u w=46.725u l=1u
X12493 BAT GATE DVDD DVDD pfet_06v0 ad=35.511p pd=48.245u as=43.9215p ps=95.32999u w=46.725u l=1u
X12494 BAT GATE DVDD DVDD pfet_06v0 ad=58.1134p pd=77.985u as=58.1134p ps=77.985u w=76.465u l=1u
X12495 DVDD GATE BAT DVDD pfet_06v0 ad=47.6862p pd=64.265u as=47.6862p ps=64.265u w=62.745u l=1u
X12496 DVDD GATE BAT DVDD pfet_06v0 ad=35.511p pd=48.245u as=35.511p ps=48.245u w=46.725u l=1u
X12497 BAT GATE DVDD DVDD pfet_06v0 ad=58.1134p pd=77.985u as=58.1134p ps=77.985u w=76.465u l=1u
X12498 BAT GATE DVDD DVDD pfet_06v0 ad=35.511p pd=48.245u as=35.511p ps=48.245u w=46.725u l=1u
X12499 BAT GATE DVDD DVDD pfet_06v0 ad=47.6862p pd=64.265u as=58.9803p ps=0.12737m w=62.745u l=1u
X12500 DVDD GATE BAT DVDD pfet_06v0 ad=71.8771p pd=0.15481m as=58.1134p ps=77.985u w=76.465u l=1u
X12501 BAT GATE DVDD DVDD pfet_06v0 ad=58.1134p pd=77.985u as=58.1134p ps=77.985u w=76.465u l=1u
X12502 DVDD GATE BAT DVDD pfet_06v0 ad=58.1134p pd=77.985u as=58.1134p ps=77.985u w=76.465u l=1u
X12503 DVDD GATE BAT DVDD pfet_06v0 ad=35.511p pd=48.245u as=35.511p ps=48.245u w=46.725u l=1u
X12504 DVDD GATE BAT DVDD pfet_06v0 ad=43.9215p pd=95.32999u as=35.511p ps=48.245u w=46.725u l=1u
X12505 BAT GATE DVDD DVDD pfet_06v0 ad=35.5072p pd=48.24u as=35.5072p ps=48.24u w=46.72u l=1u
X12506 BAT GATE DVDD DVDD pfet_06v0 ad=58.1134p pd=77.985u as=58.1134p ps=77.985u w=76.465u l=1u
X12507 DVDD GATE BAT DVDD pfet_06v0 ad=71.8301p pd=0.15471m as=58.0754p ps=77.935u w=76.41499u l=1u
X12508 DVDD GATE BAT DVDD pfet_06v0 ad=35.511p pd=48.245u as=35.511p ps=48.245u w=46.725u l=1u
X12509 DVDD GATE BAT DVDD pfet_06v0 ad=58.1134p pd=77.985u as=58.1134p ps=77.985u w=76.465u l=1u
X12510 BAT GATE DVDD DVDD pfet_06v0 ad=35.511p pd=48.245u as=35.511p ps=48.245u w=46.725u l=1u
X12511 DVDD GATE BAT DVDD pfet_06v0 ad=58.1172p pd=77.99u as=58.1172p ps=77.99u w=76.47u l=1u
X12512 BAT GATE DVDD DVDD pfet_06v0 ad=58.1552p pd=78.04u as=58.1552p ps=78.04u w=76.52u l=1u
X12513 BAT GATE DVDD DVDD pfet_06v0 ad=35.511p pd=48.245u as=35.511p ps=48.245u w=46.725u l=1u
X12514 BAT GATE DVDD DVDD pfet_06v0 ad=35.5072p pd=48.24u as=43.9168p ps=95.32u w=46.72u l=1u
X12515 BAT GATE DVDD DVDD pfet_06v0 ad=58.1134p pd=77.985u as=71.8771p ps=0.15481m w=76.465u l=1u
X12516 BAT GATE DVDD DVDD pfet_06v0 ad=35.511p pd=48.245u as=35.511p ps=48.245u w=46.725u l=1u
X12517 DVDD GATE BAT DVDD pfet_06v0 ad=58.1134p pd=77.985u as=58.1134p ps=77.985u w=76.465u l=1u
X12518 DVDD GATE BAT DVDD pfet_06v0 ad=71.8771p pd=0.15481m as=58.1134p ps=77.985u w=76.465u l=1u
X12519 BAT GATE DVDD DVDD pfet_06v0 ad=58.1552p pd=78.04u as=58.1552p ps=78.04u w=76.52u l=1u
X12520 BAT GATE DVDD DVDD pfet_06v0 ad=58.1134p pd=77.985u as=58.1134p ps=77.985u w=76.465u l=1u
X12521 BAT GATE DVDD DVDD pfet_06v0 ad=35.511p pd=48.245u as=35.511p ps=48.245u w=46.725u l=1u
X12522 BAT GATE DVDD DVDD pfet_06v0 ad=35.511p pd=48.245u as=43.9215p ps=95.32999u w=46.725u l=1u
X12523 BAT GATE DVDD DVDD pfet_06v0 ad=49.3848p pd=66.5u as=49.3848p ps=66.5u w=64.98u l=1u
X12524 BAT GATE DVDD DVDD pfet_06v0 ad=35.511p pd=48.245u as=35.511p ps=48.245u w=46.725u l=1u
X12525 DVDD GATE BAT DVDD pfet_06v0 ad=58.1134p pd=77.985u as=58.1134p ps=77.985u w=76.465u l=1u
X12526 BAT GATE DVDD DVDD pfet_06v0 ad=58.1134p pd=77.985u as=58.1134p ps=77.985u w=76.465u l=1u
X12527 BAT GATE DVDD DVDD pfet_06v0 ad=35.511p pd=48.245u as=35.511p ps=48.245u w=46.725u l=1u
X12528 DVDD GATE BAT DVDD pfet_06v0 ad=58.1552p pd=78.04u as=58.1552p ps=78.04u w=76.52u l=1u
X12529 BAT GATE DVDD DVDD pfet_06v0 ad=58.1134p pd=77.985u as=71.8771p ps=0.15481m w=76.465u l=1u
X12530 DVDD GATE BAT DVDD pfet_06v0 ad=35.511p pd=48.245u as=35.511p ps=48.245u w=46.725u l=1u
X12531 BAT GATE DVDD DVDD pfet_06v0 ad=58.1172p pd=77.99u as=71.8818p ps=0.15482m w=76.47u l=1u
X12532 BAT GATE DVDD DVDD pfet_06v0 ad=58.1134p pd=77.985u as=58.1134p ps=77.985u w=76.465u l=1u
X12533 DVDD GATE BAT DVDD pfet_06v0 ad=43.9215p pd=95.32999u as=35.511p ps=48.245u w=46.725u l=1u
X12534 DVDD GATE BAT DVDD pfet_06v0 ad=71.8771p pd=0.15481m as=58.1134p ps=77.985u w=76.465u l=1u
X12535 BAT GATE DVDD DVDD pfet_06v0 ad=58.1134p pd=77.985u as=71.8771p ps=0.15481m w=76.465u l=1u
X12536 BAT GATE DVDD DVDD pfet_06v0 ad=49.3848p pd=66.5u as=49.3848p ps=66.5u w=64.98u l=1u
X12537 DVDD GATE BAT DVDD pfet_06v0 ad=47.6862p pd=64.265u as=47.6862p ps=64.265u w=62.745u l=1u
X12538 BAT GATE DVDD DVDD pfet_06v0 ad=49.3848p pd=66.5u as=49.3848p ps=66.5u w=64.98u l=1u
X12539 DVDD GATE BAT DVDD pfet_06v0 ad=49.3848p pd=66.5u as=49.3848p ps=66.5u w=64.98u l=1u
X12540 BAT GATE DVDD DVDD pfet_06v0 ad=58.0754p pd=77.935u as=71.8301p ps=0.15471m w=76.41499u l=1u
X12541 DVDD GATE BAT DVDD pfet_06v0 ad=49.3848p pd=66.5u as=49.3848p ps=66.5u w=64.98u l=1u
X12542 BAT GATE DVDD DVDD pfet_06v0 ad=58.1552p pd=78.04u as=71.92879p ps=0.15492m w=76.52u l=1u
X12543 DVDD GATE BAT DVDD pfet_06v0 ad=58.1134p pd=77.985u as=58.1134p ps=77.985u w=76.465u l=1u
X12544 BAT GATE DVDD DVDD pfet_06v0 ad=35.511p pd=48.245u as=35.511p ps=48.245u w=46.725u l=1u
X12545 DVDD GATE BAT DVDD pfet_06v0 ad=61.0812p pd=0.13184m as=49.3848p ps=66.5u w=64.98u l=1u
X12546 BAT GATE DVDD DVDD pfet_06v0 ad=58.1134p pd=77.985u as=58.1134p ps=77.985u w=76.465u l=1u
X12547 BAT GATE DVDD DVDD pfet_06v0 ad=58.1096p pd=77.98u as=71.8724p ps=0.1548m w=76.46u l=1u
X12548 BAT GATE DVDD DVDD pfet_06v0 ad=49.3848p pd=66.5u as=49.3848p ps=66.5u w=64.98u l=1u
X12549 DVDD GATE BAT DVDD pfet_06v0 ad=71.8818p pd=0.15482m as=58.1172p ps=77.99u w=76.47u l=1u
X12550 DVDD GATE BAT DVDD pfet_06v0 ad=35.511p pd=48.245u as=35.511p ps=48.245u w=46.725u l=1u
X12551 BAT GATE DVDD DVDD pfet_06v0 ad=58.0754p pd=77.935u as=71.8301p ps=0.15471m w=76.41499u l=1u
X12552 DVDD GATE BAT DVDD pfet_06v0 ad=35.511p pd=48.245u as=35.511p ps=48.245u w=46.725u l=1u
X12553 DVDD GATE BAT DVDD pfet_06v0 ad=71.8771p pd=0.15481m as=58.1134p ps=77.985u w=76.465u l=1u
X12554 DVDD GATE BAT DVDD pfet_06v0 ad=43.9215p pd=95.32999u as=35.511p ps=48.245u w=46.725u l=1u
X12555 BAT GATE DVDD DVDD pfet_06v0 ad=35.511p pd=48.245u as=35.511p ps=48.245u w=46.725u l=1u
X12556 BAT GATE DVDD DVDD pfet_06v0 ad=35.511p pd=48.245u as=43.9215p ps=95.32999u w=46.725u l=1u
X12557 DVDD GATE BAT DVDD pfet_06v0 ad=58.1134p pd=77.985u as=58.1134p ps=77.985u w=76.465u l=1u
X12558 BAT GATE DVDD DVDD pfet_06v0 ad=35.511p pd=48.245u as=35.511p ps=48.245u w=46.725u l=1u
X12559 DVDD GATE BAT DVDD pfet_06v0 ad=47.6862p pd=64.265u as=47.6862p ps=64.265u w=62.745u l=1u
X12560 DVDD GATE BAT DVDD pfet_06v0 ad=58.1134p pd=77.985u as=58.1134p ps=77.985u w=76.465u l=1u
X12561 DVDD GATE BAT DVDD pfet_06v0 ad=58.1134p pd=77.985u as=58.1134p ps=77.985u w=76.465u l=1u
X12562 DVDD GATE BAT DVDD pfet_06v0 ad=43.9215p pd=95.32999u as=35.511p ps=48.245u w=46.725u l=1u
X12563 DVDD GATE BAT DVDD pfet_06v0 ad=35.511p pd=48.245u as=35.511p ps=48.245u w=46.725u l=1u
X12564 BAT GATE DVDD DVDD pfet_06v0 ad=35.5072p pd=48.24u as=43.9168p ps=95.32u w=46.72u l=1u
X12565 DVDD GATE BAT DVDD pfet_06v0 ad=43.9215p pd=95.32999u as=35.511p ps=48.245u w=46.725u l=1u
X12566 BAT GATE DVDD DVDD pfet_06v0 ad=58.1134p pd=77.985u as=58.1134p ps=77.985u w=76.465u l=1u
X12567 BAT GATE DVDD DVDD pfet_06v0 ad=35.511p pd=48.245u as=43.9215p ps=95.32999u w=46.725u l=1u
X12568 BAT GATE DVDD DVDD pfet_06v0 ad=58.1172p pd=77.99u as=71.8818p ps=0.15482m w=76.47u l=1u
X12569 DVDD GATE BAT DVDD pfet_06v0 ad=35.511p pd=48.245u as=35.511p ps=48.245u w=46.725u l=1u
X12570 BAT GATE DVDD DVDD pfet_06v0 ad=35.511p pd=48.245u as=35.511p ps=48.245u w=46.725u l=1u
X12571 DVDD GATE BAT DVDD pfet_06v0 ad=43.9215p pd=95.32999u as=35.511p ps=48.245u w=46.725u l=1u
X12572 BAT GATE DVDD DVDD pfet_06v0 ad=58.1172p pd=77.99u as=58.1172p ps=77.99u w=76.47u l=1u
X12573 DVDD GATE BAT DVDD pfet_06v0 ad=71.8771p pd=0.15481m as=58.1134p ps=77.985u w=76.465u l=1u
X12574 DVDD GATE BAT DVDD pfet_06v0 ad=35.511p pd=48.245u as=35.511p ps=48.245u w=46.725u l=1u
X12575 BAT GATE DVDD DVDD pfet_06v0 ad=58.0754p pd=77.935u as=58.0754p ps=77.935u w=76.41499u l=1u
X12576 BAT GATE DVDD DVDD pfet_06v0 ad=35.511p pd=48.245u as=35.511p ps=48.245u w=46.725u l=1u
X12577 DVDD GATE BAT DVDD pfet_06v0 ad=58.1096p pd=77.98u as=58.1096p ps=77.98u w=76.46u l=1u
X12578 BAT GATE DVDD DVDD pfet_06v0 ad=58.1172p pd=77.99u as=58.1172p ps=77.99u w=76.47u l=1u
X12579 DVDD GATE BAT DVDD pfet_06v0 ad=35.511p pd=48.245u as=35.511p ps=48.245u w=46.725u l=1u
X12580 BAT GATE DVDD DVDD pfet_06v0 ad=35.511p pd=48.245u as=35.511p ps=48.245u w=46.725u l=1u
X12581 DVDD GATE BAT DVDD pfet_06v0 ad=58.1172p pd=77.99u as=58.1172p ps=77.99u w=76.47u l=1u
X12582 DVDD GATE BAT DVDD pfet_06v0 ad=43.9215p pd=95.32999u as=35.511p ps=48.245u w=46.725u l=1u
X12583 DVDD GATE BAT DVDD pfet_06v0 ad=58.1134p pd=77.985u as=58.1134p ps=77.985u w=76.465u l=1u
X12584 DVDD GATE BAT DVDD pfet_06v0 ad=35.511p pd=48.245u as=35.511p ps=48.245u w=46.725u l=1u
X12585 DVDD GATE BAT DVDD pfet_06v0 ad=35.5072p pd=48.24u as=35.5072p ps=48.24u w=46.72u l=1u
X12586 DVDD GATE BAT DVDD pfet_06v0 ad=58.1134p pd=77.985u as=58.1134p ps=77.985u w=76.465u l=1u
X12587 BAT GATE DVDD DVDD pfet_06v0 ad=35.511p pd=48.245u as=35.511p ps=48.245u w=46.725u l=1u
X12588 BAT GATE DVDD DVDD pfet_06v0 ad=35.511p pd=48.245u as=35.511p ps=48.245u w=46.725u l=1u
X12589 DVDD GATE BAT DVDD pfet_06v0 ad=58.1134p pd=77.985u as=58.1134p ps=77.985u w=76.465u l=1u
X12590 DVDD GATE BAT DVDD pfet_06v0 ad=35.511p pd=48.245u as=35.511p ps=48.245u w=46.725u l=1u
X12591 DVDD GATE BAT DVDD pfet_06v0 ad=58.1134p pd=77.985u as=58.1134p ps=77.985u w=76.465u l=1u
X12592 DVDD GATE BAT DVDD pfet_06v0 ad=58.1134p pd=77.985u as=58.1134p ps=77.985u w=76.465u l=1u
X12593 BAT GATE DVDD DVDD pfet_06v0 ad=58.1134p pd=77.985u as=58.1134p ps=77.985u w=76.465u l=1u
X12594 BAT GATE DVDD DVDD pfet_06v0 ad=58.1134p pd=77.985u as=58.1134p ps=77.985u w=76.465u l=1u
X12595 DVDD GATE BAT DVDD pfet_06v0 ad=71.92879p pd=0.15492m as=58.1552p ps=78.04u w=76.52u l=1u
X12596 BAT GATE DVDD DVDD pfet_06v0 ad=35.511p pd=48.245u as=35.511p ps=48.245u w=46.725u l=1u
X12597 BAT GATE DVDD DVDD pfet_06v0 ad=58.1552p pd=78.04u as=58.1552p ps=78.04u w=76.52u l=1u
X12598 BAT GATE DVDD DVDD pfet_06v0 ad=35.511p pd=48.245u as=43.9215p ps=95.32999u w=46.725u l=1u
X12599 BAT GATE DVDD DVDD pfet_06v0 ad=35.511p pd=48.245u as=35.511p ps=48.245u w=46.725u l=1u
X12600 BAT GATE DVDD DVDD pfet_06v0 ad=35.511p pd=48.245u as=35.511p ps=48.245u w=46.725u l=1u
X12601 DVDD GATE BAT DVDD pfet_06v0 ad=58.1134p pd=77.985u as=58.1134p ps=77.985u w=76.465u l=1u
X12602 BAT GATE DVDD DVDD pfet_06v0 ad=35.5072p pd=48.24u as=43.9168p ps=95.32u w=46.72u l=1u
X12603 BAT GATE DVDD DVDD pfet_06v0 ad=58.0754p pd=77.935u as=58.0754p ps=77.935u w=76.41499u l=1u
X12604 DVDD GATE BAT DVDD pfet_06v0 ad=58.1096p pd=77.98u as=58.1096p ps=77.98u w=76.46u l=1u
X12605 DVDD GATE BAT DVDD pfet_06v0 ad=71.8771p pd=0.15481m as=58.1134p ps=77.985u w=76.465u l=1u
X12606 BAT GATE DVDD DVDD pfet_06v0 ad=58.1134p pd=77.985u as=58.1134p ps=77.985u w=76.465u l=1u
X12607 DVDD GATE BAT DVDD pfet_06v0 ad=58.1134p pd=77.985u as=58.1134p ps=77.985u w=76.465u l=1u
X12608 BAT GATE DVDD DVDD pfet_06v0 ad=58.1134p pd=77.985u as=58.1134p ps=77.985u w=76.465u l=1u
X12609 DVDD GATE BAT DVDD pfet_06v0 ad=49.3848p pd=66.5u as=49.3848p ps=66.5u w=64.98u l=1u
X12610 BAT GATE DVDD DVDD pfet_06v0 ad=35.511p pd=48.245u as=35.511p ps=48.245u w=46.725u l=1u
X12611 BAT GATE DVDD DVDD pfet_06v0 ad=35.511p pd=48.245u as=43.9215p ps=95.32999u w=46.725u l=1u
X12612 DVDD GATE BAT DVDD pfet_06v0 ad=35.511p pd=48.245u as=35.511p ps=48.245u w=46.725u l=1u
X12613 DVDD GATE BAT DVDD pfet_06v0 ad=61.0812p pd=0.13184m as=49.3848p ps=66.5u w=64.98u l=1u
X12614 BAT GATE DVDD DVDD pfet_06v0 ad=58.1134p pd=77.985u as=71.8771p ps=0.15481m w=76.465u l=1u
X12615 DVDD GATE BAT DVDD pfet_06v0 ad=43.9215p pd=95.32999u as=35.511p ps=48.245u w=46.725u l=1u
X12616 DVDD GATE BAT DVDD pfet_06v0 ad=47.6862p pd=64.265u as=47.6862p ps=64.265u w=62.745u l=1u
X12617 BAT GATE DVDD DVDD pfet_06v0 ad=58.1134p pd=77.985u as=58.1134p ps=77.985u w=76.465u l=1u
X12618 DVDD GATE BAT DVDD pfet_06v0 ad=35.511p pd=48.245u as=35.511p ps=48.245u w=46.725u l=1u
X12619 BAT GATE DVDD DVDD pfet_06v0 ad=35.511p pd=48.245u as=35.511p ps=48.245u w=46.725u l=1u
X12620 BAT GATE DVDD DVDD pfet_06v0 ad=58.0754p pd=77.935u as=58.0754p ps=77.935u w=76.41499u l=1u
X12621 BAT GATE DVDD DVDD pfet_06v0 ad=58.1134p pd=77.985u as=58.1134p ps=77.985u w=76.465u l=1u
X12622 DVDD GATE BAT DVDD pfet_06v0 ad=35.511p pd=48.245u as=35.511p ps=48.245u w=46.725u l=1u
X12623 DVDD GATE BAT DVDD pfet_06v0 ad=71.92879p pd=0.15492m as=58.1552p ps=78.04u w=76.52u l=1u
X12624 BAT GATE DVDD DVDD pfet_06v0 ad=58.1134p pd=77.985u as=58.1134p ps=77.985u w=76.465u l=1u
X12625 DVDD GATE BAT DVDD pfet_06v0 ad=58.1172p pd=77.99u as=58.1172p ps=77.99u w=76.47u l=1u
X12626 DVDD GATE BAT DVDD pfet_06v0 ad=35.511p pd=48.245u as=35.511p ps=48.245u w=46.725u l=1u
X12627 DVDD GATE BAT DVDD pfet_06v0 ad=58.1552p pd=78.04u as=58.1552p ps=78.04u w=76.52u l=1u
X12628 BAT GATE DVDD DVDD pfet_06v0 ad=35.511p pd=48.245u as=35.511p ps=48.245u w=46.725u l=1u
X12629 DVDD GATE BAT DVDD pfet_06v0 ad=58.1172p pd=77.99u as=58.1172p ps=77.99u w=76.47u l=1u
X12630 DVDD GATE BAT DVDD pfet_06v0 ad=43.9215p pd=95.32999u as=35.511p ps=48.245u w=46.725u l=1u
X12631 DVDD GATE BAT DVDD pfet_06v0 ad=71.8771p pd=0.15481m as=58.1134p ps=77.985u w=76.465u l=1u
X12632 BAT GATE DVDD DVDD pfet_06v0 ad=49.3848p pd=66.5u as=49.3848p ps=66.5u w=64.98u l=1u
X12633 BAT GATE DVDD DVDD pfet_06v0 ad=47.6862p pd=64.265u as=47.6862p ps=64.265u w=62.745u l=1u
X12634 BAT GATE DVDD DVDD pfet_06v0 ad=58.0754p pd=77.935u as=58.0754p ps=77.935u w=76.41499u l=1u
X12635 BAT GATE DVDD DVDD pfet_06v0 ad=58.1134p pd=77.985u as=71.8771p ps=0.15481m w=76.465u l=1u
X12636 BAT GATE DVDD DVDD pfet_06v0 ad=58.1134p pd=77.985u as=58.1134p ps=77.985u w=76.465u l=1u
X12637 BAT GATE DVDD DVDD pfet_06v0 ad=49.3848p pd=66.5u as=49.3848p ps=66.5u w=64.98u l=1u
X12638 BAT GATE DVDD DVDD pfet_06v0 ad=58.1134p pd=77.985u as=58.1134p ps=77.985u w=76.465u l=1u
X12639 DVDD GATE BAT DVDD pfet_06v0 ad=49.3848p pd=66.5u as=49.3848p ps=66.5u w=64.98u l=1u
X12640 DVDD GATE BAT DVDD pfet_06v0 ad=35.511p pd=48.245u as=35.511p ps=48.245u w=46.725u l=1u
X12641 BAT GATE DVDD DVDD pfet_06v0 ad=35.511p pd=48.245u as=35.511p ps=48.245u w=46.725u l=1u
X12642 DVDD GATE BAT DVDD pfet_06v0 ad=35.511p pd=48.245u as=35.511p ps=48.245u w=46.725u l=1u
X12643 DVDD GATE BAT DVDD pfet_06v0 ad=35.511p pd=48.245u as=35.511p ps=48.245u w=46.725u l=1u
X12644 DVDD GATE BAT DVDD pfet_06v0 ad=71.8771p pd=0.15481m as=58.1134p ps=77.985u w=76.465u l=1u
X12645 BAT GATE DVDD DVDD pfet_06v0 ad=49.3848p pd=66.5u as=49.3848p ps=66.5u w=64.98u l=1u
X12646 DVDD GATE BAT DVDD pfet_06v0 ad=43.9215p pd=95.32999u as=35.511p ps=48.245u w=46.725u l=1u
X12647 DVDD GATE BAT DVDD pfet_06v0 ad=58.1134p pd=77.985u as=58.1134p ps=77.985u w=76.465u l=1u
X12648 BAT GATE DVDD DVDD pfet_06v0 ad=58.1134p pd=77.985u as=58.1134p ps=77.985u w=76.465u l=1u
X12649 DVDD GATE BAT DVDD pfet_06v0 ad=58.1134p pd=77.985u as=58.1134p ps=77.985u w=76.465u l=1u
X12650 DVDD GATE BAT DVDD pfet_06v0 ad=49.3848p pd=66.5u as=49.3848p ps=66.5u w=64.98u l=1u
X12651 BAT GATE DVDD DVDD pfet_06v0 ad=58.1134p pd=77.985u as=58.1134p ps=77.985u w=76.465u l=1u
X12652 DVDD GATE BAT DVDD pfet_06v0 ad=58.1552p pd=78.04u as=58.1552p ps=78.04u w=76.52u l=1u
X12653 DVDD GATE BAT DVDD pfet_06v0 ad=58.0754p pd=77.935u as=58.0754p ps=77.935u w=76.41499u l=1u
X12654 BAT GATE DVDD DVDD pfet_06v0 ad=58.1134p pd=77.985u as=71.8771p ps=0.15481m w=76.465u l=1u
X12655 DVDD GATE BAT DVDD pfet_06v0 ad=71.92879p pd=0.15492m as=58.1552p ps=78.04u w=76.52u l=1u
X12656 BAT GATE DVDD DVDD pfet_06v0 ad=47.6862p pd=64.265u as=47.6862p ps=64.265u w=62.745u l=1u
X12657 BAT GATE DVDD DVDD pfet_06v0 ad=58.1134p pd=77.985u as=71.8771p ps=0.15481m w=76.465u l=1u
X12658 BAT GATE DVDD DVDD pfet_06v0 ad=58.1134p pd=77.985u as=58.1134p ps=77.985u w=76.465u l=1u
X12659 DVDD GATE BAT DVDD pfet_06v0 ad=35.511p pd=48.245u as=35.511p ps=48.245u w=46.725u l=1u
X12660 DVDD GATE BAT DVDD pfet_06v0 ad=58.1134p pd=77.985u as=58.1134p ps=77.985u w=76.465u l=1u
X12661 BAT GATE DVDD DVDD pfet_06v0 ad=35.511p pd=48.245u as=35.511p ps=48.245u w=46.725u l=1u
X12662 DVDD GATE BAT DVDD pfet_06v0 ad=71.8771p pd=0.15481m as=58.1134p ps=77.985u w=76.465u l=1u
X12663 BAT GATE DVDD DVDD pfet_06v0 ad=58.1134p pd=77.985u as=58.1134p ps=77.985u w=76.465u l=1u
X12664 DVDD GATE BAT DVDD pfet_06v0 ad=58.1134p pd=77.985u as=58.1134p ps=77.985u w=76.465u l=1u
X12665 BAT GATE DVDD DVDD pfet_06v0 ad=58.1134p pd=77.985u as=58.1134p ps=77.985u w=76.465u l=1u
X12666 BAT GATE DVDD DVDD pfet_06v0 ad=35.511p pd=48.245u as=35.511p ps=48.245u w=46.725u l=1u
X12667 DVDD GATE BAT DVDD pfet_06v0 ad=58.1172p pd=77.99u as=58.1172p ps=77.99u w=76.47u l=1u
X12668 BAT GATE DVDD DVDD pfet_06v0 ad=58.1134p pd=77.985u as=58.1134p ps=77.985u w=76.465u l=1u
X12669 DVDD GATE BAT DVDD pfet_06v0 ad=35.511p pd=48.245u as=35.511p ps=48.245u w=46.725u l=1u
X12670 BAT GATE DVDD DVDD pfet_06v0 ad=35.511p pd=48.245u as=35.511p ps=48.245u w=46.725u l=1u
X12671 BAT GATE DVDD DVDD pfet_06v0 ad=35.511p pd=48.245u as=43.9215p ps=95.32999u w=46.725u l=1u
X12672 DVDD GATE BAT DVDD pfet_06v0 ad=35.511p pd=48.245u as=35.511p ps=48.245u w=46.725u l=1u
X12673 BAT GATE DVDD DVDD pfet_06v0 ad=58.0754p pd=77.935u as=71.8301p ps=0.15471m w=76.41499u l=1u
X12674 DVDD GATE BAT DVDD pfet_06v0 ad=58.1552p pd=78.04u as=58.1552p ps=78.04u w=76.52u l=1u
X12675 BAT GATE DVDD DVDD pfet_06v0 ad=35.511p pd=48.245u as=35.511p ps=48.245u w=46.725u l=1u
X12676 DVDD GATE BAT DVDD pfet_06v0 ad=35.511p pd=48.245u as=35.511p ps=48.245u w=46.725u l=1u
X12677 DVDD GATE BAT DVDD pfet_06v0 ad=35.511p pd=48.245u as=35.511p ps=48.245u w=46.725u l=1u
X12678 BAT GATE DVDD DVDD pfet_06v0 ad=35.511p pd=48.245u as=35.511p ps=48.245u w=46.725u l=1u
X12679 BAT GATE DVDD DVDD pfet_06v0 ad=35.511p pd=48.245u as=43.9215p ps=95.32999u w=46.725u l=1u
X12680 BAT GATE DVDD DVDD pfet_06v0 ad=58.1134p pd=77.985u as=71.8771p ps=0.15481m w=76.465u l=1u
X12681 DVDD GATE BAT DVDD pfet_06v0 ad=35.511p pd=48.245u as=35.511p ps=48.245u w=46.725u l=1u
X12682 BAT GATE DVDD DVDD pfet_06v0 ad=35.511p pd=48.245u as=35.511p ps=48.245u w=46.725u l=1u
X12683 DVDD GATE BAT DVDD pfet_06v0 ad=58.1134p pd=77.985u as=58.1134p ps=77.985u w=76.465u l=1u
X12684 BAT GATE DVDD DVDD pfet_06v0 ad=35.511p pd=48.245u as=35.511p ps=48.245u w=46.725u l=1u
X12685 BAT GATE DVDD DVDD pfet_06v0 ad=47.6862p pd=64.265u as=58.9803p ps=0.12737m w=62.745u l=1u
X12686 DVDD GATE BAT DVDD pfet_06v0 ad=58.1552p pd=78.04u as=58.1552p ps=78.04u w=76.52u l=1u
X12687 BAT GATE DVDD DVDD pfet_06v0 ad=58.1134p pd=77.985u as=58.1134p ps=77.985u w=76.465u l=1u
X12688 DVDD GATE BAT DVDD pfet_06v0 ad=43.9215p pd=95.32999u as=35.511p ps=48.245u w=46.725u l=1u
X12689 BAT GATE DVDD DVDD pfet_06v0 ad=58.1172p pd=77.99u as=58.1172p ps=77.99u w=76.47u l=1u
X12690 DVDD GATE BAT DVDD pfet_06v0 ad=35.511p pd=48.245u as=35.511p ps=48.245u w=46.725u l=1u
X12691 BAT GATE DVDD DVDD pfet_06v0 ad=58.1096p pd=77.98u as=71.8724p ps=0.1548m w=76.46u l=1u
X12692 BAT GATE DVDD DVDD pfet_06v0 ad=58.1552p pd=78.04u as=58.1552p ps=78.04u w=76.52u l=1u
X12693 BAT GATE DVDD DVDD pfet_06v0 ad=58.1134p pd=77.985u as=58.1134p ps=77.985u w=76.465u l=1u
X12694 BAT GATE DVDD DVDD pfet_06v0 ad=35.511p pd=48.245u as=35.511p ps=48.245u w=46.725u l=1u
X12695 DVDD GATE BAT DVDD pfet_06v0 ad=35.511p pd=48.245u as=35.511p ps=48.245u w=46.725u l=1u
X12696 BAT GATE DVDD DVDD pfet_06v0 ad=49.3848p pd=66.5u as=49.3848p ps=66.5u w=64.98u l=1u
X12697 BAT GATE DVDD DVDD pfet_06v0 ad=35.511p pd=48.245u as=43.9215p ps=95.32999u w=46.725u l=1u
X12698 BAT GATE DVDD DVDD pfet_06v0 ad=35.511p pd=48.245u as=35.511p ps=48.245u w=46.725u l=1u
X12699 DVDD GATE BAT DVDD pfet_06v0 ad=49.3848p pd=66.5u as=49.3848p ps=66.5u w=64.98u l=1u
X12700 DVDD GATE BAT DVDD pfet_06v0 ad=58.1134p pd=77.985u as=58.1134p ps=77.985u w=76.465u l=1u
X12701 DVDD GATE BAT DVDD pfet_06v0 ad=43.9215p pd=95.32999u as=35.511p ps=48.245u w=46.725u l=1u
X12702 BAT GATE DVDD DVDD pfet_06v0 ad=35.511p pd=48.245u as=35.511p ps=48.245u w=46.725u l=1u
X12703 BAT GATE DVDD DVDD pfet_06v0 ad=58.1134p pd=77.985u as=58.1134p ps=77.985u w=76.465u l=1u
X12704 DVDD GATE BAT DVDD pfet_06v0 ad=58.0754p pd=77.935u as=58.0754p ps=77.935u w=76.41499u l=1u
X12705 BAT GATE DVDD DVDD pfet_06v0 ad=35.511p pd=48.245u as=35.511p ps=48.245u w=46.725u l=1u
X12706 BAT GATE DVDD DVDD pfet_06v0 ad=35.511p pd=48.245u as=35.511p ps=48.245u w=46.725u l=1u
X12707 DVDD GATE BAT DVDD pfet_06v0 ad=58.1096p pd=77.98u as=58.1096p ps=77.98u w=76.46u l=1u
X12708 DVDD GATE BAT DVDD pfet_06v0 ad=58.1134p pd=77.985u as=58.1134p ps=77.985u w=76.465u l=1u
X12709 BAT GATE DVDD DVDD pfet_06v0 ad=58.0754p pd=77.935u as=58.0754p ps=77.935u w=76.41499u l=1u
X12710 BAT GATE DVDD DVDD pfet_06v0 ad=35.511p pd=48.245u as=43.9215p ps=95.32999u w=46.725u l=1u
X12711 DVDD GATE BAT DVDD pfet_06v0 ad=71.8771p pd=0.15481m as=58.1134p ps=77.985u w=76.465u l=1u
X12712 DVDD GATE BAT DVDD pfet_06v0 ad=35.511p pd=48.245u as=35.511p ps=48.245u w=46.725u l=1u
X12713 BAT GATE DVDD DVDD pfet_06v0 ad=35.511p pd=48.245u as=35.511p ps=48.245u w=46.725u l=1u
X12714 DVDD GATE BAT DVDD pfet_06v0 ad=35.511p pd=48.245u as=35.511p ps=48.245u w=46.725u l=1u
X12715 DVDD GATE BAT DVDD pfet_06v0 ad=58.1134p pd=77.985u as=58.1134p ps=77.985u w=76.465u l=1u
X12716 DVDD GATE BAT DVDD pfet_06v0 ad=58.1134p pd=77.985u as=58.1134p ps=77.985u w=76.465u l=1u
X12717 BAT GATE DVDD DVDD pfet_06v0 ad=58.1172p pd=77.99u as=58.1172p ps=77.99u w=76.47u l=1u
X12718 DVDD GATE BAT DVDD pfet_06v0 ad=58.1134p pd=77.985u as=58.1134p ps=77.985u w=76.465u l=1u
X12719 DVDD GATE BAT DVDD pfet_06v0 ad=58.9803p pd=0.12737m as=47.6862p ps=64.265u w=62.745u l=1u
X12720 DVDD GATE BAT DVDD pfet_06v0 ad=35.511p pd=48.245u as=35.511p ps=48.245u w=46.725u l=1u
X12721 DVDD GATE BAT DVDD pfet_06v0 ad=35.5072p pd=48.24u as=35.5072p ps=48.24u w=46.72u l=1u
X12722 DVDD GATE BAT DVDD pfet_06v0 ad=35.511p pd=48.245u as=35.511p ps=48.245u w=46.725u l=1u
X12723 BAT GATE DVDD DVDD pfet_06v0 ad=47.6862p pd=64.265u as=47.6862p ps=64.265u w=62.745u l=1u
X12724 BAT GATE DVDD DVDD pfet_06v0 ad=58.1552p pd=78.04u as=58.1552p ps=78.04u w=76.52u l=1u
X12725 BAT GATE DVDD DVDD pfet_06v0 ad=35.511p pd=48.245u as=35.511p ps=48.245u w=46.725u l=1u
X12726 DVDD GATE BAT DVDD pfet_06v0 ad=35.5072p pd=48.24u as=35.5072p ps=48.24u w=46.72u l=1u
X12727 BAT GATE DVDD DVDD pfet_06v0 ad=58.1134p pd=77.985u as=58.1134p ps=77.985u w=76.465u l=1u
X12728 DVDD GATE BAT DVDD pfet_06v0 ad=58.1552p pd=78.04u as=58.1552p ps=78.04u w=76.52u l=1u
X12729 DVDD GATE BAT DVDD pfet_06v0 ad=35.511p pd=48.245u as=35.511p ps=48.245u w=46.725u l=1u
X12730 BAT GATE DVDD DVDD pfet_06v0 ad=58.1134p pd=77.985u as=58.1134p ps=77.985u w=76.465u l=1u
X12731 DVDD GATE BAT DVDD pfet_06v0 ad=35.511p pd=48.245u as=35.511p ps=48.245u w=46.725u l=1u
X12732 BAT GATE DVDD DVDD pfet_06v0 ad=58.1134p pd=77.985u as=71.8771p ps=0.15481m w=76.465u l=1u
X12733 DVDD GATE BAT DVDD pfet_06v0 ad=58.0754p pd=77.935u as=58.0754p ps=77.935u w=76.41499u l=1u
X12734 DVDD GATE BAT DVDD pfet_06v0 ad=71.8301p pd=0.15471m as=58.0754p ps=77.935u w=76.41499u l=1u
X12735 BAT GATE DVDD DVDD pfet_06v0 ad=35.511p pd=48.245u as=35.511p ps=48.245u w=46.725u l=1u
X12736 BAT GATE DVDD DVDD pfet_06v0 ad=35.511p pd=48.245u as=35.511p ps=48.245u w=46.725u l=1u
X12737 DVDD GATE BAT DVDD pfet_06v0 ad=58.1134p pd=77.985u as=58.1134p ps=77.985u w=76.465u l=1u
X12738 BAT GATE DVDD DVDD pfet_06v0 ad=58.1134p pd=77.985u as=58.1134p ps=77.985u w=76.465u l=1u
X12739 DVDD GATE BAT DVDD pfet_06v0 ad=58.1134p pd=77.985u as=58.1134p ps=77.985u w=76.465u l=1u
X12740 DVDD GATE BAT DVDD pfet_06v0 ad=58.1134p pd=77.985u as=58.1134p ps=77.985u w=76.465u l=1u
X12741 DVDD GATE BAT DVDD pfet_06v0 ad=35.511p pd=48.245u as=35.511p ps=48.245u w=46.725u l=1u
X12742 BAT GATE DVDD DVDD pfet_06v0 ad=58.1134p pd=77.985u as=58.1134p ps=77.985u w=76.465u l=1u
X12743 BAT GATE DVDD DVDD pfet_06v0 ad=35.511p pd=48.245u as=43.9215p ps=95.32999u w=46.725u l=1u
X12744 BAT GATE DVDD DVDD pfet_06v0 ad=49.3848p pd=66.5u as=61.0812p ps=0.13184m w=64.98u l=1u
X12745 DVDD GATE BAT DVDD pfet_06v0 ad=35.511p pd=48.245u as=35.511p ps=48.245u w=46.725u l=1u
X12746 BAT GATE DVDD DVDD pfet_06v0 ad=58.1172p pd=77.99u as=71.8818p ps=0.15482m w=76.47u l=1u
X12747 DVDD GATE BAT DVDD pfet_06v0 ad=35.511p pd=48.245u as=35.511p ps=48.245u w=46.725u l=1u
X12748 DVDD GATE BAT DVDD pfet_06v0 ad=43.9215p pd=95.32999u as=35.511p ps=48.245u w=46.725u l=1u
X12749 BAT GATE DVDD DVDD pfet_06v0 ad=58.1134p pd=77.985u as=58.1134p ps=77.985u w=76.465u l=1u
X12750 DVDD GATE BAT DVDD pfet_06v0 ad=35.511p pd=48.245u as=35.511p ps=48.245u w=46.725u l=1u
X12751 DVDD GATE BAT DVDD pfet_06v0 ad=58.1096p pd=77.98u as=58.1096p ps=77.98u w=76.46u l=1u
X12752 BAT GATE DVDD DVDD pfet_06v0 ad=58.1172p pd=77.99u as=58.1172p ps=77.99u w=76.47u l=1u
X12753 BAT GATE DVDD DVDD pfet_06v0 ad=35.511p pd=48.245u as=35.511p ps=48.245u w=46.725u l=1u
X12754 DVDD GATE BAT DVDD pfet_06v0 ad=58.1134p pd=77.985u as=58.1134p ps=77.985u w=76.465u l=1u
X12755 BAT GATE DVDD DVDD pfet_06v0 ad=35.511p pd=48.245u as=35.511p ps=48.245u w=46.725u l=1u
X12756 BAT GATE DVDD DVDD pfet_06v0 ad=35.5072p pd=48.24u as=35.5072p ps=48.24u w=46.72u l=1u
X12757 BAT GATE DVDD DVDD pfet_06v0 ad=35.511p pd=48.245u as=35.511p ps=48.245u w=46.725u l=1u
X12758 BAT GATE DVDD DVDD pfet_06v0 ad=58.1134p pd=77.985u as=58.1134p ps=77.985u w=76.465u l=1u
X12759 DVDD GATE BAT DVDD pfet_06v0 ad=35.511p pd=48.245u as=35.511p ps=48.245u w=46.725u l=1u
X12760 DVDD GATE BAT DVDD pfet_06v0 ad=58.1134p pd=77.985u as=58.1134p ps=77.985u w=76.465u l=1u
X12761 BAT GATE DVDD DVDD pfet_06v0 ad=35.511p pd=48.245u as=35.511p ps=48.245u w=46.725u l=1u
X12762 DVDD GATE BAT DVDD pfet_06v0 ad=58.1134p pd=77.985u as=58.1134p ps=77.985u w=76.465u l=1u
X12763 BAT GATE DVDD DVDD pfet_06v0 ad=35.511p pd=48.245u as=35.511p ps=48.245u w=46.725u l=1u
X12764 BAT GATE DVDD DVDD pfet_06v0 ad=58.1134p pd=77.985u as=58.1134p ps=77.985u w=76.465u l=1u
X12765 DVDD GATE BAT DVDD pfet_06v0 ad=58.0754p pd=77.935u as=58.0754p ps=77.935u w=76.41499u l=1u
X12766 BAT GATE DVDD DVDD pfet_06v0 ad=35.511p pd=48.245u as=35.511p ps=48.245u w=46.725u l=1u
X12767 BAT GATE DVDD DVDD pfet_06v0 ad=58.1096p pd=77.98u as=71.8724p ps=0.1548m w=76.46u l=1u
X12768 BAT GATE DVDD DVDD pfet_06v0 ad=35.511p pd=48.245u as=35.511p ps=48.245u w=46.725u l=1u
X12769 DVDD GATE BAT DVDD pfet_06v0 ad=35.511p pd=48.245u as=35.511p ps=48.245u w=46.725u l=1u
X12770 DVDD GATE BAT DVDD pfet_06v0 ad=35.511p pd=48.245u as=35.511p ps=48.245u w=46.725u l=1u
X12771 DVDD GATE BAT DVDD pfet_06v0 ad=47.6862p pd=64.265u as=47.6862p ps=64.265u w=62.745u l=1u
X12772 DVDD GATE BAT DVDD pfet_06v0 ad=71.8818p pd=0.15482m as=58.1172p ps=77.99u w=76.47u l=1u
X12773 BAT GATE DVDD DVDD pfet_06v0 ad=35.511p pd=48.245u as=43.9215p ps=95.32999u w=46.725u l=1u
X12774 BAT GATE DVDD DVDD pfet_06v0 ad=58.1134p pd=77.985u as=58.1134p ps=77.985u w=76.465u l=1u
X12775 DVDD GATE BAT DVDD pfet_06v0 ad=35.511p pd=48.245u as=35.511p ps=48.245u w=46.725u l=1u
X12776 BAT GATE DVDD DVDD pfet_06v0 ad=35.511p pd=48.245u as=35.511p ps=48.245u w=46.725u l=1u
X12777 BAT GATE DVDD DVDD pfet_06v0 ad=58.1134p pd=77.985u as=58.1134p ps=77.985u w=76.465u l=1u
X12778 BAT GATE DVDD DVDD pfet_06v0 ad=35.5072p pd=48.24u as=35.5072p ps=48.24u w=46.72u l=1u
X12779 BAT GATE DVDD DVDD pfet_06v0 ad=58.1134p pd=77.985u as=58.1134p ps=77.985u w=76.465u l=1u
X12780 DVDD GATE BAT DVDD pfet_06v0 ad=58.1172p pd=77.99u as=58.1172p ps=77.99u w=76.47u l=1u
X12781 BAT GATE DVDD DVDD pfet_06v0 ad=35.511p pd=48.245u as=35.511p ps=48.245u w=46.725u l=1u
X12782 DVDD GATE BAT DVDD pfet_06v0 ad=58.1134p pd=77.985u as=58.1134p ps=77.985u w=76.465u l=1u
X12783 DVDD GATE BAT DVDD pfet_06v0 ad=58.1552p pd=78.04u as=58.1552p ps=78.04u w=76.52u l=1u
X12784 BAT GATE DVDD DVDD pfet_06v0 ad=35.511p pd=48.245u as=35.511p ps=48.245u w=46.725u l=1u
X12785 BAT GATE DVDD DVDD pfet_06v0 ad=49.3848p pd=66.5u as=49.3848p ps=66.5u w=64.98u l=1u
X12786 DVDD GATE BAT DVDD pfet_06v0 ad=35.511p pd=48.245u as=35.511p ps=48.245u w=46.725u l=1u
X12787 DVDD GATE BAT DVDD pfet_06v0 ad=58.1134p pd=77.985u as=58.1134p ps=77.985u w=76.465u l=1u
X12788 DVDD GATE BAT DVDD pfet_06v0 ad=43.9215p pd=95.32999u as=35.511p ps=48.245u w=46.725u l=1u
X12789 DVDD GATE BAT DVDD pfet_06v0 ad=35.511p pd=48.245u as=35.511p ps=48.245u w=46.725u l=1u
X12790 BAT GATE DVDD DVDD pfet_06v0 ad=58.0754p pd=77.935u as=58.0754p ps=77.935u w=76.41499u l=1u
X12791 BAT GATE DVDD DVDD pfet_06v0 ad=58.1096p pd=77.98u as=58.1096p ps=77.98u w=76.46u l=1u
X12792 BAT GATE DVDD DVDD pfet_06v0 ad=35.511p pd=48.245u as=35.511p ps=48.245u w=46.725u l=1u
X12793 BAT GATE DVDD DVDD pfet_06v0 ad=58.1134p pd=77.985u as=58.1134p ps=77.985u w=76.465u l=1u
X12794 BAT GATE DVDD DVDD pfet_06v0 ad=35.511p pd=48.245u as=35.511p ps=48.245u w=46.725u l=1u
X12795 DVDD GATE BAT DVDD pfet_06v0 ad=47.6862p pd=64.265u as=47.6862p ps=64.265u w=62.745u l=1u
X12796 DVDD GATE BAT DVDD pfet_06v0 ad=58.1134p pd=77.985u as=58.1134p ps=77.985u w=76.465u l=1u
X12797 BAT GATE DVDD DVDD pfet_06v0 ad=58.1134p pd=77.985u as=58.1134p ps=77.985u w=76.465u l=1u
X12798 BAT GATE DVDD DVDD pfet_06v0 ad=58.1134p pd=77.985u as=71.8771p ps=0.15481m w=76.465u l=1u
X12799 DVDD GATE BAT DVDD pfet_06v0 ad=58.1134p pd=77.985u as=58.1134p ps=77.985u w=76.465u l=1u
X12800 DVDD GATE BAT DVDD pfet_06v0 ad=35.511p pd=48.245u as=35.511p ps=48.245u w=46.725u l=1u
X12801 DVDD GATE BAT DVDD pfet_06v0 ad=35.511p pd=48.245u as=35.511p ps=48.245u w=46.725u l=1u
X12802 BAT GATE DVDD DVDD pfet_06v0 ad=35.5072p pd=48.24u as=35.5072p ps=48.24u w=46.72u l=1u
X12803 BAT GATE DVDD DVDD pfet_06v0 ad=58.1134p pd=77.985u as=58.1134p ps=77.985u w=76.465u l=1u
X12804 BAT GATE DVDD DVDD pfet_06v0 ad=58.1134p pd=77.985u as=58.1134p ps=77.985u w=76.465u l=1u
X12805 BAT GATE DVDD DVDD pfet_06v0 ad=58.1134p pd=77.985u as=58.1134p ps=77.985u w=76.465u l=1u
X12806 DVDD GATE BAT DVDD pfet_06v0 ad=58.0754p pd=77.935u as=58.0754p ps=77.935u w=76.41499u l=1u
X12807 BAT GATE DVDD DVDD pfet_06v0 ad=35.511p pd=48.245u as=43.9215p ps=95.32999u w=46.725u l=1u
X12808 DVDD GATE BAT DVDD pfet_06v0 ad=58.1134p pd=77.985u as=58.1134p ps=77.985u w=76.465u l=1u
X12809 BAT GATE DVDD DVDD pfet_06v0 ad=35.511p pd=48.245u as=43.9215p ps=95.32999u w=46.725u l=1u
X12810 DVDD GATE BAT DVDD pfet_06v0 ad=71.92879p pd=0.15492m as=58.1552p ps=78.04u w=76.52u l=1u
X12811 DVDD GATE BAT DVDD pfet_06v0 ad=58.1172p pd=77.99u as=58.1172p ps=77.99u w=76.47u l=1u
X12812 DVDD GATE BAT DVDD pfet_06v0 ad=49.3848p pd=66.5u as=49.3848p ps=66.5u w=64.98u l=1u
X12813 DVDD GATE BAT DVDD pfet_06v0 ad=58.1134p pd=77.985u as=58.1134p ps=77.985u w=76.465u l=1u
X12814 BAT GATE DVDD DVDD pfet_06v0 ad=58.1552p pd=78.04u as=58.1552p ps=78.04u w=76.52u l=1u
X12815 BAT GATE DVDD DVDD pfet_06v0 ad=35.511p pd=48.245u as=35.511p ps=48.245u w=46.725u l=1u
X12816 BAT GATE DVDD DVDD pfet_06v0 ad=49.3848p pd=66.5u as=49.3848p ps=66.5u w=64.98u l=1u
X12817 DVDD GATE BAT DVDD pfet_06v0 ad=58.1134p pd=77.985u as=58.1134p ps=77.985u w=76.465u l=1u
X12818 BAT GATE DVDD DVDD pfet_06v0 ad=58.1134p pd=77.985u as=71.8771p ps=0.15481m w=76.465u l=1u
X12819 BAT GATE DVDD DVDD pfet_06v0 ad=58.1552p pd=78.04u as=71.92879p ps=0.15492m w=76.52u l=1u
X12820 BAT GATE DVDD DVDD pfet_06v0 ad=58.1096p pd=77.98u as=58.1096p ps=77.98u w=76.46u l=1u
X12821 BAT GATE DVDD DVDD pfet_06v0 ad=35.511p pd=48.245u as=35.511p ps=48.245u w=46.725u l=1u
X12822 BAT GATE DVDD DVDD pfet_06v0 ad=35.511p pd=48.245u as=35.511p ps=48.245u w=46.725u l=1u
X12823 DVDD GATE BAT DVDD pfet_06v0 ad=58.1134p pd=77.985u as=58.1134p ps=77.985u w=76.465u l=1u
X12824 BAT GATE DVDD DVDD pfet_06v0 ad=35.511p pd=48.245u as=35.511p ps=48.245u w=46.725u l=1u
X12825 BAT GATE DVDD DVDD pfet_06v0 ad=58.1552p pd=78.04u as=58.1552p ps=78.04u w=76.52u l=1u
X12826 BAT GATE DVDD DVDD pfet_06v0 ad=58.1552p pd=78.04u as=58.1552p ps=78.04u w=76.52u l=1u
X12827 BAT GATE DVDD DVDD pfet_06v0 ad=58.0754p pd=77.935u as=58.0754p ps=77.935u w=76.41499u l=1u
X12828 BAT GATE DVDD DVDD pfet_06v0 ad=58.0754p pd=77.935u as=58.0754p ps=77.935u w=76.41499u l=1u
X12829 BAT GATE DVDD DVDD pfet_06v0 ad=35.5072p pd=48.24u as=35.5072p ps=48.24u w=46.72u l=1u
X12830 DVDD GATE BAT DVDD pfet_06v0 ad=35.511p pd=48.245u as=35.511p ps=48.245u w=46.725u l=1u
X12831 DVDD GATE BAT DVDD pfet_06v0 ad=35.511p pd=48.245u as=35.511p ps=48.245u w=46.725u l=1u
X12832 BAT GATE DVDD DVDD pfet_06v0 ad=35.511p pd=48.245u as=35.511p ps=48.245u w=46.725u l=1u
X12833 BAT GATE DVDD DVDD pfet_06v0 ad=58.1134p pd=77.985u as=58.1134p ps=77.985u w=76.465u l=1u
X12834 BAT GATE DVDD DVDD pfet_06v0 ad=58.1134p pd=77.985u as=58.1134p ps=77.985u w=76.465u l=1u
X12835 BAT GATE DVDD DVDD pfet_06v0 ad=58.1172p pd=77.99u as=58.1172p ps=77.99u w=76.47u l=1u
X12836 DVDD GATE BAT DVDD pfet_06v0 ad=35.511p pd=48.245u as=35.511p ps=48.245u w=46.725u l=1u
X12837 DVDD GATE BAT DVDD pfet_06v0 ad=49.3848p pd=66.5u as=49.3848p ps=66.5u w=64.98u l=1u
X12838 BAT GATE DVDD DVDD pfet_06v0 ad=49.3848p pd=66.5u as=49.3848p ps=66.5u w=64.98u l=1u
X12839 DVDD GATE BAT DVDD pfet_06v0 ad=47.6862p pd=64.265u as=47.6862p ps=64.265u w=62.745u l=1u
X12840 DVDD GATE BAT DVDD pfet_06v0 ad=58.0754p pd=77.935u as=58.0754p ps=77.935u w=76.41499u l=1u
X12841 DVDD GATE BAT DVDD pfet_06v0 ad=49.3848p pd=66.5u as=49.3848p ps=66.5u w=64.98u l=1u
X12842 DVDD GATE BAT DVDD pfet_06v0 ad=43.9215p pd=95.32999u as=35.511p ps=48.245u w=46.725u l=1u
X12843 DVDD GATE BAT DVDD pfet_06v0 ad=35.511p pd=48.245u as=35.511p ps=48.245u w=46.725u l=1u
X12844 BAT GATE DVDD DVDD pfet_06v0 ad=35.511p pd=48.245u as=35.511p ps=48.245u w=46.725u l=1u
X12845 BAT GATE DVDD DVDD pfet_06v0 ad=58.1134p pd=77.985u as=58.1134p ps=77.985u w=76.465u l=1u
X12846 DVDD GATE BAT DVDD pfet_06v0 ad=58.1134p pd=77.985u as=58.1134p ps=77.985u w=76.465u l=1u
X12847 BAT GATE DVDD DVDD pfet_06v0 ad=35.511p pd=48.245u as=35.511p ps=48.245u w=46.725u l=1u
X12848 DVDD GATE BAT DVDD pfet_06v0 ad=71.8771p pd=0.15481m as=58.1134p ps=77.985u w=76.465u l=1u
X12849 DVDD GATE BAT DVDD pfet_06v0 ad=43.9215p pd=95.32999u as=35.511p ps=48.245u w=46.725u l=1u
X12850 BAT GATE DVDD DVDD pfet_06v0 ad=58.1134p pd=77.985u as=58.1134p ps=77.985u w=76.465u l=1u
X12851 DVDD GATE BAT DVDD pfet_06v0 ad=49.3848p pd=66.5u as=49.3848p ps=66.5u w=64.98u l=1u
X12852 BAT GATE DVDD DVDD pfet_06v0 ad=35.511p pd=48.245u as=35.511p ps=48.245u w=46.725u l=1u
X12853 BAT GATE DVDD DVDD pfet_06v0 ad=49.3848p pd=66.5u as=61.0812p ps=0.13184m w=64.98u l=1u
X12854 DVDD GATE BAT DVDD pfet_06v0 ad=58.1172p pd=77.99u as=58.1172p ps=77.99u w=76.47u l=1u
X12855 DVDD GATE BAT DVDD pfet_06v0 ad=35.511p pd=48.245u as=35.511p ps=48.245u w=46.725u l=1u
X12856 DVDD GATE BAT DVDD pfet_06v0 ad=49.3848p pd=66.5u as=49.3848p ps=66.5u w=64.98u l=1u
X12857 BAT GATE DVDD DVDD pfet_06v0 ad=58.1134p pd=77.985u as=58.1134p ps=77.985u w=76.465u l=1u
X12858 BAT GATE DVDD DVDD pfet_06v0 ad=58.1134p pd=77.985u as=58.1134p ps=77.985u w=76.465u l=1u
X12859 DVDD GATE BAT DVDD pfet_06v0 ad=35.5072p pd=48.24u as=35.5072p ps=48.24u w=46.72u l=1u
X12860 BAT GATE DVDD DVDD pfet_06v0 ad=35.511p pd=48.245u as=35.511p ps=48.245u w=46.725u l=1u
X12861 DVDD GATE BAT DVDD pfet_06v0 ad=35.511p pd=48.245u as=35.511p ps=48.245u w=46.725u l=1u
X12862 DVDD GATE BAT DVDD pfet_06v0 ad=58.1134p pd=77.985u as=58.1134p ps=77.985u w=76.465u l=1u
X12863 BAT GATE DVDD DVDD pfet_06v0 ad=58.1552p pd=78.04u as=58.1552p ps=78.04u w=76.52u l=1u
X12864 DVDD GATE BAT DVDD pfet_06v0 ad=47.6862p pd=64.265u as=47.6862p ps=64.265u w=62.745u l=1u
X12865 DVDD GATE BAT DVDD pfet_06v0 ad=35.511p pd=48.245u as=35.511p ps=48.245u w=46.725u l=1u
X12866 DVDD GATE BAT DVDD pfet_06v0 ad=35.511p pd=48.245u as=35.511p ps=48.245u w=46.725u l=1u
X12867 BAT GATE DVDD DVDD pfet_06v0 ad=58.1134p pd=77.985u as=58.1134p ps=77.985u w=76.465u l=1u
X12868 BAT GATE DVDD DVDD pfet_06v0 ad=35.511p pd=48.245u as=35.511p ps=48.245u w=46.725u l=1u
X12869 BAT GATE DVDD DVDD pfet_06v0 ad=35.511p pd=48.245u as=35.511p ps=48.245u w=46.725u l=1u
X12870 DVDD GATE BAT DVDD pfet_06v0 ad=35.511p pd=48.245u as=35.511p ps=48.245u w=46.725u l=1u
X12871 BAT GATE DVDD DVDD pfet_06v0 ad=35.511p pd=48.245u as=43.9215p ps=95.32999u w=46.725u l=1u
X12872 BAT GATE DVDD DVDD pfet_06v0 ad=58.1172p pd=77.99u as=58.1172p ps=77.99u w=76.47u l=1u
X12873 DVDD GATE BAT DVDD pfet_06v0 ad=35.511p pd=48.245u as=35.511p ps=48.245u w=46.725u l=1u
X12874 BAT GATE DVDD DVDD pfet_06v0 ad=35.511p pd=48.245u as=43.9215p ps=95.32999u w=46.725u l=1u
X12875 BAT GATE DVDD DVDD pfet_06v0 ad=58.1172p pd=77.99u as=58.1172p ps=77.99u w=76.47u l=1u
X12876 DVDD GATE BAT DVDD pfet_06v0 ad=58.1134p pd=77.985u as=58.1134p ps=77.985u w=76.465u l=1u
X12877 DVDD GATE BAT DVDD pfet_06v0 ad=35.511p pd=48.245u as=35.511p ps=48.245u w=46.725u l=1u
X12878 DVDD GATE BAT DVDD pfet_06v0 ad=35.5072p pd=48.24u as=35.5072p ps=48.24u w=46.72u l=1u
X12879 DVDD GATE BAT DVDD pfet_06v0 ad=58.1134p pd=77.985u as=58.1134p ps=77.985u w=76.465u l=1u
X12880 DVDD GATE BAT DVDD pfet_06v0 ad=35.511p pd=48.245u as=35.511p ps=48.245u w=46.725u l=1u
X12881 BAT GATE DVDD DVDD pfet_06v0 ad=58.1134p pd=77.985u as=58.1134p ps=77.985u w=76.465u l=1u
X12882 BAT GATE DVDD DVDD pfet_06v0 ad=35.511p pd=48.245u as=35.511p ps=48.245u w=46.725u l=1u
X12883 BAT GATE DVDD DVDD pfet_06v0 ad=58.1134p pd=77.985u as=58.1134p ps=77.985u w=76.465u l=1u
X12884 BAT GATE DVDD DVDD pfet_06v0 ad=35.511p pd=48.245u as=35.511p ps=48.245u w=46.725u l=1u
X12885 BAT GATE DVDD DVDD pfet_06v0 ad=58.1134p pd=77.985u as=58.1134p ps=77.985u w=76.465u l=1u
X12886 BAT GATE DVDD DVDD pfet_06v0 ad=35.511p pd=48.245u as=35.511p ps=48.245u w=46.725u l=1u
X12887 DVDD GATE BAT DVDD pfet_06v0 ad=35.511p pd=48.245u as=35.511p ps=48.245u w=46.725u l=1u
X12888 DVDD GATE BAT DVDD pfet_06v0 ad=71.8771p pd=0.15481m as=58.1134p ps=77.985u w=76.465u l=1u
X12889 DVDD GATE BAT DVDD pfet_06v0 ad=35.511p pd=48.245u as=35.511p ps=48.245u w=46.725u l=1u
X12890 BAT GATE DVDD DVDD pfet_06v0 ad=35.511p pd=48.245u as=43.9215p ps=95.32999u w=46.725u l=1u
X12891 DVDD GATE BAT DVDD pfet_06v0 ad=35.511p pd=48.245u as=35.511p ps=48.245u w=46.725u l=1u
X12892 DVDD GATE BAT DVDD pfet_06v0 ad=43.9215p pd=95.32999u as=35.511p ps=48.245u w=46.725u l=1u
X12893 BAT GATE DVDD DVDD pfet_06v0 ad=35.511p pd=48.245u as=35.511p ps=48.245u w=46.725u l=1u
X12894 DVDD GATE BAT DVDD pfet_06v0 ad=58.1134p pd=77.985u as=58.1134p ps=77.985u w=76.465u l=1u
X12895 DVDD GATE BAT DVDD pfet_06v0 ad=43.9215p pd=95.32999u as=35.511p ps=48.245u w=46.725u l=1u
X12896 DVDD GATE BAT DVDD pfet_06v0 ad=58.1552p pd=78.04u as=58.1552p ps=78.04u w=76.52u l=1u
X12897 BAT GATE DVDD DVDD pfet_06v0 ad=35.511p pd=48.245u as=35.511p ps=48.245u w=46.725u l=1u
X12898 BAT GATE DVDD DVDD pfet_06v0 ad=35.511p pd=48.245u as=35.511p ps=48.245u w=46.725u l=1u
X12899 BAT GATE DVDD DVDD pfet_06v0 ad=35.511p pd=48.245u as=35.511p ps=48.245u w=46.725u l=1u
X12900 BAT GATE DVDD DVDD pfet_06v0 ad=58.1552p pd=78.04u as=58.1552p ps=78.04u w=76.52u l=1u
X12901 DVDD GATE BAT DVDD pfet_06v0 ad=58.1134p pd=77.985u as=58.1134p ps=77.985u w=76.465u l=1u
X12902 BAT GATE DVDD DVDD pfet_06v0 ad=35.511p pd=48.245u as=35.511p ps=48.245u w=46.725u l=1u
X12903 DVDD GATE BAT DVDD pfet_06v0 ad=58.1134p pd=77.985u as=58.1134p ps=77.985u w=76.465u l=1u
X12904 DVDD GATE BAT DVDD pfet_06v0 ad=58.1096p pd=77.98u as=58.1096p ps=77.98u w=76.46u l=1u
X12905 BAT GATE DVDD DVDD pfet_06v0 ad=58.1134p pd=77.985u as=58.1134p ps=77.985u w=76.465u l=1u
X12906 DVDD GATE BAT DVDD pfet_06v0 ad=49.3848p pd=66.5u as=49.3848p ps=66.5u w=64.98u l=1u
X12907 DVDD GATE BAT DVDD pfet_06v0 ad=43.9215p pd=95.32999u as=35.511p ps=48.245u w=46.725u l=1u
X12908 DVDD GATE BAT DVDD pfet_06v0 ad=71.8771p pd=0.15481m as=58.1134p ps=77.985u w=76.465u l=1u
X12909 BAT GATE DVDD DVDD pfet_06v0 ad=49.3848p pd=66.5u as=49.3848p ps=66.5u w=64.98u l=1u
X12910 BAT GATE DVDD DVDD pfet_06v0 ad=35.511p pd=48.245u as=35.511p ps=48.245u w=46.725u l=1u
X12911 BAT GATE DVDD DVDD pfet_06v0 ad=58.1134p pd=77.985u as=71.8771p ps=0.15481m w=76.465u l=1u
X12912 DVDD GATE BAT DVDD pfet_06v0 ad=58.1134p pd=77.985u as=58.1134p ps=77.985u w=76.465u l=1u
X12913 DVDD GATE BAT DVDD pfet_06v0 ad=35.511p pd=48.245u as=35.511p ps=48.245u w=46.725u l=1u
X12914 DVDD GATE BAT DVDD pfet_06v0 ad=49.3848p pd=66.5u as=49.3848p ps=66.5u w=64.98u l=1u
X12915 DVDD GATE BAT DVDD pfet_06v0 ad=58.1096p pd=77.98u as=58.1096p ps=77.98u w=76.46u l=1u
X12916 DVDD GATE BAT DVDD pfet_06v0 ad=58.1134p pd=77.985u as=58.1134p ps=77.985u w=76.465u l=1u
X12917 DVDD GATE BAT DVDD pfet_06v0 ad=58.0754p pd=77.935u as=58.0754p ps=77.935u w=76.41499u l=1u
X12918 DVDD GATE BAT DVDD pfet_06v0 ad=49.3848p pd=66.5u as=49.3848p ps=66.5u w=64.98u l=1u
X12919 DVDD GATE BAT DVDD pfet_06v0 ad=35.511p pd=48.245u as=35.511p ps=48.245u w=46.725u l=1u
X12920 DVDD GATE BAT DVDD pfet_06v0 ad=35.511p pd=48.245u as=35.511p ps=48.245u w=46.725u l=1u
X12921 BAT GATE DVDD DVDD pfet_06v0 ad=58.1134p pd=77.985u as=58.1134p ps=77.985u w=76.465u l=1u
X12922 BAT GATE DVDD DVDD pfet_06v0 ad=58.1134p pd=77.985u as=58.1134p ps=77.985u w=76.465u l=1u
X12923 DVDD GATE BAT DVDD pfet_06v0 ad=43.9215p pd=95.32999u as=35.511p ps=48.245u w=46.725u l=1u
X12924 BAT GATE DVDD DVDD pfet_06v0 ad=58.0754p pd=77.935u as=58.0754p ps=77.935u w=76.41499u l=1u
X12925 DVDD GATE BAT DVDD pfet_06v0 ad=35.511p pd=48.245u as=35.511p ps=48.245u w=46.725u l=1u
X12926 BAT GATE DVDD DVDD pfet_06v0 ad=58.1134p pd=77.985u as=58.1134p ps=77.985u w=76.465u l=1u
X12927 DVDD GATE BAT DVDD pfet_06v0 ad=71.8301p pd=0.15471m as=58.0754p ps=77.935u w=76.41499u l=1u
X12928 BAT GATE DVDD DVDD pfet_06v0 ad=58.1172p pd=77.99u as=58.1172p ps=77.99u w=76.47u l=1u
X12929 BAT GATE DVDD DVDD pfet_06v0 ad=47.6862p pd=64.265u as=47.6862p ps=64.265u w=62.745u l=1u
X12930 DVDD GATE BAT DVDD pfet_06v0 ad=35.5072p pd=48.24u as=35.5072p ps=48.24u w=46.72u l=1u
X12931 DVDD GATE BAT DVDD pfet_06v0 ad=35.511p pd=48.245u as=35.511p ps=48.245u w=46.725u l=1u
X12932 BAT GATE DVDD DVDD pfet_06v0 ad=35.511p pd=48.245u as=35.511p ps=48.245u w=46.725u l=1u
X12933 DVDD GATE BAT DVDD pfet_06v0 ad=58.1172p pd=77.99u as=58.1172p ps=77.99u w=76.47u l=1u
X12934 DVDD GATE BAT DVDD pfet_06v0 ad=71.8818p pd=0.15482m as=58.1172p ps=77.99u w=76.47u l=1u
X12935 DVDD GATE BAT DVDD pfet_06v0 ad=58.1134p pd=77.985u as=58.1134p ps=77.985u w=76.465u l=1u
X12936 DVDD GATE BAT DVDD pfet_06v0 ad=35.511p pd=48.245u as=35.511p ps=48.245u w=46.725u l=1u
X12937 BAT GATE DVDD DVDD pfet_06v0 ad=49.3848p pd=66.5u as=49.3848p ps=66.5u w=64.98u l=1u
X12938 BAT GATE DVDD DVDD pfet_06v0 ad=58.0754p pd=77.935u as=71.8301p ps=0.15471m w=76.41499u l=1u
X12939 BAT GATE DVDD DVDD pfet_06v0 ad=49.3848p pd=66.5u as=61.0812p ps=0.13184m w=64.98u l=1u
X12940 BAT GATE DVDD DVDD pfet_06v0 ad=35.511p pd=48.245u as=35.511p ps=48.245u w=46.725u l=1u
X12941 BAT GATE DVDD DVDD pfet_06v0 ad=58.1096p pd=77.98u as=58.1096p ps=77.98u w=76.46u l=1u
X12942 BAT GATE DVDD DVDD pfet_06v0 ad=35.5072p pd=48.24u as=35.5072p ps=48.24u w=46.72u l=1u
X12943 BAT GATE DVDD DVDD pfet_06v0 ad=58.1134p pd=77.985u as=58.1134p ps=77.985u w=76.465u l=1u
X12944 DVDD GATE BAT DVDD pfet_06v0 ad=35.511p pd=48.245u as=35.511p ps=48.245u w=46.725u l=1u
X12945 BAT GATE DVDD DVDD pfet_06v0 ad=58.1134p pd=77.985u as=58.1134p ps=77.985u w=76.465u l=1u
X12946 BAT GATE DVDD DVDD pfet_06v0 ad=35.5072p pd=48.24u as=35.5072p ps=48.24u w=46.72u l=1u
X12947 DVDD GATE BAT DVDD pfet_06v0 ad=58.1134p pd=77.985u as=58.1134p ps=77.985u w=76.465u l=1u
X12948 BAT GATE DVDD DVDD pfet_06v0 ad=49.3848p pd=66.5u as=49.3848p ps=66.5u w=64.98u l=1u
X12949 DVDD GATE BAT DVDD pfet_06v0 ad=35.511p pd=48.245u as=35.511p ps=48.245u w=46.725u l=1u
X12950 BAT GATE DVDD DVDD pfet_06v0 ad=35.511p pd=48.245u as=35.511p ps=48.245u w=46.725u l=1u
X12951 DVDD GATE BAT DVDD pfet_06v0 ad=71.8771p pd=0.15481m as=58.1134p ps=77.985u w=76.465u l=1u
X12952 DVDD GATE BAT DVDD pfet_06v0 ad=58.1134p pd=77.985u as=58.1134p ps=77.985u w=76.465u l=1u
X12953 DVDD GATE BAT DVDD pfet_06v0 ad=58.1134p pd=77.985u as=58.1134p ps=77.985u w=76.465u l=1u
X12954 DVDD GATE BAT DVDD pfet_06v0 ad=58.1552p pd=78.04u as=58.1552p ps=78.04u w=76.52u l=1u
X12955 BAT GATE DVDD DVDD pfet_06v0 ad=35.511p pd=48.245u as=35.511p ps=48.245u w=46.725u l=1u
X12956 BAT GATE DVDD DVDD pfet_06v0 ad=58.1134p pd=77.985u as=71.8771p ps=0.15481m w=76.465u l=1u
X12957 DVDD GATE BAT DVDD pfet_06v0 ad=58.1134p pd=77.985u as=58.1134p ps=77.985u w=76.465u l=1u
X12958 DVDD GATE BAT DVDD pfet_06v0 ad=58.1552p pd=78.04u as=58.1552p ps=78.04u w=76.52u l=1u
X12959 BAT GATE DVDD DVDD pfet_06v0 ad=58.0754p pd=77.935u as=58.0754p ps=77.935u w=76.41499u l=1u
X12960 BAT GATE DVDD DVDD pfet_06v0 ad=58.1134p pd=77.985u as=58.1134p ps=77.985u w=76.465u l=1u
X12961 BAT GATE DVDD DVDD pfet_06v0 ad=47.6862p pd=64.265u as=47.6862p ps=64.265u w=62.745u l=1u
X12962 DVDD GATE BAT DVDD pfet_06v0 ad=71.8771p pd=0.15481m as=58.1134p ps=77.985u w=76.465u l=1u
X12963 DVDD GATE BAT DVDD pfet_06v0 ad=43.9215p pd=95.32999u as=35.511p ps=48.245u w=46.725u l=1u
X12964 BAT GATE DVDD DVDD pfet_06v0 ad=35.511p pd=48.245u as=35.511p ps=48.245u w=46.725u l=1u
X12965 DVDD GATE BAT DVDD pfet_06v0 ad=35.511p pd=48.245u as=35.511p ps=48.245u w=46.725u l=1u
X12966 DVDD GATE BAT DVDD pfet_06v0 ad=71.8771p pd=0.15481m as=58.1134p ps=77.985u w=76.465u l=1u
X12967 BAT GATE DVDD DVDD pfet_06v0 ad=58.1096p pd=77.98u as=58.1096p ps=77.98u w=76.46u l=1u
X12968 DVDD GATE BAT DVDD pfet_06v0 ad=58.1134p pd=77.985u as=58.1134p ps=77.985u w=76.465u l=1u
X12969 BAT GATE DVDD DVDD pfet_06v0 ad=35.511p pd=48.245u as=35.511p ps=48.245u w=46.725u l=1u
X12970 BAT GATE DVDD DVDD pfet_06v0 ad=35.511p pd=48.245u as=35.511p ps=48.245u w=46.725u l=1u
X12971 DVDD GATE BAT DVDD pfet_06v0 ad=58.1134p pd=77.985u as=58.1134p ps=77.985u w=76.465u l=1u
X12972 BAT GATE DVDD DVDD pfet_06v0 ad=58.1134p pd=77.985u as=58.1134p ps=77.985u w=76.465u l=1u
X12973 DVDD GATE BAT DVDD pfet_06v0 ad=71.8771p pd=0.15481m as=58.1134p ps=77.985u w=76.465u l=1u
X12974 BAT GATE DVDD DVDD pfet_06v0 ad=35.511p pd=48.245u as=43.9215p ps=95.32999u w=46.725u l=1u
X12975 DVDD GATE BAT DVDD pfet_06v0 ad=58.1552p pd=78.04u as=58.1552p ps=78.04u w=76.52u l=1u
X12976 BAT GATE DVDD DVDD pfet_06v0 ad=35.511p pd=48.245u as=35.511p ps=48.245u w=46.725u l=1u
X12977 DVDD GATE BAT DVDD pfet_06v0 ad=35.511p pd=48.245u as=35.511p ps=48.245u w=46.725u l=1u
X12978 DVDD GATE BAT DVDD pfet_06v0 ad=35.511p pd=48.245u as=35.511p ps=48.245u w=46.725u l=1u
X12979 DVDD GATE BAT DVDD pfet_06v0 ad=58.1134p pd=77.985u as=58.1134p ps=77.985u w=76.465u l=1u
X12980 BAT GATE DVDD DVDD pfet_06v0 ad=35.511p pd=48.245u as=43.9215p ps=95.32999u w=46.725u l=1u
X12981 BAT GATE DVDD DVDD pfet_06v0 ad=35.511p pd=48.245u as=35.511p ps=48.245u w=46.725u l=1u
X12982 DVDD GATE BAT DVDD pfet_06v0 ad=35.511p pd=48.245u as=35.511p ps=48.245u w=46.725u l=1u
X12983 DVDD GATE BAT DVDD pfet_06v0 ad=35.511p pd=48.245u as=35.511p ps=48.245u w=46.725u l=1u
X12984 BAT GATE DVDD DVDD pfet_06v0 ad=58.1134p pd=77.985u as=58.1134p ps=77.985u w=76.465u l=1u
X12985 BAT GATE DVDD DVDD pfet_06v0 ad=58.1134p pd=77.985u as=71.8771p ps=0.15481m w=76.465u l=1u
X12986 DVDD GATE BAT DVDD pfet_06v0 ad=43.9215p pd=95.32999u as=35.511p ps=48.245u w=46.725u l=1u
X12987 BAT GATE DVDD DVDD pfet_06v0 ad=35.511p pd=48.245u as=35.511p ps=48.245u w=46.725u l=1u
X12988 DVDD GATE BAT DVDD pfet_06v0 ad=35.511p pd=48.245u as=35.511p ps=48.245u w=46.725u l=1u
X12989 BAT GATE DVDD DVDD pfet_06v0 ad=35.511p pd=48.245u as=35.511p ps=48.245u w=46.725u l=1u
X12990 DVDD GATE BAT DVDD pfet_06v0 ad=71.8771p pd=0.15481m as=58.1134p ps=77.985u w=76.465u l=1u
X12991 BAT GATE DVDD DVDD pfet_06v0 ad=35.511p pd=48.245u as=43.9215p ps=95.32999u w=46.725u l=1u
X12992 DVDD GATE BAT DVDD pfet_06v0 ad=35.511p pd=48.245u as=35.511p ps=48.245u w=46.725u l=1u
X12993 DVDD GATE BAT DVDD pfet_06v0 ad=35.511p pd=48.245u as=35.511p ps=48.245u w=46.725u l=1u
X12994 BAT GATE DVDD DVDD pfet_06v0 ad=58.1172p pd=77.99u as=58.1172p ps=77.99u w=76.47u l=1u
X12995 BAT GATE DVDD DVDD pfet_06v0 ad=58.1134p pd=77.985u as=58.1134p ps=77.985u w=76.465u l=1u
X12996 BAT GATE DVDD DVDD pfet_06v0 ad=58.1552p pd=78.04u as=58.1552p ps=78.04u w=76.52u l=1u
X12997 DVDD GATE BAT DVDD pfet_06v0 ad=49.3848p pd=66.5u as=49.3848p ps=66.5u w=64.98u l=1u
X12998 BAT GATE DVDD DVDD pfet_06v0 ad=58.1134p pd=77.985u as=58.1134p ps=77.985u w=76.465u l=1u
X12999 DVDD GATE BAT DVDD pfet_06v0 ad=58.9803p pd=0.12737m as=47.6862p ps=64.265u w=62.745u l=1u
X13000 BAT GATE DVDD DVDD pfet_06v0 ad=35.511p pd=48.245u as=35.511p ps=48.245u w=46.725u l=1u
X13001 DVDD GATE BAT DVDD pfet_06v0 ad=35.511p pd=48.245u as=35.511p ps=48.245u w=46.725u l=1u
X13002 BAT GATE DVDD DVDD pfet_06v0 ad=35.511p pd=48.245u as=35.511p ps=48.245u w=46.725u l=1u
X13003 DVDD GATE BAT DVDD pfet_06v0 ad=49.3848p pd=66.5u as=49.3848p ps=66.5u w=64.98u l=1u
X13004 BAT GATE DVDD DVDD pfet_06v0 ad=49.3848p pd=66.5u as=49.3848p ps=66.5u w=64.98u l=1u
X13005 BAT GATE DVDD DVDD pfet_06v0 ad=58.1134p pd=77.985u as=58.1134p ps=77.985u w=76.465u l=1u
X13006 DVDD GATE BAT DVDD pfet_06v0 ad=58.0754p pd=77.935u as=58.0754p ps=77.935u w=76.41499u l=1u
X13007 DVDD GATE BAT DVDD pfet_06v0 ad=58.1172p pd=77.99u as=58.1172p ps=77.99u w=76.47u l=1u
X13008 BAT GATE DVDD DVDD pfet_06v0 ad=58.1552p pd=78.04u as=58.1552p ps=78.04u w=76.52u l=1u
X13009 BAT GATE DVDD DVDD pfet_06v0 ad=35.511p pd=48.245u as=43.9215p ps=95.32999u w=46.725u l=1u
X13010 DVDD GATE BAT DVDD pfet_06v0 ad=58.1096p pd=77.98u as=58.1096p ps=77.98u w=76.46u l=1u
X13011 BAT GATE DVDD DVDD pfet_06v0 ad=35.511p pd=48.245u as=35.511p ps=48.245u w=46.725u l=1u
X13012 DVDD GATE BAT DVDD pfet_06v0 ad=58.1134p pd=77.985u as=58.1134p ps=77.985u w=76.465u l=1u
X13013 DVDD GATE BAT DVDD pfet_06v0 ad=58.1134p pd=77.985u as=58.1134p ps=77.985u w=76.465u l=1u
X13014 BAT GATE DVDD DVDD pfet_06v0 ad=49.3848p pd=66.5u as=49.3848p ps=66.5u w=64.98u l=1u
X13015 BAT GATE DVDD DVDD pfet_06v0 ad=58.1134p pd=77.985u as=58.1134p ps=77.985u w=76.465u l=1u
X13016 BAT GATE DVDD DVDD pfet_06v0 ad=58.0754p pd=77.935u as=58.0754p ps=77.935u w=76.41499u l=1u
X13017 BAT GATE DVDD DVDD pfet_06v0 ad=35.511p pd=48.245u as=35.511p ps=48.245u w=46.725u l=1u
X13018 DVDD GATE BAT DVDD pfet_06v0 ad=58.1134p pd=77.985u as=58.1134p ps=77.985u w=76.465u l=1u
X13019 BAT GATE DVDD DVDD pfet_06v0 ad=58.1552p pd=78.04u as=58.1552p ps=78.04u w=76.52u l=1u
X13020 BAT GATE DVDD DVDD pfet_06v0 ad=58.1172p pd=77.99u as=58.1172p ps=77.99u w=76.47u l=1u
X13021 DVDD GATE BAT DVDD pfet_06v0 ad=58.1134p pd=77.985u as=58.1134p ps=77.985u w=76.465u l=1u
X13022 DVDD GATE BAT DVDD pfet_06v0 ad=58.1134p pd=77.985u as=58.1134p ps=77.985u w=76.465u l=1u
X13023 DVDD GATE BAT DVDD pfet_06v0 ad=47.6862p pd=64.265u as=47.6862p ps=64.265u w=62.745u l=1u
X13024 DVDD GATE BAT DVDD pfet_06v0 ad=35.5072p pd=48.24u as=35.5072p ps=48.24u w=46.72u l=1u
X13025 DVDD GATE BAT DVDD pfet_06v0 ad=35.511p pd=48.245u as=35.511p ps=48.245u w=46.725u l=1u
X13026 DVDD GATE BAT DVDD pfet_06v0 ad=58.1134p pd=77.985u as=58.1134p ps=77.985u w=76.465u l=1u
X13027 BAT GATE DVDD DVDD pfet_06v0 ad=35.511p pd=48.245u as=35.511p ps=48.245u w=46.725u l=1u
X13028 DVDD GATE BAT DVDD pfet_06v0 ad=58.1134p pd=77.985u as=58.1134p ps=77.985u w=76.465u l=1u
X13029 DVDD GATE BAT DVDD pfet_06v0 ad=35.511p pd=48.245u as=35.511p ps=48.245u w=46.725u l=1u
X13030 DVDD GATE BAT DVDD pfet_06v0 ad=35.5072p pd=48.24u as=35.5072p ps=48.24u w=46.72u l=1u
X13031 BAT GATE DVDD DVDD pfet_06v0 ad=58.1134p pd=77.985u as=58.1134p ps=77.985u w=76.465u l=1u
X13032 BAT GATE DVDD DVDD pfet_06v0 ad=35.511p pd=48.245u as=35.511p ps=48.245u w=46.725u l=1u
X13033 BAT GATE DVDD DVDD pfet_06v0 ad=35.511p pd=48.245u as=35.511p ps=48.245u w=46.725u l=1u
X13034 BAT GATE DVDD DVDD pfet_06v0 ad=35.511p pd=48.245u as=35.511p ps=48.245u w=46.725u l=1u
X13035 BAT GATE DVDD DVDD pfet_06v0 ad=58.1172p pd=77.99u as=58.1172p ps=77.99u w=76.47u l=1u
X13036 DVDD GATE BAT DVDD pfet_06v0 ad=35.511p pd=48.245u as=35.511p ps=48.245u w=46.725u l=1u
X13037 DVDD GATE BAT DVDD pfet_06v0 ad=35.511p pd=48.245u as=35.511p ps=48.245u w=46.725u l=1u
X13038 DVDD GATE BAT DVDD pfet_06v0 ad=58.1096p pd=77.98u as=58.1096p ps=77.98u w=76.46u l=1u
X13039 BAT GATE DVDD DVDD pfet_06v0 ad=47.6862p pd=64.265u as=47.6862p ps=64.265u w=62.745u l=1u
X13040 DVDD GATE BAT DVDD pfet_06v0 ad=58.0754p pd=77.935u as=58.0754p ps=77.935u w=76.41499u l=1u
X13041 BAT GATE DVDD DVDD pfet_06v0 ad=35.511p pd=48.245u as=35.511p ps=48.245u w=46.725u l=1u
X13042 BAT GATE DVDD DVDD pfet_06v0 ad=35.511p pd=48.245u as=35.511p ps=48.245u w=46.725u l=1u
X13043 BAT GATE DVDD DVDD pfet_06v0 ad=35.511p pd=48.245u as=35.511p ps=48.245u w=46.725u l=1u
X13044 DVDD GATE BAT DVDD pfet_06v0 ad=49.3848p pd=66.5u as=49.3848p ps=66.5u w=64.98u l=1u
X13045 BAT GATE DVDD DVDD pfet_06v0 ad=58.1134p pd=77.985u as=71.8771p ps=0.15481m w=76.465u l=1u
X13046 DVDD GATE BAT DVDD pfet_06v0 ad=35.511p pd=48.245u as=35.511p ps=48.245u w=46.725u l=1u
X13047 BAT GATE DVDD DVDD pfet_06v0 ad=58.1134p pd=77.985u as=71.8771p ps=0.15481m w=76.465u l=1u
X13048 BAT GATE DVDD DVDD pfet_06v0 ad=35.511p pd=48.245u as=35.511p ps=48.245u w=46.725u l=1u
X13049 BAT GATE DVDD DVDD pfet_06v0 ad=58.1552p pd=78.04u as=58.1552p ps=78.04u w=76.52u l=1u
X13050 BAT GATE DVDD DVDD pfet_06v0 ad=58.1134p pd=77.985u as=58.1134p ps=77.985u w=76.465u l=1u
X13051 DVDD GATE BAT DVDD pfet_06v0 ad=58.1134p pd=77.985u as=58.1134p ps=77.985u w=76.465u l=1u
X13052 DVDD GATE BAT DVDD pfet_06v0 ad=58.1172p pd=77.99u as=58.1172p ps=77.99u w=76.47u l=1u
X13053 DVDD GATE BAT DVDD pfet_06v0 ad=43.9215p pd=95.32999u as=35.511p ps=48.245u w=46.725u l=1u
X13054 BAT GATE DVDD DVDD pfet_06v0 ad=35.511p pd=48.245u as=35.511p ps=48.245u w=46.725u l=1u
X13055 DVDD GATE BAT DVDD pfet_06v0 ad=35.511p pd=48.245u as=35.511p ps=48.245u w=46.725u l=1u
X13056 DVDD GATE BAT DVDD pfet_06v0 ad=35.511p pd=48.245u as=35.511p ps=48.245u w=46.725u l=1u
X13057 BAT GATE DVDD DVDD pfet_06v0 ad=58.1134p pd=77.985u as=71.8771p ps=0.15481m w=76.465u l=1u
X13058 DVDD GATE BAT DVDD pfet_06v0 ad=35.511p pd=48.245u as=35.511p ps=48.245u w=46.725u l=1u
X13059 DVDD GATE BAT DVDD pfet_06v0 ad=71.8818p pd=0.15482m as=58.1172p ps=77.99u w=76.47u l=1u
X13060 DVDD GATE BAT DVDD pfet_06v0 ad=35.511p pd=48.245u as=35.511p ps=48.245u w=46.725u l=1u
X13061 BAT GATE DVDD DVDD pfet_06v0 ad=35.511p pd=48.245u as=35.511p ps=48.245u w=46.725u l=1u
X13062 DVDD GATE BAT DVDD pfet_06v0 ad=58.1096p pd=77.98u as=58.1096p ps=77.98u w=76.46u l=1u
X13063 DVDD GATE BAT DVDD pfet_06v0 ad=35.511p pd=48.245u as=35.511p ps=48.245u w=46.725u l=1u
X13064 BAT GATE DVDD DVDD pfet_06v0 ad=49.3848p pd=66.5u as=61.0812p ps=0.13184m w=64.98u l=1u
X13065 BAT GATE DVDD DVDD pfet_06v0 ad=58.1172p pd=77.99u as=58.1172p ps=77.99u w=76.47u l=1u
X13066 DVDD GATE BAT DVDD pfet_06v0 ad=43.9215p pd=95.32999u as=35.511p ps=48.245u w=46.725u l=1u
X13067 BAT GATE DVDD DVDD pfet_06v0 ad=35.5072p pd=48.24u as=35.5072p ps=48.24u w=46.72u l=1u
X13068 BAT GATE DVDD DVDD pfet_06v0 ad=35.511p pd=48.245u as=35.511p ps=48.245u w=46.725u l=1u
X13069 BAT GATE DVDD DVDD pfet_06v0 ad=58.1134p pd=77.985u as=58.1134p ps=77.985u w=76.465u l=1u
X13070 BAT GATE DVDD DVDD pfet_06v0 ad=35.511p pd=48.245u as=35.511p ps=48.245u w=46.725u l=1u
X13071 DVDD GATE BAT DVDD pfet_06v0 ad=35.511p pd=48.245u as=35.511p ps=48.245u w=46.725u l=1u
X13072 DVDD GATE BAT DVDD pfet_06v0 ad=58.1134p pd=77.985u as=58.1134p ps=77.985u w=76.465u l=1u
X13073 DVDD GATE BAT DVDD pfet_06v0 ad=71.8771p pd=0.15481m as=58.1134p ps=77.985u w=76.465u l=1u
X13074 BAT GATE DVDD DVDD pfet_06v0 ad=35.511p pd=48.245u as=35.511p ps=48.245u w=46.725u l=1u
X13075 DVDD GATE BAT DVDD pfet_06v0 ad=35.511p pd=48.245u as=35.511p ps=48.245u w=46.725u l=1u
X13076 DVDD GATE BAT DVDD pfet_06v0 ad=58.1134p pd=77.985u as=58.1134p ps=77.985u w=76.465u l=1u
X13077 BAT GATE DVDD DVDD pfet_06v0 ad=58.1134p pd=77.985u as=58.1134p ps=77.985u w=76.465u l=1u
X13078 BAT GATE DVDD DVDD pfet_06v0 ad=35.511p pd=48.245u as=43.9215p ps=95.32999u w=46.725u l=1u
X13079 BAT GATE DVDD DVDD pfet_06v0 ad=58.1134p pd=77.985u as=58.1134p ps=77.985u w=76.465u l=1u
X13080 DVDD GATE BAT DVDD pfet_06v0 ad=58.0754p pd=77.935u as=58.0754p ps=77.935u w=76.41499u l=1u
X13081 DVDD GATE BAT DVDD pfet_06v0 ad=71.92879p pd=0.15492m as=58.1552p ps=78.04u w=76.52u l=1u
X13082 BAT GATE DVDD DVDD pfet_06v0 ad=35.511p pd=48.245u as=43.9215p ps=95.32999u w=46.725u l=1u
X13083 DVDD GATE BAT DVDD pfet_06v0 ad=35.511p pd=48.245u as=35.511p ps=48.245u w=46.725u l=1u
X13084 BAT GATE DVDD DVDD pfet_06v0 ad=35.511p pd=48.245u as=35.511p ps=48.245u w=46.725u l=1u
X13085 BAT GATE DVDD DVDD pfet_06v0 ad=35.511p pd=48.245u as=35.511p ps=48.245u w=46.725u l=1u
X13086 BAT GATE DVDD DVDD pfet_06v0 ad=58.1134p pd=77.985u as=58.1134p ps=77.985u w=76.465u l=1u
X13087 BAT GATE DVDD DVDD pfet_06v0 ad=35.511p pd=48.245u as=35.511p ps=48.245u w=46.725u l=1u
X13088 DVDD GATE BAT DVDD pfet_06v0 ad=47.6862p pd=64.265u as=47.6862p ps=64.265u w=62.745u l=1u
X13089 DVDD GATE BAT DVDD pfet_06v0 ad=58.1172p pd=77.99u as=58.1172p ps=77.99u w=76.47u l=1u
X13090 BAT GATE DVDD DVDD pfet_06v0 ad=58.1134p pd=77.985u as=58.1134p ps=77.985u w=76.465u l=1u
X13091 BAT GATE DVDD DVDD pfet_06v0 ad=35.511p pd=48.245u as=35.511p ps=48.245u w=46.725u l=1u
X13092 BAT GATE DVDD DVDD pfet_06v0 ad=58.1134p pd=77.985u as=71.8771p ps=0.15481m w=76.465u l=1u
X13093 BAT GATE DVDD DVDD pfet_06v0 ad=35.511p pd=48.245u as=35.511p ps=48.245u w=46.725u l=1u
X13094 BAT GATE DVDD DVDD pfet_06v0 ad=35.511p pd=48.245u as=43.9215p ps=95.32999u w=46.725u l=1u
X13095 DVDD GATE BAT DVDD pfet_06v0 ad=35.511p pd=48.245u as=35.511p ps=48.245u w=46.725u l=1u
X13096 BAT GATE DVDD DVDD pfet_06v0 ad=35.5072p pd=48.24u as=35.5072p ps=48.24u w=46.72u l=1u
X13097 DVDD GATE BAT DVDD pfet_06v0 ad=58.1552p pd=78.04u as=58.1552p ps=78.04u w=76.52u l=1u
X13098 DVDD GATE BAT DVDD pfet_06v0 ad=58.1172p pd=77.99u as=58.1172p ps=77.99u w=76.47u l=1u
X13099 BAT GATE DVDD DVDD pfet_06v0 ad=58.1134p pd=77.985u as=58.1134p ps=77.985u w=76.465u l=1u
X13100 BAT GATE DVDD DVDD pfet_06v0 ad=35.511p pd=48.245u as=35.511p ps=48.245u w=46.725u l=1u
X13101 DVDD GATE BAT DVDD pfet_06v0 ad=58.1172p pd=77.99u as=58.1172p ps=77.99u w=76.47u l=1u
X13102 DVDD GATE BAT DVDD pfet_06v0 ad=35.511p pd=48.245u as=35.511p ps=48.245u w=46.725u l=1u
X13103 DVDD GATE BAT DVDD pfet_06v0 ad=35.511p pd=48.245u as=35.511p ps=48.245u w=46.725u l=1u
X13104 DVDD GATE BAT DVDD pfet_06v0 ad=58.1134p pd=77.985u as=58.1134p ps=77.985u w=76.465u l=1u
X13105 DVDD GATE BAT DVDD pfet_06v0 ad=35.511p pd=48.245u as=35.511p ps=48.245u w=46.725u l=1u
X13106 BAT GATE DVDD DVDD pfet_06v0 ad=35.511p pd=48.245u as=43.9215p ps=95.32999u w=46.725u l=1u
X13107 BAT GATE DVDD DVDD pfet_06v0 ad=35.511p pd=48.245u as=35.511p ps=48.245u w=46.725u l=1u
X13108 DVDD GATE BAT DVDD pfet_06v0 ad=58.1134p pd=77.985u as=58.1134p ps=77.985u w=76.465u l=1u
X13109 BAT GATE DVDD DVDD pfet_06v0 ad=58.0754p pd=77.935u as=58.0754p ps=77.935u w=76.41499u l=1u
X13110 BAT GATE DVDD DVDD pfet_06v0 ad=58.0754p pd=77.935u as=58.0754p ps=77.935u w=76.41499u l=1u
X13111 DVDD GATE BAT DVDD pfet_06v0 ad=35.511p pd=48.245u as=35.511p ps=48.245u w=46.725u l=1u
X13112 DVDD GATE BAT DVDD pfet_06v0 ad=35.511p pd=48.245u as=35.511p ps=48.245u w=46.725u l=1u
X13113 BAT GATE DVDD DVDD pfet_06v0 ad=58.1134p pd=77.985u as=71.8771p ps=0.15481m w=76.465u l=1u
X13114 BAT GATE DVDD DVDD pfet_06v0 ad=58.1134p pd=77.985u as=58.1134p ps=77.985u w=76.465u l=1u
X13115 DVDD GATE BAT DVDD pfet_06v0 ad=58.0754p pd=77.935u as=58.0754p ps=77.935u w=76.41499u l=1u
X13116 BAT GATE DVDD DVDD pfet_06v0 ad=58.1134p pd=77.985u as=58.1134p ps=77.985u w=76.465u l=1u
X13117 BAT GATE DVDD DVDD pfet_06v0 ad=35.511p pd=48.245u as=35.511p ps=48.245u w=46.725u l=1u
X13118 DVDD GATE BAT DVDD pfet_06v0 ad=58.1134p pd=77.985u as=58.1134p ps=77.985u w=76.465u l=1u
X13119 DVDD GATE BAT DVDD pfet_06v0 ad=58.1552p pd=78.04u as=58.1552p ps=78.04u w=76.52u l=1u
X13120 DVDD GATE BAT DVDD pfet_06v0 ad=58.1172p pd=77.99u as=58.1172p ps=77.99u w=76.47u l=1u
X13121 DVDD GATE BAT DVDD pfet_06v0 ad=49.3848p pd=66.5u as=49.3848p ps=66.5u w=64.98u l=1u
X13122 BAT GATE DVDD DVDD pfet_06v0 ad=58.1134p pd=77.985u as=58.1134p ps=77.985u w=76.465u l=1u
X13123 DVDD GATE BAT DVDD pfet_06v0 ad=58.1172p pd=77.99u as=58.1172p ps=77.99u w=76.47u l=1u
X13124 BAT GATE DVDD DVDD pfet_06v0 ad=35.511p pd=48.245u as=35.511p ps=48.245u w=46.725u l=1u
X13125 DVDD GATE BAT DVDD pfet_06v0 ad=35.511p pd=48.245u as=35.511p ps=48.245u w=46.725u l=1u
X13126 DVDD GATE BAT DVDD pfet_06v0 ad=35.511p pd=48.245u as=35.511p ps=48.245u w=46.725u l=1u
X13127 BAT GATE DVDD DVDD pfet_06v0 ad=58.1134p pd=77.985u as=58.1134p ps=77.985u w=76.465u l=1u
X13128 BAT GATE DVDD DVDD pfet_06v0 ad=35.511p pd=48.245u as=43.9215p ps=95.32999u w=46.725u l=1u
X13129 DVDD GATE BAT DVDD pfet_06v0 ad=58.1134p pd=77.985u as=58.1134p ps=77.985u w=76.465u l=1u
X13130 BAT GATE DVDD DVDD pfet_06v0 ad=58.1096p pd=77.98u as=58.1096p ps=77.98u w=76.46u l=1u
X13131 DVDD GATE BAT DVDD pfet_06v0 ad=58.1134p pd=77.985u as=58.1134p ps=77.985u w=76.465u l=1u
X13132 BAT GATE DVDD DVDD pfet_06v0 ad=58.1096p pd=77.98u as=58.1096p ps=77.98u w=76.46u l=1u
X13133 BAT GATE DVDD DVDD pfet_06v0 ad=58.1096p pd=77.98u as=58.1096p ps=77.98u w=76.46u l=1u
X13134 BAT GATE DVDD DVDD pfet_06v0 ad=35.511p pd=48.245u as=35.511p ps=48.245u w=46.725u l=1u
X13135 DVDD GATE BAT DVDD pfet_06v0 ad=43.9168p pd=95.32u as=35.5072p ps=48.24u w=46.72u l=1u
X13136 DVDD GATE BAT DVDD pfet_06v0 ad=35.511p pd=48.245u as=35.511p ps=48.245u w=46.725u l=1u
X13137 BAT GATE DVDD DVDD pfet_06v0 ad=35.511p pd=48.245u as=35.511p ps=48.245u w=46.725u l=1u
X13138 BAT GATE DVDD DVDD pfet_06v0 ad=35.511p pd=48.245u as=35.511p ps=48.245u w=46.725u l=1u
X13139 BAT GATE DVDD DVDD pfet_06v0 ad=35.511p pd=48.245u as=35.511p ps=48.245u w=46.725u l=1u
X13140 BAT GATE DVDD DVDD pfet_06v0 ad=35.5072p pd=48.24u as=35.5072p ps=48.24u w=46.72u l=1u
X13141 BAT GATE DVDD DVDD pfet_06v0 ad=58.1172p pd=77.99u as=58.1172p ps=77.99u w=76.47u l=1u
X13142 DVDD GATE BAT DVDD pfet_06v0 ad=35.511p pd=48.245u as=35.511p ps=48.245u w=46.725u l=1u
X13143 BAT GATE DVDD DVDD pfet_06v0 ad=58.1134p pd=77.985u as=58.1134p ps=77.985u w=76.465u l=1u
X13144 BAT GATE DVDD DVDD pfet_06v0 ad=49.3848p pd=66.5u as=49.3848p ps=66.5u w=64.98u l=1u
X13145 DVDD GATE BAT DVDD pfet_06v0 ad=49.3848p pd=66.5u as=49.3848p ps=66.5u w=64.98u l=1u
X13146 DVDD GATE BAT DVDD pfet_06v0 ad=47.6862p pd=64.265u as=47.6862p ps=64.265u w=62.745u l=1u
X13147 DVDD GATE BAT DVDD pfet_06v0 ad=58.0754p pd=77.935u as=58.0754p ps=77.935u w=76.41499u l=1u
X13148 DVDD GATE BAT DVDD pfet_06v0 ad=58.1552p pd=78.04u as=58.1552p ps=78.04u w=76.52u l=1u
X13149 DVDD GATE BAT DVDD pfet_06v0 ad=58.9803p pd=0.12737m as=47.6862p ps=64.265u w=62.745u l=1u
X13150 BAT GATE DVDD DVDD pfet_06v0 ad=35.511p pd=48.245u as=35.511p ps=48.245u w=46.725u l=1u
X13151 DVDD GATE BAT DVDD pfet_06v0 ad=35.511p pd=48.245u as=35.511p ps=48.245u w=46.725u l=1u
X13152 DVDD GATE BAT DVDD pfet_06v0 ad=35.511p pd=48.245u as=35.511p ps=48.245u w=46.725u l=1u
X13153 BAT GATE DVDD DVDD pfet_06v0 ad=35.511p pd=48.245u as=35.511p ps=48.245u w=46.725u l=1u
X13154 BAT GATE DVDD DVDD pfet_06v0 ad=35.511p pd=48.245u as=35.511p ps=48.245u w=46.725u l=1u
X13155 DVDD GATE BAT DVDD pfet_06v0 ad=71.8771p pd=0.15481m as=58.1134p ps=77.985u w=76.465u l=1u
X13156 BAT GATE DVDD DVDD pfet_06v0 ad=58.1134p pd=77.985u as=58.1134p ps=77.985u w=76.465u l=1u
X13157 DVDD GATE BAT DVDD pfet_06v0 ad=58.1134p pd=77.985u as=58.1134p ps=77.985u w=76.465u l=1u
X13158 DVDD GATE BAT DVDD pfet_06v0 ad=35.5072p pd=48.24u as=35.5072p ps=48.24u w=46.72u l=1u
X13159 DVDD GATE BAT DVDD pfet_06v0 ad=58.1134p pd=77.985u as=58.1134p ps=77.985u w=76.465u l=1u
X13160 BAT GATE DVDD DVDD pfet_06v0 ad=58.1172p pd=77.99u as=58.1172p ps=77.99u w=76.47u l=1u
X13161 DVDD GATE BAT DVDD pfet_06v0 ad=58.1134p pd=77.985u as=58.1134p ps=77.985u w=76.465u l=1u
X13162 BAT GATE DVDD DVDD pfet_06v0 ad=58.1134p pd=77.985u as=58.1134p ps=77.985u w=76.465u l=1u
X13163 DVDD GATE BAT DVDD pfet_06v0 ad=49.3848p pd=66.5u as=49.3848p ps=66.5u w=64.98u l=1u
X13164 DVDD GATE BAT DVDD pfet_06v0 ad=49.3848p pd=66.5u as=49.3848p ps=66.5u w=64.98u l=1u
X13165 DVDD GATE BAT DVDD pfet_06v0 ad=35.511p pd=48.245u as=35.511p ps=48.245u w=46.725u l=1u
X13166 BAT GATE DVDD DVDD pfet_06v0 ad=35.511p pd=48.245u as=35.511p ps=48.245u w=46.725u l=1u
X13167 DVDD GATE BAT DVDD pfet_06v0 ad=58.1134p pd=77.985u as=58.1134p ps=77.985u w=76.465u l=1u
X13168 DVDD GATE BAT DVDD pfet_06v0 ad=58.1172p pd=77.99u as=58.1172p ps=77.99u w=76.47u l=1u
X13169 BAT GATE DVDD DVDD pfet_06v0 ad=58.1134p pd=77.985u as=71.8771p ps=0.15481m w=76.465u l=1u
X13170 BAT GATE DVDD DVDD pfet_06v0 ad=58.1134p pd=77.985u as=71.8771p ps=0.15481m w=76.465u l=1u
X13171 DVDD GATE BAT DVDD pfet_06v0 ad=35.511p pd=48.245u as=35.511p ps=48.245u w=46.725u l=1u
X13172 BAT GATE DVDD DVDD pfet_06v0 ad=35.511p pd=48.245u as=35.511p ps=48.245u w=46.725u l=1u
X13173 BAT GATE DVDD DVDD pfet_06v0 ad=35.511p pd=48.245u as=35.511p ps=48.245u w=46.725u l=1u
X13174 DVDD GATE BAT DVDD pfet_06v0 ad=71.8771p pd=0.15481m as=58.1134p ps=77.985u w=76.465u l=1u
X13175 DVDD GATE BAT DVDD pfet_06v0 ad=35.5072p pd=48.24u as=35.5072p ps=48.24u w=46.72u l=1u
X13176 DVDD GATE BAT DVDD pfet_06v0 ad=58.1134p pd=77.985u as=58.1134p ps=77.985u w=76.465u l=1u
X13177 DVDD GATE BAT DVDD pfet_06v0 ad=35.511p pd=48.245u as=35.511p ps=48.245u w=46.725u l=1u
X13178 BAT GATE DVDD DVDD pfet_06v0 ad=35.511p pd=48.245u as=35.511p ps=48.245u w=46.725u l=1u
X13179 BAT GATE DVDD DVDD pfet_06v0 ad=58.1552p pd=78.04u as=58.1552p ps=78.04u w=76.52u l=1u
X13180 DVDD GATE BAT DVDD pfet_06v0 ad=58.1134p pd=77.985u as=58.1134p ps=77.985u w=76.465u l=1u
X13181 BAT GATE DVDD DVDD pfet_06v0 ad=58.1134p pd=77.985u as=58.1134p ps=77.985u w=76.465u l=1u
X13182 DVDD GATE BAT DVDD pfet_06v0 ad=35.511p pd=48.245u as=35.511p ps=48.245u w=46.725u l=1u
X13183 BAT GATE DVDD DVDD pfet_06v0 ad=35.511p pd=48.245u as=35.511p ps=48.245u w=46.725u l=1u
X13184 BAT GATE DVDD DVDD pfet_06v0 ad=35.511p pd=48.245u as=35.511p ps=48.245u w=46.725u l=1u
X13185 BAT GATE DVDD DVDD pfet_06v0 ad=58.1134p pd=77.985u as=58.1134p ps=77.985u w=76.465u l=1u
X13186 DVDD GATE BAT DVDD pfet_06v0 ad=35.511p pd=48.245u as=35.511p ps=48.245u w=46.725u l=1u
X13187 DVDD GATE BAT DVDD pfet_06v0 ad=58.1134p pd=77.985u as=58.1134p ps=77.985u w=76.465u l=1u
X13188 BAT GATE DVDD DVDD pfet_06v0 ad=35.511p pd=48.245u as=35.511p ps=48.245u w=46.725u l=1u
X13189 DVDD GATE BAT DVDD pfet_06v0 ad=35.511p pd=48.245u as=35.511p ps=48.245u w=46.725u l=1u
X13190 BAT GATE DVDD DVDD pfet_06v0 ad=58.1172p pd=77.99u as=71.8818p ps=0.15482m w=76.47u l=1u
X13191 BAT GATE DVDD DVDD pfet_06v0 ad=35.511p pd=48.245u as=35.511p ps=48.245u w=46.725u l=1u
X13192 BAT GATE DVDD DVDD pfet_06v0 ad=35.511p pd=48.245u as=35.511p ps=48.245u w=46.725u l=1u
X13193 BAT GATE DVDD DVDD pfet_06v0 ad=58.1172p pd=77.99u as=58.1172p ps=77.99u w=76.47u l=1u
X13194 BAT GATE DVDD DVDD pfet_06v0 ad=47.6862p pd=64.265u as=47.6862p ps=64.265u w=62.745u l=1u
X13195 BAT GATE DVDD DVDD pfet_06v0 ad=58.1134p pd=77.985u as=58.1134p ps=77.985u w=76.465u l=1u
X13196 BAT GATE DVDD DVDD pfet_06v0 ad=35.511p pd=48.245u as=43.9215p ps=95.32999u w=46.725u l=1u
X13197 DVDD GATE BAT DVDD pfet_06v0 ad=35.511p pd=48.245u as=35.511p ps=48.245u w=46.725u l=1u
X13198 DVDD GATE BAT DVDD pfet_06v0 ad=35.5072p pd=48.24u as=35.5072p ps=48.24u w=46.72u l=1u
X13199 BAT GATE DVDD DVDD pfet_06v0 ad=35.511p pd=48.245u as=43.9215p ps=95.32999u w=46.725u l=1u
X13200 BAT GATE DVDD DVDD pfet_06v0 ad=58.1134p pd=77.985u as=58.1134p ps=77.985u w=76.465u l=1u
X13201 BAT GATE DVDD DVDD pfet_06v0 ad=58.1134p pd=77.985u as=71.8771p ps=0.15481m w=76.465u l=1u
X13202 DVDD GATE BAT DVDD pfet_06v0 ad=35.511p pd=48.245u as=35.511p ps=48.245u w=46.725u l=1u
X13203 BAT GATE DVDD DVDD pfet_06v0 ad=35.511p pd=48.245u as=43.9215p ps=95.32999u w=46.725u l=1u
X13204 BAT GATE DVDD DVDD pfet_06v0 ad=35.511p pd=48.245u as=43.9215p ps=95.32999u w=46.725u l=1u
X13205 BAT GATE DVDD DVDD pfet_06v0 ad=58.1134p pd=77.985u as=58.1134p ps=77.985u w=76.465u l=1u
X13206 BAT GATE DVDD DVDD pfet_06v0 ad=35.511p pd=48.245u as=35.511p ps=48.245u w=46.725u l=1u
X13207 DVDD GATE BAT DVDD pfet_06v0 ad=58.1134p pd=77.985u as=58.1134p ps=77.985u w=76.465u l=1u
X13208 DVDD GATE BAT DVDD pfet_06v0 ad=58.1134p pd=77.985u as=58.1134p ps=77.985u w=76.465u l=1u
X13209 BAT GATE DVDD DVDD pfet_06v0 ad=35.511p pd=48.245u as=35.511p ps=48.245u w=46.725u l=1u
X13210 DVDD GATE BAT DVDD pfet_06v0 ad=35.511p pd=48.245u as=35.511p ps=48.245u w=46.725u l=1u
X13211 DVDD GATE BAT DVDD pfet_06v0 ad=58.1096p pd=77.98u as=58.1096p ps=77.98u w=76.46u l=1u
X13212 BAT GATE DVDD DVDD pfet_06v0 ad=35.511p pd=48.245u as=43.9215p ps=95.32999u w=46.725u l=1u
X13213 DVDD GATE BAT DVDD pfet_06v0 ad=35.511p pd=48.245u as=35.511p ps=48.245u w=46.725u l=1u
X13214 DVDD GATE BAT DVDD pfet_06v0 ad=35.511p pd=48.245u as=35.511p ps=48.245u w=46.725u l=1u
X13215 DVDD GATE BAT DVDD pfet_06v0 ad=35.511p pd=48.245u as=35.511p ps=48.245u w=46.725u l=1u
X13216 DVDD GATE BAT DVDD pfet_06v0 ad=58.1552p pd=78.04u as=58.1552p ps=78.04u w=76.52u l=1u
X13217 DVDD GATE BAT DVDD pfet_06v0 ad=58.0754p pd=77.935u as=58.0754p ps=77.935u w=76.41499u l=1u
X13218 BAT GATE DVDD DVDD pfet_06v0 ad=35.511p pd=48.245u as=35.511p ps=48.245u w=46.725u l=1u
X13219 BAT GATE DVDD DVDD pfet_06v0 ad=35.511p pd=48.245u as=43.9215p ps=95.32999u w=46.725u l=1u
X13220 DVDD GATE BAT DVDD pfet_06v0 ad=58.1134p pd=77.985u as=58.1134p ps=77.985u w=76.465u l=1u
X13221 DVDD GATE BAT DVDD pfet_06v0 ad=35.5072p pd=48.24u as=35.5072p ps=48.24u w=46.72u l=1u
X13222 BAT GATE DVDD DVDD pfet_06v0 ad=35.511p pd=48.245u as=35.511p ps=48.245u w=46.725u l=1u
X13223 DVDD GATE BAT DVDD pfet_06v0 ad=58.1172p pd=77.99u as=58.1172p ps=77.99u w=76.47u l=1u
X13224 DVDD GATE BAT DVDD pfet_06v0 ad=35.511p pd=48.245u as=35.511p ps=48.245u w=46.725u l=1u
X13225 BAT GATE DVDD DVDD pfet_06v0 ad=49.3848p pd=66.5u as=49.3848p ps=66.5u w=64.98u l=1u
X13226 DVDD GATE BAT DVDD pfet_06v0 ad=58.1096p pd=77.98u as=58.1096p ps=77.98u w=76.46u l=1u
X13227 BAT GATE DVDD DVDD pfet_06v0 ad=58.1134p pd=77.985u as=58.1134p ps=77.985u w=76.465u l=1u
X13228 DVDD GATE BAT DVDD pfet_06v0 ad=61.0812p pd=0.13184m as=49.3848p ps=66.5u w=64.98u l=1u
X13229 BAT GATE DVDD DVDD pfet_06v0 ad=47.6862p pd=64.265u as=47.6862p ps=64.265u w=62.745u l=1u
X13230 BAT GATE DVDD DVDD pfet_06v0 ad=58.0754p pd=77.935u as=58.0754p ps=77.935u w=76.41499u l=1u
X13231 DVDD GATE BAT DVDD pfet_06v0 ad=35.511p pd=48.245u as=35.511p ps=48.245u w=46.725u l=1u
X13232 DVDD GATE BAT DVDD pfet_06v0 ad=58.1134p pd=77.985u as=58.1134p ps=77.985u w=76.465u l=1u
X13233 BAT GATE DVDD DVDD pfet_06v0 ad=49.3848p pd=66.5u as=49.3848p ps=66.5u w=64.98u l=1u
X13234 BAT GATE DVDD DVDD pfet_06v0 ad=35.511p pd=48.245u as=35.511p ps=48.245u w=46.725u l=1u
X13235 BAT GATE DVDD DVDD pfet_06v0 ad=58.1552p pd=78.04u as=71.92879p ps=0.15492m w=76.52u l=1u
X13236 DVDD GATE BAT DVDD pfet_06v0 ad=35.5072p pd=48.24u as=35.5072p ps=48.24u w=46.72u l=1u
X13237 DVDD GATE BAT DVDD pfet_06v0 ad=35.511p pd=48.245u as=35.511p ps=48.245u w=46.725u l=1u
X13238 DVDD GATE BAT DVDD pfet_06v0 ad=58.1134p pd=77.985u as=58.1134p ps=77.985u w=76.465u l=1u
X13239 DVDD GATE BAT DVDD pfet_06v0 ad=58.1096p pd=77.98u as=58.1096p ps=77.98u w=76.46u l=1u
X13240 DVDD GATE BAT DVDD pfet_06v0 ad=58.1134p pd=77.985u as=58.1134p ps=77.985u w=76.465u l=1u
X13241 DVDD GATE BAT DVDD pfet_06v0 ad=43.9168p pd=95.32u as=35.5072p ps=48.24u w=46.72u l=1u
X13242 DVDD GATE BAT DVDD pfet_06v0 ad=49.3848p pd=66.5u as=49.3848p ps=66.5u w=64.98u l=1u
X13243 BAT GATE DVDD DVDD pfet_06v0 ad=49.3848p pd=66.5u as=49.3848p ps=66.5u w=64.98u l=1u
X13244 DVDD GATE BAT DVDD pfet_06v0 ad=58.0754p pd=77.935u as=58.0754p ps=77.935u w=76.41499u l=1u
X13245 DVDD GATE BAT DVDD pfet_06v0 ad=58.1134p pd=77.985u as=58.1134p ps=77.985u w=76.465u l=1u
X13246 DVDD GATE BAT DVDD pfet_06v0 ad=35.511p pd=48.245u as=35.511p ps=48.245u w=46.725u l=1u
X13247 BAT GATE DVDD DVDD pfet_06v0 ad=35.5072p pd=48.24u as=35.5072p ps=48.24u w=46.72u l=1u
X13248 BAT GATE DVDD DVDD pfet_06v0 ad=58.1134p pd=77.985u as=58.1134p ps=77.985u w=76.465u l=1u
X13249 BAT GATE DVDD DVDD pfet_06v0 ad=58.1134p pd=77.985u as=58.1134p ps=77.985u w=76.465u l=1u
X13250 DVDD GATE BAT DVDD pfet_06v0 ad=35.511p pd=48.245u as=35.511p ps=48.245u w=46.725u l=1u
X13251 DVDD GATE BAT DVDD pfet_06v0 ad=35.511p pd=48.245u as=35.511p ps=48.245u w=46.725u l=1u
X13252 BAT GATE DVDD DVDD pfet_06v0 ad=58.1134p pd=77.985u as=58.1134p ps=77.985u w=76.465u l=1u
X13253 DVDD GATE BAT DVDD pfet_06v0 ad=58.0754p pd=77.935u as=58.0754p ps=77.935u w=76.41499u l=1u
X13254 BAT GATE DVDD DVDD pfet_06v0 ad=35.511p pd=48.245u as=35.511p ps=48.245u w=46.725u l=1u
X13255 BAT GATE DVDD DVDD pfet_06v0 ad=58.1172p pd=77.99u as=71.8818p ps=0.15482m w=76.47u l=1u
X13256 DVDD GATE BAT DVDD pfet_06v0 ad=71.8771p pd=0.15481m as=58.1134p ps=77.985u w=76.465u l=1u
X13257 BAT GATE DVDD DVDD pfet_06v0 ad=47.6862p pd=64.265u as=47.6862p ps=64.265u w=62.745u l=1u
X13258 DVDD GATE BAT DVDD pfet_06v0 ad=35.5072p pd=48.24u as=35.5072p ps=48.24u w=46.72u l=1u
X13259 BAT GATE DVDD DVDD pfet_06v0 ad=35.511p pd=48.245u as=43.9215p ps=95.32999u w=46.725u l=1u
X13260 DVDD GATE BAT DVDD pfet_06v0 ad=35.511p pd=48.245u as=35.511p ps=48.245u w=46.725u l=1u
X13261 DVDD GATE BAT DVDD pfet_06v0 ad=58.1134p pd=77.985u as=58.1134p ps=77.985u w=76.465u l=1u
X13262 BAT GATE DVDD DVDD pfet_06v0 ad=49.3848p pd=66.5u as=61.0812p ps=0.13184m w=64.98u l=1u
X13263 DVDD GATE BAT DVDD pfet_06v0 ad=35.511p pd=48.245u as=35.511p ps=48.245u w=46.725u l=1u
X13264 DVDD GATE BAT DVDD pfet_06v0 ad=35.511p pd=48.245u as=35.511p ps=48.245u w=46.725u l=1u
X13265 BAT GATE DVDD DVDD pfet_06v0 ad=35.511p pd=48.245u as=35.511p ps=48.245u w=46.725u l=1u
X13266 DVDD GATE BAT DVDD pfet_06v0 ad=58.1134p pd=77.985u as=58.1134p ps=77.985u w=76.465u l=1u
X13267 BAT GATE DVDD DVDD pfet_06v0 ad=58.1096p pd=77.98u as=58.1096p ps=77.98u w=76.46u l=1u
X13268 BAT GATE DVDD DVDD pfet_06v0 ad=35.5072p pd=48.24u as=43.9168p ps=95.32u w=46.72u l=1u
X13269 BAT GATE DVDD DVDD pfet_06v0 ad=58.1134p pd=77.985u as=58.1134p ps=77.985u w=76.465u l=1u
X13270 DVDD GATE BAT DVDD pfet_06v0 ad=35.511p pd=48.245u as=35.511p ps=48.245u w=46.725u l=1u
X13271 BAT GATE DVDD DVDD pfet_06v0 ad=35.511p pd=48.245u as=35.511p ps=48.245u w=46.725u l=1u
X13272 DVDD GATE BAT DVDD pfet_06v0 ad=35.511p pd=48.245u as=35.511p ps=48.245u w=46.725u l=1u
X13273 BAT GATE DVDD DVDD pfet_06v0 ad=58.1134p pd=77.985u as=58.1134p ps=77.985u w=76.465u l=1u
X13274 BAT GATE DVDD DVDD pfet_06v0 ad=35.5072p pd=48.24u as=35.5072p ps=48.24u w=46.72u l=1u
X13275 DVDD GATE BAT DVDD pfet_06v0 ad=58.1134p pd=77.985u as=58.1134p ps=77.985u w=76.465u l=1u
X13276 DVDD GATE BAT DVDD pfet_06v0 ad=35.511p pd=48.245u as=35.511p ps=48.245u w=46.725u l=1u
X13277 BAT GATE DVDD DVDD pfet_06v0 ad=35.511p pd=48.245u as=35.511p ps=48.245u w=46.725u l=1u
X13278 BAT GATE DVDD DVDD pfet_06v0 ad=35.511p pd=48.245u as=35.511p ps=48.245u w=46.725u l=1u
X13279 BAT GATE DVDD DVDD pfet_06v0 ad=35.511p pd=48.245u as=35.511p ps=48.245u w=46.725u l=1u
X13280 DVDD GATE BAT DVDD pfet_06v0 ad=35.511p pd=48.245u as=35.511p ps=48.245u w=46.725u l=1u
X13281 DVDD GATE BAT DVDD pfet_06v0 ad=35.511p pd=48.245u as=35.511p ps=48.245u w=46.725u l=1u
X13282 BAT GATE DVDD DVDD pfet_06v0 ad=58.1134p pd=77.985u as=58.1134p ps=77.985u w=76.465u l=1u
X13283 BAT GATE DVDD DVDD pfet_06v0 ad=58.1134p pd=77.985u as=58.1134p ps=77.985u w=76.465u l=1u
X13284 BAT GATE DVDD DVDD pfet_06v0 ad=35.511p pd=48.245u as=35.511p ps=48.245u w=46.725u l=1u
X13285 DVDD GATE BAT DVDD pfet_06v0 ad=58.1134p pd=77.985u as=58.1134p ps=77.985u w=76.465u l=1u
X13286 BAT GATE DVDD DVDD pfet_06v0 ad=58.1172p pd=77.99u as=58.1172p ps=77.99u w=76.47u l=1u
X13287 BAT GATE DVDD DVDD pfet_06v0 ad=58.1134p pd=77.985u as=58.1134p ps=77.985u w=76.465u l=1u
X13288 BAT GATE DVDD DVDD pfet_06v0 ad=58.0754p pd=77.935u as=58.0754p ps=77.935u w=76.41499u l=1u
X13289 BAT GATE DVDD DVDD pfet_06v0 ad=58.1134p pd=77.985u as=58.1134p ps=77.985u w=76.465u l=1u
X13290 DVDD GATE BAT DVDD pfet_06v0 ad=35.511p pd=48.245u as=35.511p ps=48.245u w=46.725u l=1u
X13291 DVDD GATE BAT DVDD pfet_06v0 ad=43.9215p pd=95.32999u as=35.511p ps=48.245u w=46.725u l=1u
X13292 BAT GATE DVDD DVDD pfet_06v0 ad=35.511p pd=48.245u as=43.9215p ps=95.32999u w=46.725u l=1u
X13293 DVDD GATE BAT DVDD pfet_06v0 ad=35.511p pd=48.245u as=35.511p ps=48.245u w=46.725u l=1u
X13294 DVDD GATE BAT DVDD pfet_06v0 ad=35.511p pd=48.245u as=35.511p ps=48.245u w=46.725u l=1u
X13295 BAT GATE DVDD DVDD pfet_06v0 ad=58.1134p pd=77.985u as=58.1134p ps=77.985u w=76.465u l=1u
X13296 DVDD GATE BAT DVDD pfet_06v0 ad=35.511p pd=48.245u as=35.511p ps=48.245u w=46.725u l=1u
X13297 DVDD GATE BAT DVDD pfet_06v0 ad=43.9215p pd=95.32999u as=35.511p ps=48.245u w=46.725u l=1u
X13298 DVDD GATE BAT DVDD pfet_06v0 ad=43.9215p pd=95.32999u as=35.511p ps=48.245u w=46.725u l=1u
X13299 BAT GATE DVDD DVDD pfet_06v0 ad=35.511p pd=48.245u as=35.511p ps=48.245u w=46.725u l=1u
X13300 BAT GATE DVDD DVDD pfet_06v0 ad=35.511p pd=48.245u as=35.511p ps=48.245u w=46.725u l=1u
X13301 BAT GATE DVDD DVDD pfet_06v0 ad=58.1096p pd=77.98u as=58.1096p ps=77.98u w=76.46u l=1u
X13302 DVDD GATE BAT DVDD pfet_06v0 ad=58.1134p pd=77.985u as=58.1134p ps=77.985u w=76.465u l=1u
X13303 BAT GATE DVDD DVDD pfet_06v0 ad=35.511p pd=48.245u as=35.511p ps=48.245u w=46.725u l=1u
X13304 BAT GATE DVDD DVDD pfet_06v0 ad=35.511p pd=48.245u as=35.511p ps=48.245u w=46.725u l=1u
X13305 BAT GATE DVDD DVDD pfet_06v0 ad=58.1134p pd=77.985u as=58.1134p ps=77.985u w=76.465u l=1u
X13306 DVDD GATE BAT DVDD pfet_06v0 ad=35.511p pd=48.245u as=35.511p ps=48.245u w=46.725u l=1u
X13307 DVDD GATE BAT DVDD pfet_06v0 ad=35.511p pd=48.245u as=35.511p ps=48.245u w=46.725u l=1u
X13308 DVDD GATE BAT DVDD pfet_06v0 ad=58.1552p pd=78.04u as=58.1552p ps=78.04u w=76.52u l=1u
X13309 DVDD GATE BAT DVDD pfet_06v0 ad=58.1134p pd=77.985u as=58.1134p ps=77.985u w=76.465u l=1u
X13310 BAT GATE DVDD DVDD pfet_06v0 ad=58.1134p pd=77.985u as=58.1134p ps=77.985u w=76.465u l=1u
X13311 BAT GATE DVDD DVDD pfet_06v0 ad=35.511p pd=48.245u as=35.511p ps=48.245u w=46.725u l=1u
X13312 DVDD GATE BAT DVDD pfet_06v0 ad=58.1134p pd=77.985u as=58.1134p ps=77.985u w=76.465u l=1u
X13313 DVDD GATE BAT DVDD pfet_06v0 ad=35.511p pd=48.245u as=35.511p ps=48.245u w=46.725u l=1u
X13314 BAT GATE DVDD DVDD pfet_06v0 ad=58.1134p pd=77.985u as=58.1134p ps=77.985u w=76.465u l=1u
X13315 DVDD GATE BAT DVDD pfet_06v0 ad=58.1134p pd=77.985u as=58.1134p ps=77.985u w=76.465u l=1u
X13316 BAT GATE DVDD DVDD pfet_06v0 ad=58.1552p pd=78.04u as=58.1552p ps=78.04u w=76.52u l=1u
X13317 BAT GATE DVDD DVDD pfet_06v0 ad=58.1096p pd=77.98u as=58.1096p ps=77.98u w=76.46u l=1u
X13318 BAT GATE DVDD DVDD pfet_06v0 ad=58.1134p pd=77.985u as=58.1134p ps=77.985u w=76.465u l=1u
X13319 BAT GATE DVDD DVDD pfet_06v0 ad=49.3848p pd=66.5u as=49.3848p ps=66.5u w=64.98u l=1u
X13320 DVDD GATE BAT DVDD pfet_06v0 ad=71.8771p pd=0.15481m as=58.1134p ps=77.985u w=76.465u l=1u
X13321 BAT GATE DVDD DVDD pfet_06v0 ad=35.511p pd=48.245u as=35.511p ps=48.245u w=46.725u l=1u
X13322 DVDD GATE BAT DVDD pfet_06v0 ad=58.1134p pd=77.985u as=58.1134p ps=77.985u w=76.465u l=1u
X13323 BAT GATE DVDD DVDD pfet_06v0 ad=35.511p pd=48.245u as=35.511p ps=48.245u w=46.725u l=1u
X13324 BAT GATE DVDD DVDD pfet_06v0 ad=58.1134p pd=77.985u as=71.8771p ps=0.15481m w=76.465u l=1u
X13325 DVDD GATE BAT DVDD pfet_06v0 ad=58.1096p pd=77.98u as=58.1096p ps=77.98u w=76.46u l=1u
X13326 BAT GATE DVDD DVDD pfet_06v0 ad=58.1172p pd=77.99u as=58.1172p ps=77.99u w=76.47u l=1u
X13327 BAT GATE DVDD DVDD pfet_06v0 ad=58.1134p pd=77.985u as=71.8771p ps=0.15481m w=76.465u l=1u
X13328 BAT GATE DVDD DVDD pfet_06v0 ad=35.5072p pd=48.24u as=35.5072p ps=48.24u w=46.72u l=1u
X13329 DVDD GATE BAT DVDD pfet_06v0 ad=35.511p pd=48.245u as=35.511p ps=48.245u w=46.725u l=1u
X13330 BAT GATE DVDD DVDD pfet_06v0 ad=58.1134p pd=77.985u as=71.8771p ps=0.15481m w=76.465u l=1u
X13331 BAT GATE DVDD DVDD pfet_06v0 ad=58.1134p pd=77.985u as=58.1134p ps=77.985u w=76.465u l=1u
X13332 DVDD GATE BAT DVDD pfet_06v0 ad=35.511p pd=48.245u as=35.511p ps=48.245u w=46.725u l=1u
X13333 DVDD GATE BAT DVDD pfet_06v0 ad=49.3848p pd=66.5u as=49.3848p ps=66.5u w=64.98u l=1u
X13334 BAT GATE DVDD DVDD pfet_06v0 ad=49.3848p pd=66.5u as=49.3848p ps=66.5u w=64.98u l=1u
X13335 BAT GATE DVDD DVDD pfet_06v0 ad=58.1134p pd=77.985u as=58.1134p ps=77.985u w=76.465u l=1u
X13336 DVDD GATE BAT DVDD pfet_06v0 ad=58.0754p pd=77.935u as=58.0754p ps=77.935u w=76.41499u l=1u
X13337 DVDD GATE BAT DVDD pfet_06v0 ad=35.5072p pd=48.24u as=35.5072p ps=48.24u w=46.72u l=1u
X13338 BAT GATE DVDD DVDD pfet_06v0 ad=35.511p pd=48.245u as=35.511p ps=48.245u w=46.725u l=1u
X13339 DVDD GATE BAT DVDD pfet_06v0 ad=47.6862p pd=64.265u as=47.6862p ps=64.265u w=62.745u l=1u
X13340 DVDD GATE BAT DVDD pfet_06v0 ad=71.8724p pd=0.1548m as=58.1096p ps=77.98u w=76.46u l=1u
X13341 BAT GATE DVDD DVDD pfet_06v0 ad=58.1552p pd=78.04u as=58.1552p ps=78.04u w=76.52u l=1u
X13342 DVDD GATE BAT DVDD pfet_06v0 ad=35.5072p pd=48.24u as=35.5072p ps=48.24u w=46.72u l=1u
X13343 DVDD GATE BAT DVDD pfet_06v0 ad=71.8771p pd=0.15481m as=58.1134p ps=77.985u w=76.465u l=1u
X13344 BAT GATE DVDD DVDD pfet_06v0 ad=35.511p pd=48.245u as=35.511p ps=48.245u w=46.725u l=1u
X13345 BAT GATE DVDD DVDD pfet_06v0 ad=58.1134p pd=77.985u as=58.1134p ps=77.985u w=76.465u l=1u
X13346 DVDD GATE BAT DVDD pfet_06v0 ad=61.0812p pd=0.13184m as=49.3848p ps=66.5u w=64.98u l=1u
X13347 BAT GATE DVDD DVDD pfet_06v0 ad=58.0754p pd=77.935u as=58.0754p ps=77.935u w=76.41499u l=1u
X13348 BAT GATE DVDD DVDD pfet_06v0 ad=35.5072p pd=48.24u as=35.5072p ps=48.24u w=46.72u l=1u
X13349 DVDD GATE BAT DVDD pfet_06v0 ad=35.511p pd=48.245u as=35.511p ps=48.245u w=46.725u l=1u
X13350 BAT GATE DVDD DVDD pfet_06v0 ad=58.1134p pd=77.985u as=58.1134p ps=77.985u w=76.465u l=1u
X13351 DVDD GATE BAT DVDD pfet_06v0 ad=35.511p pd=48.245u as=35.511p ps=48.245u w=46.725u l=1u
X13352 DVDD GATE BAT DVDD pfet_06v0 ad=58.1134p pd=77.985u as=58.1134p ps=77.985u w=76.465u l=1u
X13353 BAT GATE DVDD DVDD pfet_06v0 ad=58.1552p pd=78.04u as=58.1552p ps=78.04u w=76.52u l=1u
X13354 DVDD GATE BAT DVDD pfet_06v0 ad=58.1134p pd=77.985u as=58.1134p ps=77.985u w=76.465u l=1u
X13355 DVDD GATE BAT DVDD pfet_06v0 ad=58.1134p pd=77.985u as=58.1134p ps=77.985u w=76.465u l=1u
X13356 DVDD GATE BAT DVDD pfet_06v0 ad=35.511p pd=48.245u as=35.511p ps=48.245u w=46.725u l=1u
X13357 DVDD GATE BAT DVDD pfet_06v0 ad=47.6862p pd=64.265u as=47.6862p ps=64.265u w=62.745u l=1u
X13358 BAT GATE DVDD DVDD pfet_06v0 ad=58.1172p pd=77.99u as=58.1172p ps=77.99u w=76.47u l=1u
X13359 DVDD GATE BAT DVDD pfet_06v0 ad=43.9215p pd=95.32999u as=35.511p ps=48.245u w=46.725u l=1u
X13360 DVDD GATE BAT DVDD pfet_06v0 ad=35.511p pd=48.245u as=35.511p ps=48.245u w=46.725u l=1u
X13361 BAT GATE DVDD DVDD pfet_06v0 ad=35.511p pd=48.245u as=35.511p ps=48.245u w=46.725u l=1u
X13362 DVDD GATE BAT DVDD pfet_06v0 ad=43.9215p pd=95.32999u as=35.511p ps=48.245u w=46.725u l=1u
X13363 DVDD GATE BAT DVDD pfet_06v0 ad=47.6862p pd=64.265u as=47.6862p ps=64.265u w=62.745u l=1u
X13364 DVDD GATE BAT DVDD pfet_06v0 ad=58.1096p pd=77.98u as=58.1096p ps=77.98u w=76.46u l=1u
X13365 BAT GATE DVDD DVDD pfet_06v0 ad=35.511p pd=48.245u as=35.511p ps=48.245u w=46.725u l=1u
X13366 DVDD GATE BAT DVDD pfet_06v0 ad=58.1096p pd=77.98u as=58.1096p ps=77.98u w=76.46u l=1u
X13367 DVDD GATE BAT DVDD pfet_06v0 ad=35.511p pd=48.245u as=35.511p ps=48.245u w=46.725u l=1u
X13368 BAT GATE DVDD DVDD pfet_06v0 ad=35.511p pd=48.245u as=43.9215p ps=95.32999u w=46.725u l=1u
X13369 DVDD GATE BAT DVDD pfet_06v0 ad=58.0754p pd=77.935u as=58.0754p ps=77.935u w=76.41499u l=1u
X13370 BAT GATE DVDD DVDD pfet_06v0 ad=35.511p pd=48.245u as=43.9215p ps=95.32999u w=46.725u l=1u
X13371 DVDD GATE BAT DVDD pfet_06v0 ad=49.3848p pd=66.5u as=49.3848p ps=66.5u w=64.98u l=1u
X13372 BAT GATE DVDD DVDD pfet_06v0 ad=35.511p pd=48.245u as=35.511p ps=48.245u w=46.725u l=1u
X13373 BAT GATE DVDD DVDD pfet_06v0 ad=35.511p pd=48.245u as=35.511p ps=48.245u w=46.725u l=1u
X13374 DVDD GATE BAT DVDD pfet_06v0 ad=61.0812p pd=0.13184m as=49.3848p ps=66.5u w=64.98u l=1u
X13375 DVDD GATE BAT DVDD pfet_06v0 ad=35.511p pd=48.245u as=35.511p ps=48.245u w=46.725u l=1u
X13376 DVDD GATE BAT DVDD pfet_06v0 ad=43.9215p pd=95.32999u as=35.511p ps=48.245u w=46.725u l=1u
X13377 DVDD GATE BAT DVDD pfet_06v0 ad=35.511p pd=48.245u as=35.511p ps=48.245u w=46.725u l=1u
X13378 BAT GATE DVDD DVDD pfet_06v0 ad=35.511p pd=48.245u as=35.511p ps=48.245u w=46.725u l=1u
X13379 DVDD GATE BAT DVDD pfet_06v0 ad=35.511p pd=48.245u as=35.511p ps=48.245u w=46.725u l=1u
X13380 BAT GATE DVDD DVDD pfet_06v0 ad=35.511p pd=48.245u as=35.511p ps=48.245u w=46.725u l=1u
X13381 DVDD GATE BAT DVDD pfet_06v0 ad=58.1134p pd=77.985u as=58.1134p ps=77.985u w=76.465u l=1u
X13382 BAT GATE DVDD DVDD pfet_06v0 ad=58.1552p pd=78.04u as=58.1552p ps=78.04u w=76.52u l=1u
X13383 BAT GATE DVDD DVDD pfet_06v0 ad=35.511p pd=48.245u as=35.511p ps=48.245u w=46.725u l=1u
X13384 BAT GATE DVDD DVDD pfet_06v0 ad=58.1134p pd=77.985u as=58.1134p ps=77.985u w=76.465u l=1u
X13385 DVDD GATE BAT DVDD pfet_06v0 ad=58.1134p pd=77.985u as=58.1134p ps=77.985u w=76.465u l=1u
X13386 BAT GATE DVDD DVDD pfet_06v0 ad=35.511p pd=48.245u as=43.9215p ps=95.32999u w=46.725u l=1u
X13387 DVDD GATE BAT DVDD pfet_06v0 ad=58.1172p pd=77.99u as=58.1172p ps=77.99u w=76.47u l=1u
X13388 BAT GATE DVDD DVDD pfet_06v0 ad=35.511p pd=48.245u as=35.511p ps=48.245u w=46.725u l=1u
X13389 DVDD GATE BAT DVDD pfet_06v0 ad=35.511p pd=48.245u as=35.511p ps=48.245u w=46.725u l=1u
X13390 DVDD GATE BAT DVDD pfet_06v0 ad=35.511p pd=48.245u as=35.511p ps=48.245u w=46.725u l=1u
X13391 BAT GATE DVDD DVDD pfet_06v0 ad=35.511p pd=48.245u as=35.511p ps=48.245u w=46.725u l=1u
X13392 DVDD GATE BAT DVDD pfet_06v0 ad=71.8771p pd=0.15481m as=58.1134p ps=77.985u w=76.465u l=1u
X13393 DVDD GATE BAT DVDD pfet_06v0 ad=58.1172p pd=77.99u as=58.1172p ps=77.99u w=76.47u l=1u
X13394 BAT GATE DVDD DVDD pfet_06v0 ad=35.511p pd=48.245u as=35.511p ps=48.245u w=46.725u l=1u
X13395 BAT GATE DVDD DVDD pfet_06v0 ad=58.1134p pd=77.985u as=71.8771p ps=0.15481m w=76.465u l=1u
X13396 DVDD GATE BAT DVDD pfet_06v0 ad=58.1134p pd=77.985u as=58.1134p ps=77.985u w=76.465u l=1u
X13397 DVDD GATE BAT DVDD pfet_06v0 ad=58.1172p pd=77.99u as=58.1172p ps=77.99u w=76.47u l=1u
X13398 DVDD GATE BAT DVDD pfet_06v0 ad=43.9215p pd=95.32999u as=35.511p ps=48.245u w=46.725u l=1u
X13399 DVDD GATE BAT DVDD pfet_06v0 ad=35.511p pd=48.245u as=35.511p ps=48.245u w=46.725u l=1u
X13400 DVDD GATE BAT DVDD pfet_06v0 ad=58.1096p pd=77.98u as=58.1096p ps=77.98u w=76.46u l=1u
X13401 DVDD GATE BAT DVDD pfet_06v0 ad=71.92879p pd=0.15492m as=58.1552p ps=78.04u w=76.52u l=1u
X13402 DVDD GATE BAT DVDD pfet_06v0 ad=71.8771p pd=0.15481m as=58.1134p ps=77.985u w=76.465u l=1u
X13403 BAT GATE DVDD DVDD pfet_06v0 ad=58.1134p pd=77.985u as=71.8771p ps=0.15481m w=76.465u l=1u
X13404 BAT GATE DVDD DVDD pfet_06v0 ad=58.1172p pd=77.99u as=58.1172p ps=77.99u w=76.47u l=1u
X13405 DVDD GATE BAT DVDD pfet_06v0 ad=35.511p pd=48.245u as=35.511p ps=48.245u w=46.725u l=1u
X13406 BAT GATE DVDD DVDD pfet_06v0 ad=58.1134p pd=77.985u as=71.8771p ps=0.15481m w=76.465u l=1u
X13407 BAT GATE DVDD DVDD pfet_06v0 ad=35.511p pd=48.245u as=35.511p ps=48.245u w=46.725u l=1u
X13408 BAT GATE DVDD DVDD pfet_06v0 ad=35.5072p pd=48.24u as=35.5072p ps=48.24u w=46.72u l=1u
X13409 DVDD GATE BAT DVDD pfet_06v0 ad=35.511p pd=48.245u as=35.511p ps=48.245u w=46.725u l=1u
X13410 BAT GATE DVDD DVDD pfet_06v0 ad=58.1134p pd=77.985u as=58.1134p ps=77.985u w=76.465u l=1u
X13411 DVDD GATE BAT DVDD pfet_06v0 ad=58.1134p pd=77.985u as=58.1134p ps=77.985u w=76.465u l=1u
X13412 DVDD GATE BAT DVDD pfet_06v0 ad=58.1134p pd=77.985u as=58.1134p ps=77.985u w=76.465u l=1u
X13413 BAT GATE DVDD DVDD pfet_06v0 ad=35.511p pd=48.245u as=43.9215p ps=95.32999u w=46.725u l=1u
X13414 DVDD GATE BAT DVDD pfet_06v0 ad=71.92879p pd=0.15492m as=58.1552p ps=78.04u w=76.52u l=1u
X13415 DVDD GATE BAT DVDD pfet_06v0 ad=35.511p pd=48.245u as=35.511p ps=48.245u w=46.725u l=1u
X13416 BAT GATE DVDD DVDD pfet_06v0 ad=58.1134p pd=77.985u as=58.1134p ps=77.985u w=76.465u l=1u
X13417 DVDD GATE BAT DVDD pfet_06v0 ad=43.9215p pd=95.32999u as=35.511p ps=48.245u w=46.725u l=1u
X13418 BAT GATE DVDD DVDD pfet_06v0 ad=58.1134p pd=77.985u as=58.1134p ps=77.985u w=76.465u l=1u
X13419 DVDD GATE BAT DVDD pfet_06v0 ad=58.1552p pd=78.04u as=58.1552p ps=78.04u w=76.52u l=1u
X13420 DVDD GATE BAT DVDD pfet_06v0 ad=35.511p pd=48.245u as=35.511p ps=48.245u w=46.725u l=1u
X13421 BAT GATE DVDD DVDD pfet_06v0 ad=58.1134p pd=77.985u as=58.1134p ps=77.985u w=76.465u l=1u
X13422 DVDD GATE BAT DVDD pfet_06v0 ad=49.3848p pd=66.5u as=49.3848p ps=66.5u w=64.98u l=1u
X13423 DVDD GATE BAT DVDD pfet_06v0 ad=58.0754p pd=77.935u as=58.0754p ps=77.935u w=76.41499u l=1u
X13424 DVDD GATE BAT DVDD pfet_06v0 ad=35.511p pd=48.245u as=35.511p ps=48.245u w=46.725u l=1u
X13425 BAT GATE DVDD DVDD pfet_06v0 ad=58.1134p pd=77.985u as=58.1134p ps=77.985u w=76.465u l=1u
X13426 DVDD GATE BAT DVDD pfet_06v0 ad=43.9215p pd=95.32999u as=35.511p ps=48.245u w=46.725u l=1u
X13427 DVDD GATE BAT DVDD pfet_06v0 ad=58.1552p pd=78.04u as=58.1552p ps=78.04u w=76.52u l=1u
X13428 BAT GATE DVDD DVDD pfet_06v0 ad=58.1134p pd=77.985u as=58.1134p ps=77.985u w=76.465u l=1u
X13429 DVDD GATE BAT DVDD pfet_06v0 ad=47.6862p pd=64.265u as=47.6862p ps=64.265u w=62.745u l=1u
X13430 DVDD GATE BAT DVDD pfet_06v0 ad=58.1172p pd=77.99u as=58.1172p ps=77.99u w=76.47u l=1u
X13431 BAT GATE DVDD DVDD pfet_06v0 ad=58.1134p pd=77.985u as=58.1134p ps=77.985u w=76.465u l=1u
X13432 DVDD GATE BAT DVDD pfet_06v0 ad=47.6862p pd=64.265u as=47.6862p ps=64.265u w=62.745u l=1u
X13433 BAT GATE DVDD DVDD pfet_06v0 ad=35.511p pd=48.245u as=35.511p ps=48.245u w=46.725u l=1u
X13434 BAT GATE DVDD DVDD pfet_06v0 ad=35.511p pd=48.245u as=35.511p ps=48.245u w=46.725u l=1u
X13435 DVDD GATE BAT DVDD pfet_06v0 ad=58.1172p pd=77.99u as=58.1172p ps=77.99u w=76.47u l=1u
X13436 BAT GATE DVDD DVDD pfet_06v0 ad=58.1134p pd=77.985u as=71.8771p ps=0.15481m w=76.465u l=1u
X13437 BAT GATE DVDD DVDD pfet_06v0 ad=35.511p pd=48.245u as=35.511p ps=48.245u w=46.725u l=1u
X13438 DVDD GATE BAT DVDD pfet_06v0 ad=58.1172p pd=77.99u as=58.1172p ps=77.99u w=76.47u l=1u
X13439 DVDD GATE BAT DVDD pfet_06v0 ad=58.1096p pd=77.98u as=58.1096p ps=77.98u w=76.46u l=1u
X13440 DVDD GATE BAT DVDD pfet_06v0 ad=35.511p pd=48.245u as=35.511p ps=48.245u w=46.725u l=1u
X13441 DVDD GATE BAT DVDD pfet_06v0 ad=35.511p pd=48.245u as=35.511p ps=48.245u w=46.725u l=1u
X13442 DVDD GATE BAT DVDD pfet_06v0 ad=58.1134p pd=77.985u as=58.1134p ps=77.985u w=76.465u l=1u
X13443 BAT GATE DVDD DVDD pfet_06v0 ad=58.1134p pd=77.985u as=71.8771p ps=0.15481m w=76.465u l=1u
X13444 BAT GATE DVDD DVDD pfet_06v0 ad=35.511p pd=48.245u as=43.9215p ps=95.32999u w=46.725u l=1u
X13445 DVDD GATE BAT DVDD pfet_06v0 ad=71.8724p pd=0.1548m as=58.1096p ps=77.98u w=76.46u l=1u
X13446 BAT GATE DVDD DVDD pfet_06v0 ad=58.0754p pd=77.935u as=58.0754p ps=77.935u w=76.41499u l=1u
X13447 DVDD GATE BAT DVDD pfet_06v0 ad=58.1134p pd=77.985u as=58.1134p ps=77.985u w=76.465u l=1u
X13448 BAT GATE DVDD DVDD pfet_06v0 ad=58.1096p pd=77.98u as=58.1096p ps=77.98u w=76.46u l=1u
X13449 BAT GATE DVDD DVDD pfet_06v0 ad=58.0754p pd=77.935u as=58.0754p ps=77.935u w=76.41499u l=1u
X13450 DVDD GATE BAT DVDD pfet_06v0 ad=35.511p pd=48.245u as=35.511p ps=48.245u w=46.725u l=1u
X13451 DVDD GATE BAT DVDD pfet_06v0 ad=58.0754p pd=77.935u as=58.0754p ps=77.935u w=76.41499u l=1u
X13452 BAT GATE DVDD DVDD pfet_06v0 ad=35.511p pd=48.245u as=35.511p ps=48.245u w=46.725u l=1u
X13453 BAT GATE DVDD DVDD pfet_06v0 ad=49.3848p pd=66.5u as=49.3848p ps=66.5u w=64.98u l=1u
X13454 DVDD GATE BAT DVDD pfet_06v0 ad=71.8771p pd=0.15481m as=58.1134p ps=77.985u w=76.465u l=1u
X13455 DVDD GATE BAT DVDD pfet_06v0 ad=58.1134p pd=77.985u as=58.1134p ps=77.985u w=76.465u l=1u
X13456 BAT GATE DVDD DVDD pfet_06v0 ad=47.6862p pd=64.265u as=58.9803p ps=0.12737m w=62.745u l=1u
X13457 BAT GATE DVDD DVDD pfet_06v0 ad=58.1134p pd=77.985u as=58.1134p ps=77.985u w=76.465u l=1u
X13458 BAT GATE DVDD DVDD pfet_06v0 ad=58.1172p pd=77.99u as=58.1172p ps=77.99u w=76.47u l=1u
X13459 DVDD GATE BAT DVDD pfet_06v0 ad=49.3848p pd=66.5u as=49.3848p ps=66.5u w=64.98u l=1u
X13460 BAT GATE DVDD DVDD pfet_06v0 ad=35.5072p pd=48.24u as=43.9168p ps=95.32u w=46.72u l=1u
X13461 DVDD GATE BAT DVDD pfet_06v0 ad=58.1172p pd=77.99u as=58.1172p ps=77.99u w=76.47u l=1u
X13462 BAT GATE DVDD DVDD pfet_06v0 ad=35.511p pd=48.245u as=35.511p ps=48.245u w=46.725u l=1u
X13463 BAT GATE DVDD DVDD pfet_06v0 ad=58.1134p pd=77.985u as=71.8771p ps=0.15481m w=76.465u l=1u
X13464 DVDD GATE BAT DVDD pfet_06v0 ad=58.1134p pd=77.985u as=58.1134p ps=77.985u w=76.465u l=1u
X13465 DVDD GATE BAT DVDD pfet_06v0 ad=71.8771p pd=0.15481m as=58.1134p ps=77.985u w=76.465u l=1u
X13466 BAT GATE DVDD DVDD pfet_06v0 ad=58.1096p pd=77.98u as=71.8724p ps=0.1548m w=76.46u l=1u
X13467 BAT GATE DVDD DVDD pfet_06v0 ad=35.511p pd=48.245u as=35.511p ps=48.245u w=46.725u l=1u
X13468 BAT GATE DVDD DVDD pfet_06v0 ad=58.1096p pd=77.98u as=71.8724p ps=0.1548m w=76.46u l=1u
X13469 BAT GATE DVDD DVDD pfet_06v0 ad=58.1096p pd=77.98u as=58.1096p ps=77.98u w=76.46u l=1u
X13470 DVDD GATE BAT DVDD pfet_06v0 ad=58.1134p pd=77.985u as=58.1134p ps=77.985u w=76.465u l=1u
X13471 DVDD GATE BAT DVDD pfet_06v0 ad=71.8818p pd=0.15482m as=58.1172p ps=77.99u w=76.47u l=1u
X13472 DVDD GATE BAT DVDD pfet_06v0 ad=49.3848p pd=66.5u as=49.3848p ps=66.5u w=64.98u l=1u
X13473 DVDD GATE BAT DVDD pfet_06v0 ad=43.9215p pd=95.32999u as=35.511p ps=48.245u w=46.725u l=1u
X13474 BAT GATE DVDD DVDD pfet_06v0 ad=35.511p pd=48.245u as=43.9215p ps=95.32999u w=46.725u l=1u
X13475 DVDD GATE BAT DVDD pfet_06v0 ad=35.5072p pd=48.24u as=35.5072p ps=48.24u w=46.72u l=1u
X13476 DVDD GATE BAT DVDD pfet_06v0 ad=71.8771p pd=0.15481m as=58.1134p ps=77.985u w=76.465u l=1u
X13477 DVDD GATE BAT DVDD pfet_06v0 ad=35.511p pd=48.245u as=35.511p ps=48.245u w=46.725u l=1u
X13478 BAT GATE DVDD DVDD pfet_06v0 ad=35.511p pd=48.245u as=35.511p ps=48.245u w=46.725u l=1u
X13479 BAT GATE DVDD DVDD pfet_06v0 ad=58.1134p pd=77.985u as=58.1134p ps=77.985u w=76.465u l=1u
X13480 BAT GATE DVDD DVDD pfet_06v0 ad=35.511p pd=48.245u as=35.511p ps=48.245u w=46.725u l=1u
X13481 BAT GATE DVDD DVDD pfet_06v0 ad=35.511p pd=48.245u as=35.511p ps=48.245u w=46.725u l=1u
X13482 BAT GATE DVDD DVDD pfet_06v0 ad=58.1134p pd=77.985u as=58.1134p ps=77.985u w=76.465u l=1u
X13483 DVDD GATE BAT DVDD pfet_06v0 ad=71.8771p pd=0.15481m as=58.1134p ps=77.985u w=76.465u l=1u
X13484 BAT GATE DVDD DVDD pfet_06v0 ad=35.5072p pd=48.24u as=43.9168p ps=95.32u w=46.72u l=1u
X13485 BAT GATE DVDD DVDD pfet_06v0 ad=58.1172p pd=77.99u as=71.8818p ps=0.15482m w=76.47u l=1u
X13486 DVDD GATE BAT DVDD pfet_06v0 ad=71.8771p pd=0.15481m as=58.1134p ps=77.985u w=76.465u l=1u
X13487 BAT GATE DVDD DVDD pfet_06v0 ad=58.1134p pd=77.985u as=58.1134p ps=77.985u w=76.465u l=1u
X13488 BAT GATE DVDD DVDD pfet_06v0 ad=35.511p pd=48.245u as=35.511p ps=48.245u w=46.725u l=1u
X13489 DVDD GATE BAT DVDD pfet_06v0 ad=35.511p pd=48.245u as=35.511p ps=48.245u w=46.725u l=1u
X13490 BAT GATE DVDD DVDD pfet_06v0 ad=35.511p pd=48.245u as=35.511p ps=48.245u w=46.725u l=1u
X13491 DVDD GATE BAT DVDD pfet_06v0 ad=71.8771p pd=0.15481m as=58.1134p ps=77.985u w=76.465u l=1u
X13492 BAT GATE DVDD DVDD pfet_06v0 ad=58.0754p pd=77.935u as=58.0754p ps=77.935u w=76.41499u l=1u
X13493 BAT GATE DVDD DVDD pfet_06v0 ad=35.511p pd=48.245u as=35.511p ps=48.245u w=46.725u l=1u
X13494 DVDD GATE BAT DVDD pfet_06v0 ad=47.6862p pd=64.265u as=47.6862p ps=64.265u w=62.745u l=1u
X13495 DVDD GATE BAT DVDD pfet_06v0 ad=71.8771p pd=0.15481m as=58.1134p ps=77.985u w=76.465u l=1u
X13496 BAT GATE DVDD DVDD pfet_06v0 ad=58.1134p pd=77.985u as=58.1134p ps=77.985u w=76.465u l=1u
X13497 DVDD GATE BAT DVDD pfet_06v0 ad=58.1552p pd=78.04u as=58.1552p ps=78.04u w=76.52u l=1u
X13498 DVDD GATE BAT DVDD pfet_06v0 ad=58.1134p pd=77.985u as=58.1134p ps=77.985u w=76.465u l=1u
X13499 BAT GATE DVDD DVDD pfet_06v0 ad=35.511p pd=48.245u as=35.511p ps=48.245u w=46.725u l=1u
X13500 DVDD GATE BAT DVDD pfet_06v0 ad=43.9215p pd=95.32999u as=35.511p ps=48.245u w=46.725u l=1u
X13501 BAT GATE DVDD DVDD pfet_06v0 ad=58.1172p pd=77.99u as=71.8818p ps=0.15482m w=76.47u l=1u
X13502 DVDD GATE BAT DVDD pfet_06v0 ad=58.1134p pd=77.985u as=58.1134p ps=77.985u w=76.465u l=1u
X13503 DVDD GATE BAT DVDD pfet_06v0 ad=43.9215p pd=95.32999u as=35.511p ps=48.245u w=46.725u l=1u
X13504 DVDD GATE BAT DVDD pfet_06v0 ad=58.1134p pd=77.985u as=58.1134p ps=77.985u w=76.465u l=1u
X13505 BAT GATE DVDD DVDD pfet_06v0 ad=58.1172p pd=77.99u as=58.1172p ps=77.99u w=76.47u l=1u
X13506 DVDD GATE BAT DVDD pfet_06v0 ad=35.5072p pd=48.24u as=35.5072p ps=48.24u w=46.72u l=1u
X13507 BAT GATE DVDD DVDD pfet_06v0 ad=58.1134p pd=77.985u as=58.1134p ps=77.985u w=76.465u l=1u
X13508 DVDD GATE BAT DVDD pfet_06v0 ad=35.511p pd=48.245u as=35.511p ps=48.245u w=46.725u l=1u
X13509 BAT GATE DVDD DVDD pfet_06v0 ad=35.511p pd=48.245u as=35.511p ps=48.245u w=46.725u l=1u
X13510 BAT GATE DVDD DVDD pfet_06v0 ad=58.1552p pd=78.04u as=58.1552p ps=78.04u w=76.52u l=1u
X13511 BAT GATE DVDD DVDD pfet_06v0 ad=35.511p pd=48.245u as=35.511p ps=48.245u w=46.725u l=1u
X13512 BAT GATE DVDD DVDD pfet_06v0 ad=35.511p pd=48.245u as=35.511p ps=48.245u w=46.725u l=1u
X13513 DVDD GATE BAT DVDD pfet_06v0 ad=58.1172p pd=77.99u as=58.1172p ps=77.99u w=76.47u l=1u
X13514 BAT GATE DVDD DVDD pfet_06v0 ad=58.1096p pd=77.98u as=71.8724p ps=0.1548m w=76.46u l=1u
X13515 BAT GATE DVDD DVDD pfet_06v0 ad=35.511p pd=48.245u as=35.511p ps=48.245u w=46.725u l=1u
X13516 DVDD GATE BAT DVDD pfet_06v0 ad=35.511p pd=48.245u as=35.511p ps=48.245u w=46.725u l=1u
X13517 DVDD GATE BAT DVDD pfet_06v0 ad=35.5072p pd=48.24u as=35.5072p ps=48.24u w=46.72u l=1u
X13518 BAT GATE DVDD DVDD pfet_06v0 ad=35.511p pd=48.245u as=43.9215p ps=95.32999u w=46.725u l=1u
X13519 DVDD GATE BAT DVDD pfet_06v0 ad=35.511p pd=48.245u as=35.511p ps=48.245u w=46.725u l=1u
X13520 BAT GATE DVDD DVDD pfet_06v0 ad=35.511p pd=48.245u as=43.9215p ps=95.32999u w=46.725u l=1u
X13521 BAT GATE DVDD DVDD pfet_06v0 ad=58.1552p pd=78.04u as=71.92879p ps=0.15492m w=76.52u l=1u
X13522 BAT GATE DVDD DVDD pfet_06v0 ad=58.1552p pd=78.04u as=58.1552p ps=78.04u w=76.52u l=1u
X13523 BAT GATE DVDD DVDD pfet_06v0 ad=58.1134p pd=77.985u as=58.1134p ps=77.985u w=76.465u l=1u
X13524 DVDD GATE BAT DVDD pfet_06v0 ad=71.8301p pd=0.15471m as=58.0754p ps=77.935u w=76.41499u l=1u
X13525 DVDD GATE BAT DVDD pfet_06v0 ad=71.92879p pd=0.15492m as=58.1552p ps=78.04u w=76.52u l=1u
X13526 DVDD GATE BAT DVDD pfet_06v0 ad=58.1134p pd=77.985u as=58.1134p ps=77.985u w=76.465u l=1u
X13527 BAT GATE DVDD DVDD pfet_06v0 ad=58.1552p pd=78.04u as=58.1552p ps=78.04u w=76.52u l=1u
X13528 BAT GATE DVDD DVDD pfet_06v0 ad=35.511p pd=48.245u as=43.9215p ps=95.32999u w=46.725u l=1u
X13529 BAT GATE DVDD DVDD pfet_06v0 ad=35.511p pd=48.245u as=35.511p ps=48.245u w=46.725u l=1u
X13530 BAT GATE DVDD DVDD pfet_06v0 ad=35.511p pd=48.245u as=35.511p ps=48.245u w=46.725u l=1u
X13531 BAT GATE DVDD DVDD pfet_06v0 ad=58.1134p pd=77.985u as=58.1134p ps=77.985u w=76.465u l=1u
X13532 DVDD GATE BAT DVDD pfet_06v0 ad=35.511p pd=48.245u as=35.511p ps=48.245u w=46.725u l=1u
X13533 BAT GATE DVDD DVDD pfet_06v0 ad=58.0754p pd=77.935u as=58.0754p ps=77.935u w=76.41499u l=1u
X13534 BAT GATE DVDD DVDD pfet_06v0 ad=35.511p pd=48.245u as=43.9215p ps=95.32999u w=46.725u l=1u
X13535 DVDD GATE BAT DVDD pfet_06v0 ad=35.511p pd=48.245u as=35.511p ps=48.245u w=46.725u l=1u
X13536 DVDD GATE BAT DVDD pfet_06v0 ad=58.1134p pd=77.985u as=58.1134p ps=77.985u w=76.465u l=1u
X13537 BAT GATE DVDD DVDD pfet_06v0 ad=35.511p pd=48.245u as=43.9215p ps=95.32999u w=46.725u l=1u
X13538 BAT GATE DVDD DVDD pfet_06v0 ad=58.1552p pd=78.04u as=58.1552p ps=78.04u w=76.52u l=1u
X13539 DVDD GATE BAT DVDD pfet_06v0 ad=58.1134p pd=77.985u as=58.1134p ps=77.985u w=76.465u l=1u
X13540 BAT GATE DVDD DVDD pfet_06v0 ad=35.511p pd=48.245u as=35.511p ps=48.245u w=46.725u l=1u
X13541 BAT GATE DVDD DVDD pfet_06v0 ad=58.1172p pd=77.99u as=58.1172p ps=77.99u w=76.47u l=1u
X13542 BAT GATE DVDD DVDD pfet_06v0 ad=47.6862p pd=64.265u as=58.9803p ps=0.12737m w=62.745u l=1u
X13543 BAT GATE DVDD DVDD pfet_06v0 ad=58.1134p pd=77.985u as=58.1134p ps=77.985u w=76.465u l=1u
X13544 BAT GATE DVDD DVDD pfet_06v0 ad=58.1172p pd=77.99u as=58.1172p ps=77.99u w=76.47u l=1u
X13545 DVDD GATE BAT DVDD pfet_06v0 ad=58.1134p pd=77.985u as=58.1134p ps=77.985u w=76.465u l=1u
X13546 BAT GATE DVDD DVDD pfet_06v0 ad=58.1134p pd=77.985u as=58.1134p ps=77.985u w=76.465u l=1u
X13547 DVDD GATE BAT DVDD pfet_06v0 ad=43.9215p pd=95.32999u as=35.511p ps=48.245u w=46.725u l=1u
X13548 DVDD GATE BAT DVDD pfet_06v0 ad=35.511p pd=48.245u as=35.511p ps=48.245u w=46.725u l=1u
X13549 BAT GATE DVDD DVDD pfet_06v0 ad=58.1134p pd=77.985u as=58.1134p ps=77.985u w=76.465u l=1u
X13550 DVDD GATE BAT DVDD pfet_06v0 ad=58.1096p pd=77.98u as=58.1096p ps=77.98u w=76.46u l=1u
X13551 DVDD GATE BAT DVDD pfet_06v0 ad=58.1134p pd=77.985u as=58.1134p ps=77.985u w=76.465u l=1u
X13552 BAT GATE DVDD DVDD pfet_06v0 ad=35.511p pd=48.245u as=35.511p ps=48.245u w=46.725u l=1u
X13553 DVDD GATE BAT DVDD pfet_06v0 ad=58.1096p pd=77.98u as=58.1096p ps=77.98u w=76.46u l=1u
X13554 BAT GATE DVDD DVDD pfet_06v0 ad=58.1096p pd=77.98u as=58.1096p ps=77.98u w=76.46u l=1u
X13555 DVDD GATE BAT DVDD pfet_06v0 ad=35.511p pd=48.245u as=35.511p ps=48.245u w=46.725u l=1u
X13556 DVDD GATE BAT DVDD pfet_06v0 ad=35.511p pd=48.245u as=35.511p ps=48.245u w=46.725u l=1u
X13557 BAT GATE DVDD DVDD pfet_06v0 ad=35.511p pd=48.245u as=35.511p ps=48.245u w=46.725u l=1u
X13558 DVDD GATE BAT DVDD pfet_06v0 ad=61.0812p pd=0.13184m as=49.3848p ps=66.5u w=64.98u l=1u
X13559 DVDD GATE BAT DVDD pfet_06v0 ad=35.5072p pd=48.24u as=35.5072p ps=48.24u w=46.72u l=1u
X13560 BAT GATE DVDD DVDD pfet_06v0 ad=35.511p pd=48.245u as=35.511p ps=48.245u w=46.725u l=1u
X13561 DVDD GATE BAT DVDD pfet_06v0 ad=35.511p pd=48.245u as=35.511p ps=48.245u w=46.725u l=1u
X13562 DVDD GATE BAT DVDD pfet_06v0 ad=58.1172p pd=77.99u as=58.1172p ps=77.99u w=76.47u l=1u
X13563 BAT GATE DVDD DVDD pfet_06v0 ad=49.3848p pd=66.5u as=49.3848p ps=66.5u w=64.98u l=1u
X13564 DVDD GATE BAT DVDD pfet_06v0 ad=49.3848p pd=66.5u as=49.3848p ps=66.5u w=64.98u l=1u
X13565 BAT GATE DVDD DVDD pfet_06v0 ad=58.1134p pd=77.985u as=58.1134p ps=77.985u w=76.465u l=1u
X13566 BAT GATE DVDD DVDD pfet_06v0 ad=47.6862p pd=64.265u as=47.6862p ps=64.265u w=62.745u l=1u
X13567 BAT GATE DVDD DVDD pfet_06v0 ad=58.1134p pd=77.985u as=58.1134p ps=77.985u w=76.465u l=1u
X13568 BAT GATE DVDD DVDD pfet_06v0 ad=58.0754p pd=77.935u as=58.0754p ps=77.935u w=76.41499u l=1u
X13569 DVDD GATE BAT DVDD pfet_06v0 ad=35.511p pd=48.245u as=35.511p ps=48.245u w=46.725u l=1u
X13570 BAT GATE DVDD DVDD pfet_06v0 ad=49.3848p pd=66.5u as=61.0812p ps=0.13184m w=64.98u l=1u
X13571 BAT GATE DVDD DVDD pfet_06v0 ad=35.511p pd=48.245u as=35.511p ps=48.245u w=46.725u l=1u
X13572 DVDD GATE BAT DVDD pfet_06v0 ad=58.1134p pd=77.985u as=58.1134p ps=77.985u w=76.465u l=1u
X13573 BAT GATE DVDD DVDD pfet_06v0 ad=58.1134p pd=77.985u as=58.1134p ps=77.985u w=76.465u l=1u
X13574 BAT GATE DVDD DVDD pfet_06v0 ad=58.1134p pd=77.985u as=58.1134p ps=77.985u w=76.465u l=1u
X13575 BAT GATE DVDD DVDD pfet_06v0 ad=49.3848p pd=66.5u as=49.3848p ps=66.5u w=64.98u l=1u
X13576 DVDD GATE BAT DVDD pfet_06v0 ad=58.1134p pd=77.985u as=58.1134p ps=77.985u w=76.465u l=1u
X13577 DVDD GATE BAT DVDD pfet_06v0 ad=71.8771p pd=0.15481m as=58.1134p ps=77.985u w=76.465u l=1u
X13578 BAT GATE DVDD DVDD pfet_06v0 ad=49.3848p pd=66.5u as=49.3848p ps=66.5u w=64.98u l=1u
X13579 BAT GATE DVDD DVDD pfet_06v0 ad=58.1134p pd=77.985u as=58.1134p ps=77.985u w=76.465u l=1u
X13580 DVDD GATE BAT DVDD pfet_06v0 ad=43.9215p pd=95.32999u as=35.511p ps=48.245u w=46.725u l=1u
X13581 BAT GATE DVDD DVDD pfet_06v0 ad=58.1172p pd=77.99u as=58.1172p ps=77.99u w=76.47u l=1u
X13582 BAT GATE DVDD DVDD pfet_06v0 ad=58.0754p pd=77.935u as=58.0754p ps=77.935u w=76.41499u l=1u
X13583 DVDD GATE BAT DVDD pfet_06v0 ad=58.1134p pd=77.985u as=58.1134p ps=77.985u w=76.465u l=1u
X13584 DVDD GATE BAT DVDD pfet_06v0 ad=58.1134p pd=77.985u as=58.1134p ps=77.985u w=76.465u l=1u
X13585 BAT GATE DVDD DVDD pfet_06v0 ad=35.511p pd=48.245u as=35.511p ps=48.245u w=46.725u l=1u
X13586 DVDD GATE BAT DVDD pfet_06v0 ad=35.511p pd=48.245u as=35.511p ps=48.245u w=46.725u l=1u
X13587 BAT GATE DVDD DVDD pfet_06v0 ad=58.1134p pd=77.985u as=58.1134p ps=77.985u w=76.465u l=1u
X13588 BAT GATE DVDD DVDD pfet_06v0 ad=35.5072p pd=48.24u as=35.5072p ps=48.24u w=46.72u l=1u
X13589 DVDD GATE BAT DVDD pfet_06v0 ad=35.511p pd=48.245u as=35.511p ps=48.245u w=46.725u l=1u
X13590 BAT GATE DVDD DVDD pfet_06v0 ad=58.1134p pd=77.985u as=58.1134p ps=77.985u w=76.465u l=1u
X13591 DVDD GATE BAT DVDD pfet_06v0 ad=71.92879p pd=0.15492m as=58.1552p ps=78.04u w=76.52u l=1u
X13592 BAT GATE DVDD DVDD pfet_06v0 ad=58.1134p pd=77.985u as=71.8771p ps=0.15481m w=76.465u l=1u
X13593 BAT GATE DVDD DVDD pfet_06v0 ad=58.1134p pd=77.985u as=71.8771p ps=0.15481m w=76.465u l=1u
X13594 DVDD GATE BAT DVDD pfet_06v0 ad=58.0754p pd=77.935u as=58.0754p ps=77.935u w=76.41499u l=1u
X13595 BAT GATE DVDD DVDD pfet_06v0 ad=35.511p pd=48.245u as=35.511p ps=48.245u w=46.725u l=1u
X13596 BAT GATE DVDD DVDD pfet_06v0 ad=35.511p pd=48.245u as=43.9215p ps=95.32999u w=46.725u l=1u
X13597 DVDD GATE BAT DVDD pfet_06v0 ad=35.511p pd=48.245u as=35.511p ps=48.245u w=46.725u l=1u
X13598 DVDD GATE BAT DVDD pfet_06v0 ad=71.8771p pd=0.15481m as=58.1134p ps=77.985u w=76.465u l=1u
X13599 BAT GATE DVDD DVDD pfet_06v0 ad=58.1134p pd=77.985u as=58.1134p ps=77.985u w=76.465u l=1u
X13600 BAT GATE DVDD DVDD pfet_06v0 ad=35.511p pd=48.245u as=35.511p ps=48.245u w=46.725u l=1u
X13601 BAT GATE DVDD DVDD pfet_06v0 ad=58.1134p pd=77.985u as=58.1134p ps=77.985u w=76.465u l=1u
X13602 BAT GATE DVDD DVDD pfet_06v0 ad=35.511p pd=48.245u as=43.9215p ps=95.32999u w=46.725u l=1u
X13603 DVDD GATE BAT DVDD pfet_06v0 ad=35.511p pd=48.245u as=35.511p ps=48.245u w=46.725u l=1u
X13604 BAT GATE DVDD DVDD pfet_06v0 ad=58.1134p pd=77.985u as=58.1134p ps=77.985u w=76.465u l=1u
X13605 DVDD GATE BAT DVDD pfet_06v0 ad=71.8818p pd=0.15482m as=58.1172p ps=77.99u w=76.47u l=1u
X13606 BAT GATE DVDD DVDD pfet_06v0 ad=58.1096p pd=77.98u as=58.1096p ps=77.98u w=76.46u l=1u
X13607 BAT GATE DVDD DVDD pfet_06v0 ad=58.0754p pd=77.935u as=71.8301p ps=0.15471m w=76.41499u l=1u
X13608 BAT GATE DVDD DVDD pfet_06v0 ad=35.511p pd=48.245u as=35.511p ps=48.245u w=46.725u l=1u
X13609 DVDD GATE BAT DVDD pfet_06v0 ad=58.1134p pd=77.985u as=58.1134p ps=77.985u w=76.465u l=1u
X13610 DVDD GATE BAT DVDD pfet_06v0 ad=35.511p pd=48.245u as=35.511p ps=48.245u w=46.725u l=1u
X13611 BAT GATE DVDD DVDD pfet_06v0 ad=58.1134p pd=77.985u as=58.1134p ps=77.985u w=76.465u l=1u
X13612 DVDD GATE BAT DVDD pfet_06v0 ad=71.8771p pd=0.15481m as=58.1134p ps=77.985u w=76.465u l=1u
X13613 DVDD GATE BAT DVDD pfet_06v0 ad=35.511p pd=48.245u as=35.511p ps=48.245u w=46.725u l=1u
X13614 BAT GATE DVDD DVDD pfet_06v0 ad=35.5072p pd=48.24u as=35.5072p ps=48.24u w=46.72u l=1u
X13615 DVDD GATE BAT DVDD pfet_06v0 ad=71.8771p pd=0.15481m as=58.1134p ps=77.985u w=76.465u l=1u
X13616 BAT GATE DVDD DVDD pfet_06v0 ad=49.3848p pd=66.5u as=49.3848p ps=66.5u w=64.98u l=1u
X13617 DVDD GATE BAT DVDD pfet_06v0 ad=58.1134p pd=77.985u as=58.1134p ps=77.985u w=76.465u l=1u
X13618 DVDD GATE BAT DVDD pfet_06v0 ad=43.9215p pd=95.32999u as=35.511p ps=48.245u w=46.725u l=1u
X13619 DVDD GATE BAT DVDD pfet_06v0 ad=35.511p pd=48.245u as=35.511p ps=48.245u w=46.725u l=1u
X13620 DVDD GATE BAT DVDD pfet_06v0 ad=71.8771p pd=0.15481m as=58.1134p ps=77.985u w=76.465u l=1u
X13621 BAT GATE DVDD DVDD pfet_06v0 ad=58.1172p pd=77.99u as=58.1172p ps=77.99u w=76.47u l=1u
X13622 DVDD GATE BAT DVDD pfet_06v0 ad=35.511p pd=48.245u as=35.511p ps=48.245u w=46.725u l=1u
X13623 BAT GATE DVDD DVDD pfet_06v0 ad=35.511p pd=48.245u as=35.511p ps=48.245u w=46.725u l=1u
X13624 BAT GATE DVDD DVDD pfet_06v0 ad=58.1134p pd=77.985u as=58.1134p ps=77.985u w=76.465u l=1u
X13625 DVDD GATE BAT DVDD pfet_06v0 ad=35.511p pd=48.245u as=35.511p ps=48.245u w=46.725u l=1u
X13626 BAT GATE DVDD DVDD pfet_06v0 ad=35.511p pd=48.245u as=35.511p ps=48.245u w=46.725u l=1u
X13627 DVDD GATE BAT DVDD pfet_06v0 ad=58.1134p pd=77.985u as=58.1134p ps=77.985u w=76.465u l=1u
X13628 BAT GATE DVDD DVDD pfet_06v0 ad=58.1134p pd=77.985u as=71.8771p ps=0.15481m w=76.465u l=1u
X13629 BAT GATE DVDD DVDD pfet_06v0 ad=58.1134p pd=77.985u as=71.8771p ps=0.15481m w=76.465u l=1u
X13630 BAT GATE DVDD DVDD pfet_06v0 ad=58.1552p pd=78.04u as=58.1552p ps=78.04u w=76.52u l=1u
X13631 BAT GATE DVDD DVDD pfet_06v0 ad=58.0754p pd=77.935u as=58.0754p ps=77.935u w=76.41499u l=1u
X13632 DVDD GATE BAT DVDD pfet_06v0 ad=35.511p pd=48.245u as=35.511p ps=48.245u w=46.725u l=1u
X13633 DVDD GATE BAT DVDD pfet_06v0 ad=35.511p pd=48.245u as=35.511p ps=48.245u w=46.725u l=1u
X13634 DVDD GATE BAT DVDD pfet_06v0 ad=35.511p pd=48.245u as=35.511p ps=48.245u w=46.725u l=1u
X13635 BAT GATE DVDD DVDD pfet_06v0 ad=35.511p pd=48.245u as=43.9215p ps=95.32999u w=46.725u l=1u
X13636 BAT GATE DVDD DVDD pfet_06v0 ad=58.1134p pd=77.985u as=58.1134p ps=77.985u w=76.465u l=1u
X13637 DVDD GATE BAT DVDD pfet_06v0 ad=35.511p pd=48.245u as=35.511p ps=48.245u w=46.725u l=1u
X13638 BAT GATE DVDD DVDD pfet_06v0 ad=35.511p pd=48.245u as=35.511p ps=48.245u w=46.725u l=1u
X13639 DVDD GATE BAT DVDD pfet_06v0 ad=58.1134p pd=77.985u as=58.1134p ps=77.985u w=76.465u l=1u
X13640 BAT GATE DVDD DVDD pfet_06v0 ad=35.511p pd=48.245u as=43.9215p ps=95.32999u w=46.725u l=1u
X13641 DVDD GATE BAT DVDD pfet_06v0 ad=71.8301p pd=0.15471m as=58.0754p ps=77.935u w=76.41499u l=1u
X13642 DVDD GATE BAT DVDD pfet_06v0 ad=35.511p pd=48.245u as=35.511p ps=48.245u w=46.725u l=1u
X13643 BAT GATE DVDD DVDD pfet_06v0 ad=58.1134p pd=77.985u as=71.8771p ps=0.15481m w=76.465u l=1u
X13644 DVDD GATE BAT DVDD pfet_06v0 ad=35.511p pd=48.245u as=35.511p ps=48.245u w=46.725u l=1u
X13645 DVDD GATE BAT DVDD pfet_06v0 ad=58.1134p pd=77.985u as=58.1134p ps=77.985u w=76.465u l=1u
X13646 BAT GATE DVDD DVDD pfet_06v0 ad=35.5072p pd=48.24u as=35.5072p ps=48.24u w=46.72u l=1u
X13647 BAT GATE DVDD DVDD pfet_06v0 ad=35.511p pd=48.245u as=35.511p ps=48.245u w=46.725u l=1u
X13648 DVDD GATE BAT DVDD pfet_06v0 ad=58.1134p pd=77.985u as=58.1134p ps=77.985u w=76.465u l=1u
X13649 DVDD GATE BAT DVDD pfet_06v0 ad=35.511p pd=48.245u as=35.511p ps=48.245u w=46.725u l=1u
X13650 BAT GATE DVDD DVDD pfet_06v0 ad=35.511p pd=48.245u as=35.511p ps=48.245u w=46.725u l=1u
X13651 BAT GATE DVDD DVDD pfet_06v0 ad=58.1134p pd=77.985u as=58.1134p ps=77.985u w=76.465u l=1u
X13652 DVDD GATE BAT DVDD pfet_06v0 ad=35.511p pd=48.245u as=35.511p ps=48.245u w=46.725u l=1u
X13653 DVDD GATE BAT DVDD pfet_06v0 ad=43.9215p pd=95.32999u as=35.511p ps=48.245u w=46.725u l=1u
X13654 DVDD GATE BAT DVDD pfet_06v0 ad=58.1134p pd=77.985u as=58.1134p ps=77.985u w=76.465u l=1u
X13655 BAT GATE DVDD DVDD pfet_06v0 ad=58.1096p pd=77.98u as=58.1096p ps=77.98u w=76.46u l=1u
X13656 BAT GATE DVDD DVDD pfet_06v0 ad=58.1134p pd=77.985u as=71.8771p ps=0.15481m w=76.465u l=1u
X13657 DVDD GATE BAT DVDD pfet_06v0 ad=47.6862p pd=64.265u as=47.6862p ps=64.265u w=62.745u l=1u
X13658 BAT GATE DVDD DVDD pfet_06v0 ad=49.3848p pd=66.5u as=49.3848p ps=66.5u w=64.98u l=1u
X13659 BAT GATE DVDD DVDD pfet_06v0 ad=35.511p pd=48.245u as=35.511p ps=48.245u w=46.725u l=1u
X13660 DVDD GATE BAT DVDD pfet_06v0 ad=58.1134p pd=77.985u as=58.1134p ps=77.985u w=76.465u l=1u
X13661 DVDD GATE BAT DVDD pfet_06v0 ad=47.6862p pd=64.265u as=47.6862p ps=64.265u w=62.745u l=1u
X13662 DVDD GATE BAT DVDD pfet_06v0 ad=58.1134p pd=77.985u as=58.1134p ps=77.985u w=76.465u l=1u
X13663 DVDD GATE BAT DVDD pfet_06v0 ad=58.1134p pd=77.985u as=58.1134p ps=77.985u w=76.465u l=1u
X13664 BAT GATE DVDD DVDD pfet_06v0 ad=35.511p pd=48.245u as=35.511p ps=48.245u w=46.725u l=1u
X13665 DVDD GATE BAT DVDD pfet_06v0 ad=35.511p pd=48.245u as=35.511p ps=48.245u w=46.725u l=1u
X13666 DVDD GATE BAT DVDD pfet_06v0 ad=43.9215p pd=95.32999u as=35.511p ps=48.245u w=46.725u l=1u
X13667 BAT GATE DVDD DVDD pfet_06v0 ad=35.5072p pd=48.24u as=35.5072p ps=48.24u w=46.72u l=1u
X13668 DVDD GATE BAT DVDD pfet_06v0 ad=35.511p pd=48.245u as=35.511p ps=48.245u w=46.725u l=1u
X13669 BAT GATE DVDD DVDD pfet_06v0 ad=58.1172p pd=77.99u as=71.8818p ps=0.15482m w=76.47u l=1u
X13670 BAT GATE DVDD DVDD pfet_06v0 ad=58.1096p pd=77.98u as=71.8724p ps=0.1548m w=76.46u l=1u
X13671 DVDD GATE BAT DVDD pfet_06v0 ad=58.1134p pd=77.985u as=58.1134p ps=77.985u w=76.465u l=1u
X13672 BAT GATE DVDD DVDD pfet_06v0 ad=35.511p pd=48.245u as=35.511p ps=48.245u w=46.725u l=1u
X13673 BAT GATE DVDD DVDD pfet_06v0 ad=58.1134p pd=77.985u as=71.8771p ps=0.15481m w=76.465u l=1u
X13674 BAT GATE DVDD DVDD pfet_06v0 ad=49.3848p pd=66.5u as=49.3848p ps=66.5u w=64.98u l=1u
X13675 DVDD GATE BAT DVDD pfet_06v0 ad=58.0754p pd=77.935u as=58.0754p ps=77.935u w=76.41499u l=1u
X13676 BAT GATE DVDD DVDD pfet_06v0 ad=35.511p pd=48.245u as=35.511p ps=48.245u w=46.725u l=1u
X13677 DVDD GATE BAT DVDD pfet_06v0 ad=58.1096p pd=77.98u as=58.1096p ps=77.98u w=76.46u l=1u
X13678 BAT GATE DVDD DVDD pfet_06v0 ad=58.1552p pd=78.04u as=58.1552p ps=78.04u w=76.52u l=1u
X13679 DVDD GATE BAT DVDD pfet_06v0 ad=35.5072p pd=48.24u as=35.5072p ps=48.24u w=46.72u l=1u
X13680 DVDD GATE BAT DVDD pfet_06v0 ad=58.1134p pd=77.985u as=58.1134p ps=77.985u w=76.465u l=1u
X13681 DVDD GATE BAT DVDD pfet_06v0 ad=71.8771p pd=0.15481m as=58.1134p ps=77.985u w=76.465u l=1u
X13682 DVDD GATE BAT DVDD pfet_06v0 ad=43.9168p pd=95.32u as=35.5072p ps=48.24u w=46.72u l=1u
X13683 BAT GATE DVDD DVDD pfet_06v0 ad=35.511p pd=48.245u as=35.511p ps=48.245u w=46.725u l=1u
X13684 BAT GATE DVDD DVDD pfet_06v0 ad=35.511p pd=48.245u as=35.511p ps=48.245u w=46.725u l=1u
X13685 BAT GATE DVDD DVDD pfet_06v0 ad=58.0754p pd=77.935u as=58.0754p ps=77.935u w=76.41499u l=1u
X13686 DVDD GATE BAT DVDD pfet_06v0 ad=58.1552p pd=78.04u as=58.1552p ps=78.04u w=76.52u l=1u
X13687 BAT GATE DVDD DVDD pfet_06v0 ad=35.511p pd=48.245u as=35.511p ps=48.245u w=46.725u l=1u
X13688 DVDD GATE BAT DVDD pfet_06v0 ad=35.511p pd=48.245u as=35.511p ps=48.245u w=46.725u l=1u
X13689 BAT GATE DVDD DVDD pfet_06v0 ad=58.1134p pd=77.985u as=58.1134p ps=77.985u w=76.465u l=1u
X13690 DVDD GATE BAT DVDD pfet_06v0 ad=58.0754p pd=77.935u as=58.0754p ps=77.935u w=76.41499u l=1u
X13691 DVDD GATE BAT DVDD pfet_06v0 ad=43.9215p pd=95.32999u as=35.511p ps=48.245u w=46.725u l=1u
X13692 DVDD GATE BAT DVDD pfet_06v0 ad=35.511p pd=48.245u as=35.511p ps=48.245u w=46.725u l=1u
X13693 BAT GATE DVDD DVDD pfet_06v0 ad=35.511p pd=48.245u as=35.511p ps=48.245u w=46.725u l=1u
X13694 DVDD GATE BAT DVDD pfet_06v0 ad=43.9215p pd=95.32999u as=35.511p ps=48.245u w=46.725u l=1u
X13695 DVDD GATE BAT DVDD pfet_06v0 ad=58.1134p pd=77.985u as=58.1134p ps=77.985u w=76.465u l=1u
X13696 DVDD GATE BAT DVDD pfet_06v0 ad=58.1134p pd=77.985u as=58.1134p ps=77.985u w=76.465u l=1u
X13697 DVDD GATE BAT DVDD pfet_06v0 ad=58.1172p pd=77.99u as=58.1172p ps=77.99u w=76.47u l=1u
X13698 DVDD GATE BAT DVDD pfet_06v0 ad=43.9215p pd=95.32999u as=35.511p ps=48.245u w=46.725u l=1u
X13699 DVDD GATE BAT DVDD pfet_06v0 ad=71.8301p pd=0.15471m as=58.0754p ps=77.935u w=76.41499u l=1u
X13700 DVDD GATE BAT DVDD pfet_06v0 ad=35.511p pd=48.245u as=35.511p ps=48.245u w=46.725u l=1u
X13701 BAT GATE DVDD DVDD pfet_06v0 ad=58.1172p pd=77.99u as=71.8818p ps=0.15482m w=76.47u l=1u
X13702 DVDD GATE BAT DVDD pfet_06v0 ad=35.511p pd=48.245u as=35.511p ps=48.245u w=46.725u l=1u
X13703 BAT GATE DVDD DVDD pfet_06v0 ad=35.511p pd=48.245u as=35.511p ps=48.245u w=46.725u l=1u
X13704 BAT GATE DVDD DVDD pfet_06v0 ad=58.0754p pd=77.935u as=58.0754p ps=77.935u w=76.41499u l=1u
X13705 DVDD GATE BAT DVDD pfet_06v0 ad=71.8771p pd=0.15481m as=58.1134p ps=77.985u w=76.465u l=1u
X13706 DVDD GATE BAT DVDD pfet_06v0 ad=35.511p pd=48.245u as=35.511p ps=48.245u w=46.725u l=1u
X13707 DVDD GATE BAT DVDD pfet_06v0 ad=47.6862p pd=64.265u as=47.6862p ps=64.265u w=62.745u l=1u
X13708 DVDD GATE BAT DVDD pfet_06v0 ad=58.1096p pd=77.98u as=58.1096p ps=77.98u w=76.46u l=1u
X13709 DVDD GATE BAT DVDD pfet_06v0 ad=35.511p pd=48.245u as=35.511p ps=48.245u w=46.725u l=1u
X13710 BAT GATE DVDD DVDD pfet_06v0 ad=58.1134p pd=77.985u as=58.1134p ps=77.985u w=76.465u l=1u
X13711 BAT GATE DVDD DVDD pfet_06v0 ad=35.511p pd=48.245u as=43.9215p ps=95.32999u w=46.725u l=1u
X13712 BAT GATE DVDD DVDD pfet_06v0 ad=35.511p pd=48.245u as=35.511p ps=48.245u w=46.725u l=1u
X13713 DVDD GATE BAT DVDD pfet_06v0 ad=58.1172p pd=77.99u as=58.1172p ps=77.99u w=76.47u l=1u
X13714 DVDD GATE BAT DVDD pfet_06v0 ad=58.1096p pd=77.98u as=58.1096p ps=77.98u w=76.46u l=1u
X13715 DVDD GATE BAT DVDD pfet_06v0 ad=35.511p pd=48.245u as=35.511p ps=48.245u w=46.725u l=1u
X13716 DVDD GATE BAT DVDD pfet_06v0 ad=35.511p pd=48.245u as=35.511p ps=48.245u w=46.725u l=1u
X13717 BAT GATE DVDD DVDD pfet_06v0 ad=58.1134p pd=77.985u as=58.1134p ps=77.985u w=76.465u l=1u
X13718 BAT GATE DVDD DVDD pfet_06v0 ad=58.1134p pd=77.985u as=58.1134p ps=77.985u w=76.465u l=1u
X13719 BAT GATE DVDD DVDD pfet_06v0 ad=58.1552p pd=78.04u as=58.1552p ps=78.04u w=76.52u l=1u
X13720 BAT GATE DVDD DVDD pfet_06v0 ad=35.511p pd=48.245u as=35.511p ps=48.245u w=46.725u l=1u
X13721 DVDD GATE BAT DVDD pfet_06v0 ad=71.8771p pd=0.15481m as=58.1134p ps=77.985u w=76.465u l=1u
X13722 BAT GATE DVDD DVDD pfet_06v0 ad=35.511p pd=48.245u as=35.511p ps=48.245u w=46.725u l=1u
X13723 DVDD GATE BAT DVDD pfet_06v0 ad=49.3848p pd=66.5u as=49.3848p ps=66.5u w=64.98u l=1u
X13724 BAT GATE DVDD DVDD pfet_06v0 ad=58.1134p pd=77.985u as=58.1134p ps=77.985u w=76.465u l=1u
X13725 BAT GATE DVDD DVDD pfet_06v0 ad=58.1134p pd=77.985u as=58.1134p ps=77.985u w=76.465u l=1u
X13726 DVDD GATE BAT DVDD pfet_06v0 ad=49.3848p pd=66.5u as=49.3848p ps=66.5u w=64.98u l=1u
X13727 DVDD GATE BAT DVDD pfet_06v0 ad=35.511p pd=48.245u as=35.511p ps=48.245u w=46.725u l=1u
X13728 BAT GATE DVDD DVDD pfet_06v0 ad=58.1134p pd=77.985u as=58.1134p ps=77.985u w=76.465u l=1u
X13729 BAT GATE DVDD DVDD pfet_06v0 ad=35.511p pd=48.245u as=35.511p ps=48.245u w=46.725u l=1u
X13730 DVDD GATE BAT DVDD pfet_06v0 ad=58.1134p pd=77.985u as=58.1134p ps=77.985u w=76.465u l=1u
X13731 DVDD GATE BAT DVDD pfet_06v0 ad=35.511p pd=48.245u as=35.511p ps=48.245u w=46.725u l=1u
X13732 BAT GATE DVDD DVDD pfet_06v0 ad=35.511p pd=48.245u as=43.9215p ps=95.32999u w=46.725u l=1u
X13733 DVDD GATE BAT DVDD pfet_06v0 ad=71.8771p pd=0.15481m as=58.1134p ps=77.985u w=76.465u l=1u
X13734 DVDD GATE BAT DVDD pfet_06v0 ad=58.1134p pd=77.985u as=58.1134p ps=77.985u w=76.465u l=1u
X13735 BAT GATE DVDD DVDD pfet_06v0 ad=58.1552p pd=78.04u as=58.1552p ps=78.04u w=76.52u l=1u
X13736 BAT GATE DVDD DVDD pfet_06v0 ad=58.1134p pd=77.985u as=58.1134p ps=77.985u w=76.465u l=1u
X13737 DVDD GATE BAT DVDD pfet_06v0 ad=43.9215p pd=95.32999u as=35.511p ps=48.245u w=46.725u l=1u
X13738 DVDD GATE BAT DVDD pfet_06v0 ad=58.1134p pd=77.985u as=58.1134p ps=77.985u w=76.465u l=1u
X13739 DVDD GATE BAT DVDD pfet_06v0 ad=43.9215p pd=95.32999u as=35.511p ps=48.245u w=46.725u l=1u
X13740 DVDD GATE BAT DVDD pfet_06v0 ad=35.511p pd=48.245u as=35.511p ps=48.245u w=46.725u l=1u
X13741 BAT GATE DVDD DVDD pfet_06v0 ad=35.511p pd=48.245u as=35.511p ps=48.245u w=46.725u l=1u
X13742 BAT GATE DVDD DVDD pfet_06v0 ad=35.511p pd=48.245u as=35.511p ps=48.245u w=46.725u l=1u
X13743 DVDD GATE BAT DVDD pfet_06v0 ad=58.1134p pd=77.985u as=58.1134p ps=77.985u w=76.465u l=1u
X13744 BAT GATE DVDD DVDD pfet_06v0 ad=35.511p pd=48.245u as=35.511p ps=48.245u w=46.725u l=1u
X13745 BAT GATE DVDD DVDD pfet_06v0 ad=35.511p pd=48.245u as=35.511p ps=48.245u w=46.725u l=1u
X13746 DVDD GATE BAT DVDD pfet_06v0 ad=58.1172p pd=77.99u as=58.1172p ps=77.99u w=76.47u l=1u
X13747 DVDD GATE BAT DVDD pfet_06v0 ad=58.1134p pd=77.985u as=58.1134p ps=77.985u w=76.465u l=1u
X13748 DVDD GATE BAT DVDD pfet_06v0 ad=35.511p pd=48.245u as=35.511p ps=48.245u w=46.725u l=1u
X13749 BAT GATE DVDD DVDD pfet_06v0 ad=58.1134p pd=77.985u as=58.1134p ps=77.985u w=76.465u l=1u
X13750 DVDD GATE BAT DVDD pfet_06v0 ad=58.1134p pd=77.985u as=58.1134p ps=77.985u w=76.465u l=1u
X13751 BAT GATE DVDD DVDD pfet_06v0 ad=35.511p pd=48.245u as=35.511p ps=48.245u w=46.725u l=1u
X13752 BAT GATE DVDD DVDD pfet_06v0 ad=35.511p pd=48.245u as=35.511p ps=48.245u w=46.725u l=1u
X13753 BAT GATE DVDD DVDD pfet_06v0 ad=35.511p pd=48.245u as=35.511p ps=48.245u w=46.725u l=1u
X13754 BAT GATE DVDD DVDD pfet_06v0 ad=35.5072p pd=48.24u as=43.9168p ps=95.32u w=46.72u l=1u
X13755 BAT GATE DVDD DVDD pfet_06v0 ad=58.0754p pd=77.935u as=58.0754p ps=77.935u w=76.41499u l=1u
X13756 BAT GATE DVDD DVDD pfet_06v0 ad=47.6862p pd=64.265u as=47.6862p ps=64.265u w=62.745u l=1u
X13757 DVDD GATE BAT DVDD pfet_06v0 ad=58.1134p pd=77.985u as=58.1134p ps=77.985u w=76.465u l=1u
X13758 DVDD GATE BAT DVDD pfet_06v0 ad=43.9215p pd=95.32999u as=35.511p ps=48.245u w=46.725u l=1u
X13759 DVDD GATE BAT DVDD pfet_06v0 ad=35.511p pd=48.245u as=35.511p ps=48.245u w=46.725u l=1u
X13760 DVDD GATE BAT DVDD pfet_06v0 ad=35.511p pd=48.245u as=35.511p ps=48.245u w=46.725u l=1u
X13761 DVDD GATE BAT DVDD pfet_06v0 ad=58.1552p pd=78.04u as=58.1552p ps=78.04u w=76.52u l=1u
X13762 BAT GATE DVDD DVDD pfet_06v0 ad=58.1134p pd=77.985u as=58.1134p ps=77.985u w=76.465u l=1u
X13763 DVDD GATE BAT DVDD pfet_06v0 ad=35.511p pd=48.245u as=35.511p ps=48.245u w=46.725u l=1u
X13764 DVDD GATE BAT DVDD pfet_06v0 ad=58.1134p pd=77.985u as=58.1134p ps=77.985u w=76.465u l=1u
X13765 DVDD GATE BAT DVDD pfet_06v0 ad=58.0754p pd=77.935u as=58.0754p ps=77.935u w=76.41499u l=1u
X13766 BAT GATE DVDD DVDD pfet_06v0 ad=35.511p pd=48.245u as=35.511p ps=48.245u w=46.725u l=1u
X13767 BAT GATE DVDD DVDD pfet_06v0 ad=58.1134p pd=77.985u as=58.1134p ps=77.985u w=76.465u l=1u
X13768 BAT GATE DVDD DVDD pfet_06v0 ad=35.511p pd=48.245u as=35.511p ps=48.245u w=46.725u l=1u
X13769 DVDD GATE BAT DVDD pfet_06v0 ad=71.8724p pd=0.1548m as=58.1096p ps=77.98u w=76.46u l=1u
X13770 BAT GATE DVDD DVDD pfet_06v0 ad=58.1134p pd=77.985u as=58.1134p ps=77.985u w=76.465u l=1u
X13771 BAT GATE DVDD DVDD pfet_06v0 ad=58.1134p pd=77.985u as=58.1134p ps=77.985u w=76.465u l=1u
X13772 BAT GATE DVDD DVDD pfet_06v0 ad=47.6862p pd=64.265u as=47.6862p ps=64.265u w=62.745u l=1u
X13773 DVDD GATE BAT DVDD pfet_06v0 ad=58.1552p pd=78.04u as=58.1552p ps=78.04u w=76.52u l=1u
X13774 DVDD GATE BAT DVDD pfet_06v0 ad=71.92879p pd=0.15492m as=58.1552p ps=78.04u w=76.52u l=1u
X13775 BAT GATE DVDD DVDD pfet_06v0 ad=58.1134p pd=77.985u as=58.1134p ps=77.985u w=76.465u l=1u
X13776 DVDD GATE BAT DVDD pfet_06v0 ad=43.9215p pd=95.32999u as=35.511p ps=48.245u w=46.725u l=1u
X13777 DVDD GATE BAT DVDD pfet_06v0 ad=71.8301p pd=0.15471m as=58.0754p ps=77.935u w=76.41499u l=1u
X13778 BAT GATE DVDD DVDD pfet_06v0 ad=47.6862p pd=64.265u as=47.6862p ps=64.265u w=62.745u l=1u
X13779 BAT GATE DVDD DVDD pfet_06v0 ad=35.511p pd=48.245u as=35.511p ps=48.245u w=46.725u l=1u
X13780 BAT GATE DVDD DVDD pfet_06v0 ad=35.511p pd=48.245u as=35.511p ps=48.245u w=46.725u l=1u
X13781 BAT GATE DVDD DVDD pfet_06v0 ad=35.511p pd=48.245u as=35.511p ps=48.245u w=46.725u l=1u
X13782 BAT GATE DVDD DVDD pfet_06v0 ad=35.511p pd=48.245u as=35.511p ps=48.245u w=46.725u l=1u
X13783 DVDD GATE BAT DVDD pfet_06v0 ad=58.1172p pd=77.99u as=58.1172p ps=77.99u w=76.47u l=1u
X13784 DVDD GATE BAT DVDD pfet_06v0 ad=58.1172p pd=77.99u as=58.1172p ps=77.99u w=76.47u l=1u
X13785 DVDD GATE BAT DVDD pfet_06v0 ad=43.9168p pd=95.32u as=35.5072p ps=48.24u w=46.72u l=1u
X13786 DVDD GATE BAT DVDD pfet_06v0 ad=43.9215p pd=95.32999u as=35.511p ps=48.245u w=46.725u l=1u
X13787 BAT GATE DVDD DVDD pfet_06v0 ad=35.511p pd=48.245u as=35.511p ps=48.245u w=46.725u l=1u
X13788 BAT GATE DVDD DVDD pfet_06v0 ad=35.511p pd=48.245u as=35.511p ps=48.245u w=46.725u l=1u
X13789 BAT GATE DVDD DVDD pfet_06v0 ad=47.6862p pd=64.265u as=47.6862p ps=64.265u w=62.745u l=1u
X13790 DVDD GATE BAT DVDD pfet_06v0 ad=35.511p pd=48.245u as=35.511p ps=48.245u w=46.725u l=1u
X13791 DVDD GATE BAT DVDD pfet_06v0 ad=71.8771p pd=0.15481m as=58.1134p ps=77.985u w=76.465u l=1u
X13792 BAT GATE DVDD DVDD pfet_06v0 ad=58.0754p pd=77.935u as=58.0754p ps=77.935u w=76.41499u l=1u
X13793 BAT GATE DVDD DVDD pfet_06v0 ad=58.1134p pd=77.985u as=58.1134p ps=77.985u w=76.465u l=1u
X13794 BAT GATE DVDD DVDD pfet_06v0 ad=58.1096p pd=77.98u as=58.1096p ps=77.98u w=76.46u l=1u
X13795 BAT GATE DVDD DVDD pfet_06v0 ad=58.0754p pd=77.935u as=58.0754p ps=77.935u w=76.41499u l=1u
X13796 DVDD GATE BAT DVDD pfet_06v0 ad=35.511p pd=48.245u as=35.511p ps=48.245u w=46.725u l=1u
X13797 BAT GATE DVDD DVDD pfet_06v0 ad=49.3848p pd=66.5u as=49.3848p ps=66.5u w=64.98u l=1u
X13798 BAT GATE DVDD DVDD pfet_06v0 ad=35.511p pd=48.245u as=35.511p ps=48.245u w=46.725u l=1u
X13799 DVDD GATE BAT DVDD pfet_06v0 ad=58.0754p pd=77.935u as=58.0754p ps=77.935u w=76.41499u l=1u
X13800 DVDD GATE BAT DVDD pfet_06v0 ad=58.1134p pd=77.985u as=58.1134p ps=77.985u w=76.465u l=1u
X13801 DVDD GATE BAT DVDD pfet_06v0 ad=58.1134p pd=77.985u as=58.1134p ps=77.985u w=76.465u l=1u
X13802 BAT GATE DVDD DVDD pfet_06v0 ad=35.511p pd=48.245u as=35.511p ps=48.245u w=46.725u l=1u
X13803 BAT GATE DVDD DVDD pfet_06v0 ad=35.511p pd=48.245u as=35.511p ps=48.245u w=46.725u l=1u
X13804 BAT GATE DVDD DVDD pfet_06v0 ad=58.1134p pd=77.985u as=58.1134p ps=77.985u w=76.465u l=1u
X13805 BAT GATE DVDD DVDD pfet_06v0 ad=49.3848p pd=66.5u as=49.3848p ps=66.5u w=64.98u l=1u
X13806 DVDD GATE BAT DVDD pfet_06v0 ad=47.6862p pd=64.265u as=47.6862p ps=64.265u w=62.745u l=1u
X13807 DVDD GATE BAT DVDD pfet_06v0 ad=35.511p pd=48.245u as=35.511p ps=48.245u w=46.725u l=1u
X13808 DVDD GATE BAT DVDD pfet_06v0 ad=43.9215p pd=95.32999u as=35.511p ps=48.245u w=46.725u l=1u
X13809 DVDD GATE BAT DVDD pfet_06v0 ad=71.92879p pd=0.15492m as=58.1552p ps=78.04u w=76.52u l=1u
X13810 BAT GATE DVDD DVDD pfet_06v0 ad=58.1134p pd=77.985u as=58.1134p ps=77.985u w=76.465u l=1u
X13811 BAT GATE DVDD DVDD pfet_06v0 ad=58.1172p pd=77.99u as=58.1172p ps=77.99u w=76.47u l=1u
X13812 BAT GATE DVDD DVDD pfet_06v0 ad=58.0754p pd=77.935u as=58.0754p ps=77.935u w=76.41499u l=1u
X13813 BAT GATE DVDD DVDD pfet_06v0 ad=58.1172p pd=77.99u as=58.1172p ps=77.99u w=76.47u l=1u
X13814 DVDD GATE BAT DVDD pfet_06v0 ad=58.0754p pd=77.935u as=58.0754p ps=77.935u w=76.41499u l=1u
X13815 BAT GATE DVDD DVDD pfet_06v0 ad=35.511p pd=48.245u as=35.511p ps=48.245u w=46.725u l=1u
X13816 BAT GATE DVDD DVDD pfet_06v0 ad=35.511p pd=48.245u as=35.511p ps=48.245u w=46.725u l=1u
X13817 BAT GATE DVDD DVDD pfet_06v0 ad=58.1134p pd=77.985u as=58.1134p ps=77.985u w=76.465u l=1u
X13818 BAT GATE DVDD DVDD pfet_06v0 ad=58.1096p pd=77.98u as=58.1096p ps=77.98u w=76.46u l=1u
X13819 DVDD GATE BAT DVDD pfet_06v0 ad=58.1134p pd=77.985u as=58.1134p ps=77.985u w=76.465u l=1u
X13820 DVDD GATE BAT DVDD pfet_06v0 ad=58.1172p pd=77.99u as=58.1172p ps=77.99u w=76.47u l=1u
X13821 DVDD GATE BAT DVDD pfet_06v0 ad=43.9215p pd=95.32999u as=35.511p ps=48.245u w=46.725u l=1u
X13822 DVDD GATE BAT DVDD pfet_06v0 ad=58.1134p pd=77.985u as=58.1134p ps=77.985u w=76.465u l=1u
X13823 DVDD GATE BAT DVDD pfet_06v0 ad=35.5072p pd=48.24u as=35.5072p ps=48.24u w=46.72u l=1u
X13824 DVDD GATE BAT DVDD pfet_06v0 ad=71.8771p pd=0.15481m as=58.1134p ps=77.985u w=76.465u l=1u
X13825 DVDD GATE BAT DVDD pfet_06v0 ad=35.511p pd=48.245u as=35.511p ps=48.245u w=46.725u l=1u
X13826 BAT GATE DVDD DVDD pfet_06v0 ad=35.511p pd=48.245u as=35.511p ps=48.245u w=46.725u l=1u
X13827 BAT GATE DVDD DVDD pfet_06v0 ad=35.511p pd=48.245u as=43.9215p ps=95.32999u w=46.725u l=1u
X13828 BAT GATE DVDD DVDD pfet_06v0 ad=58.1134p pd=77.985u as=71.8771p ps=0.15481m w=76.465u l=1u
X13829 BAT GATE DVDD DVDD pfet_06v0 ad=35.511p pd=48.245u as=35.511p ps=48.245u w=46.725u l=1u
X13830 BAT GATE DVDD DVDD pfet_06v0 ad=58.1134p pd=77.985u as=58.1134p ps=77.985u w=76.465u l=1u
X13831 BAT GATE DVDD DVDD pfet_06v0 ad=49.3848p pd=66.5u as=49.3848p ps=66.5u w=64.98u l=1u
X13832 DVDD GATE BAT DVDD pfet_06v0 ad=43.9215p pd=95.32999u as=35.511p ps=48.245u w=46.725u l=1u
X13833 DVDD GATE BAT DVDD pfet_06v0 ad=58.1134p pd=77.985u as=58.1134p ps=77.985u w=76.465u l=1u
X13834 BAT GATE DVDD DVDD pfet_06v0 ad=58.1134p pd=77.985u as=58.1134p ps=77.985u w=76.465u l=1u
X13835 DVDD GATE BAT DVDD pfet_06v0 ad=58.1134p pd=77.985u as=58.1134p ps=77.985u w=76.465u l=1u
X13836 DVDD GATE BAT DVDD pfet_06v0 ad=58.1134p pd=77.985u as=58.1134p ps=77.985u w=76.465u l=1u
X13837 BAT GATE DVDD DVDD pfet_06v0 ad=35.511p pd=48.245u as=35.511p ps=48.245u w=46.725u l=1u
X13838 DVDD GATE BAT DVDD pfet_06v0 ad=58.1134p pd=77.985u as=58.1134p ps=77.985u w=76.465u l=1u
X13839 DVDD GATE BAT DVDD pfet_06v0 ad=58.1134p pd=77.985u as=58.1134p ps=77.985u w=76.465u l=1u
X13840 BAT GATE DVDD DVDD pfet_06v0 ad=58.1134p pd=77.985u as=71.8771p ps=0.15481m w=76.465u l=1u
X13841 DVDD GATE BAT DVDD pfet_06v0 ad=58.1552p pd=78.04u as=58.1552p ps=78.04u w=76.52u l=1u
X13842 DVDD GATE BAT DVDD pfet_06v0 ad=35.511p pd=48.245u as=35.511p ps=48.245u w=46.725u l=1u
X13843 BAT GATE DVDD DVDD pfet_06v0 ad=35.511p pd=48.245u as=35.511p ps=48.245u w=46.725u l=1u
X13844 BAT GATE DVDD DVDD pfet_06v0 ad=58.1552p pd=78.04u as=58.1552p ps=78.04u w=76.52u l=1u
X13845 DVDD GATE BAT DVDD pfet_06v0 ad=71.8771p pd=0.15481m as=58.1134p ps=77.985u w=76.465u l=1u
X13846 DVDD GATE BAT DVDD pfet_06v0 ad=35.511p pd=48.245u as=35.511p ps=48.245u w=46.725u l=1u
X13847 BAT GATE DVDD DVDD pfet_06v0 ad=35.511p pd=48.245u as=43.9215p ps=95.32999u w=46.725u l=1u
X13848 DVDD GATE BAT DVDD pfet_06v0 ad=35.511p pd=48.245u as=35.511p ps=48.245u w=46.725u l=1u
X13849 DVDD GATE BAT DVDD pfet_06v0 ad=58.1134p pd=77.985u as=58.1134p ps=77.985u w=76.465u l=1u
X13850 BAT GATE DVDD DVDD pfet_06v0 ad=58.1134p pd=77.985u as=58.1134p ps=77.985u w=76.465u l=1u
X13851 DVDD GATE BAT DVDD pfet_06v0 ad=35.511p pd=48.245u as=35.511p ps=48.245u w=46.725u l=1u
X13852 BAT GATE DVDD DVDD pfet_06v0 ad=58.1134p pd=77.985u as=58.1134p ps=77.985u w=76.465u l=1u
X13853 BAT GATE DVDD DVDD pfet_06v0 ad=58.1134p pd=77.985u as=58.1134p ps=77.985u w=76.465u l=1u
X13854 DVDD GATE BAT DVDD pfet_06v0 ad=35.511p pd=48.245u as=35.511p ps=48.245u w=46.725u l=1u
X13855 DVDD GATE BAT DVDD pfet_06v0 ad=58.1134p pd=77.985u as=58.1134p ps=77.985u w=76.465u l=1u
X13856 BAT GATE DVDD DVDD pfet_06v0 ad=58.1172p pd=77.99u as=58.1172p ps=77.99u w=76.47u l=1u
X13857 BAT GATE DVDD DVDD pfet_06v0 ad=58.1096p pd=77.98u as=58.1096p ps=77.98u w=76.46u l=1u
X13858 BAT GATE DVDD DVDD pfet_06v0 ad=35.511p pd=48.245u as=35.511p ps=48.245u w=46.725u l=1u
X13859 BAT GATE DVDD DVDD pfet_06v0 ad=35.511p pd=48.245u as=35.511p ps=48.245u w=46.725u l=1u
X13860 BAT GATE DVDD DVDD pfet_06v0 ad=35.511p pd=48.245u as=35.511p ps=48.245u w=46.725u l=1u
X13861 BAT GATE DVDD DVDD pfet_06v0 ad=35.511p pd=48.245u as=35.511p ps=48.245u w=46.725u l=1u
X13862 BAT GATE DVDD DVDD pfet_06v0 ad=58.1134p pd=77.985u as=58.1134p ps=77.985u w=76.465u l=1u
X13863 DVDD GATE BAT DVDD pfet_06v0 ad=58.1134p pd=77.985u as=58.1134p ps=77.985u w=76.465u l=1u
X13864 BAT GATE DVDD DVDD pfet_06v0 ad=58.1134p pd=77.985u as=58.1134p ps=77.985u w=76.465u l=1u
X13865 DVDD GATE BAT DVDD pfet_06v0 ad=35.511p pd=48.245u as=35.511p ps=48.245u w=46.725u l=1u
X13866 DVDD GATE BAT DVDD pfet_06v0 ad=61.0812p pd=0.13184m as=49.3848p ps=66.5u w=64.98u l=1u
X13867 BAT GATE DVDD DVDD pfet_06v0 ad=58.1134p pd=77.985u as=58.1134p ps=77.985u w=76.465u l=1u
X13868 DVDD GATE BAT DVDD pfet_06v0 ad=58.0754p pd=77.935u as=58.0754p ps=77.935u w=76.41499u l=1u
X13869 BAT GATE DVDD DVDD pfet_06v0 ad=35.511p pd=48.245u as=35.511p ps=48.245u w=46.725u l=1u
X13870 BAT GATE DVDD DVDD pfet_06v0 ad=35.511p pd=48.245u as=35.511p ps=48.245u w=46.725u l=1u
X13871 BAT GATE DVDD DVDD pfet_06v0 ad=35.511p pd=48.245u as=35.511p ps=48.245u w=46.725u l=1u
X13872 BAT GATE DVDD DVDD pfet_06v0 ad=58.0754p pd=77.935u as=58.0754p ps=77.935u w=76.41499u l=1u
X13873 BAT GATE DVDD DVDD pfet_06v0 ad=58.1134p pd=77.985u as=58.1134p ps=77.985u w=76.465u l=1u
X13874 BAT GATE DVDD DVDD pfet_06v0 ad=49.3848p pd=66.5u as=61.0812p ps=0.13184m w=64.98u l=1u
X13875 BAT GATE DVDD DVDD pfet_06v0 ad=58.1096p pd=77.98u as=58.1096p ps=77.98u w=76.46u l=1u
X13876 BAT GATE DVDD DVDD pfet_06v0 ad=35.511p pd=48.245u as=35.511p ps=48.245u w=46.725u l=1u
X13877 BAT GATE DVDD DVDD pfet_06v0 ad=58.1134p pd=77.985u as=58.1134p ps=77.985u w=76.465u l=1u
X13878 DVDD GATE BAT DVDD pfet_06v0 ad=47.6862p pd=64.265u as=47.6862p ps=64.265u w=62.745u l=1u
X13879 DVDD GATE BAT DVDD pfet_06v0 ad=71.8771p pd=0.15481m as=58.1134p ps=77.985u w=76.465u l=1u
X13880 DVDD GATE BAT DVDD pfet_06v0 ad=43.9215p pd=95.32999u as=35.511p ps=48.245u w=46.725u l=1u
X13881 BAT GATE DVDD DVDD pfet_06v0 ad=58.1134p pd=77.985u as=71.8771p ps=0.15481m w=76.465u l=1u
X13882 BAT GATE DVDD DVDD pfet_06v0 ad=58.1172p pd=77.99u as=58.1172p ps=77.99u w=76.47u l=1u
X13883 BAT GATE DVDD DVDD pfet_06v0 ad=35.5072p pd=48.24u as=35.5072p ps=48.24u w=46.72u l=1u
X13884 DVDD GATE BAT DVDD pfet_06v0 ad=58.1134p pd=77.985u as=58.1134p ps=77.985u w=76.465u l=1u
X13885 DVDD GATE BAT DVDD pfet_06v0 ad=35.511p pd=48.245u as=35.511p ps=48.245u w=46.725u l=1u
X13886 DVDD GATE BAT DVDD pfet_06v0 ad=35.511p pd=48.245u as=35.511p ps=48.245u w=46.725u l=1u
X13887 BAT GATE DVDD DVDD pfet_06v0 ad=58.1134p pd=77.985u as=58.1134p ps=77.985u w=76.465u l=1u
X13888 BAT GATE DVDD DVDD pfet_06v0 ad=35.511p pd=48.245u as=35.511p ps=48.245u w=46.725u l=1u
X13889 DVDD GATE BAT DVDD pfet_06v0 ad=58.1096p pd=77.98u as=58.1096p ps=77.98u w=76.46u l=1u
X13890 DVDD GATE BAT DVDD pfet_06v0 ad=47.6862p pd=64.265u as=47.6862p ps=64.265u w=62.745u l=1u
X13891 DVDD GATE BAT DVDD pfet_06v0 ad=71.8724p pd=0.1548m as=58.1096p ps=77.98u w=76.46u l=1u
X13892 DVDD GATE BAT DVDD pfet_06v0 ad=58.1096p pd=77.98u as=58.1096p ps=77.98u w=76.46u l=1u
X13893 BAT GATE DVDD DVDD pfet_06v0 ad=47.6862p pd=64.265u as=58.9803p ps=0.12737m w=62.745u l=1u
X13894 DVDD GATE BAT DVDD pfet_06v0 ad=35.511p pd=48.245u as=35.511p ps=48.245u w=46.725u l=1u
X13895 DVDD GATE BAT DVDD pfet_06v0 ad=71.8771p pd=0.15481m as=58.1134p ps=77.985u w=76.465u l=1u
X13896 DVDD GATE BAT DVDD pfet_06v0 ad=43.9215p pd=95.32999u as=35.511p ps=48.245u w=46.725u l=1u
X13897 DVDD GATE BAT DVDD pfet_06v0 ad=49.3848p pd=66.5u as=49.3848p ps=66.5u w=64.98u l=1u
X13898 DVDD GATE BAT DVDD pfet_06v0 ad=35.5072p pd=48.24u as=35.5072p ps=48.24u w=46.72u l=1u
X13899 DVDD GATE BAT DVDD pfet_06v0 ad=58.1172p pd=77.99u as=58.1172p ps=77.99u w=76.47u l=1u
X13900 DVDD GATE BAT DVDD pfet_06v0 ad=35.511p pd=48.245u as=35.511p ps=48.245u w=46.725u l=1u
X13901 BAT GATE DVDD DVDD pfet_06v0 ad=58.1134p pd=77.985u as=58.1134p ps=77.985u w=76.465u l=1u
X13902 BAT GATE DVDD DVDD pfet_06v0 ad=47.6862p pd=64.265u as=47.6862p ps=64.265u w=62.745u l=1u
X13903 BAT GATE DVDD DVDD pfet_06v0 ad=58.1134p pd=77.985u as=71.8771p ps=0.15481m w=76.465u l=1u
X13904 BAT GATE DVDD DVDD pfet_06v0 ad=58.1552p pd=78.04u as=58.1552p ps=78.04u w=76.52u l=1u
X13905 BAT GATE DVDD DVDD pfet_06v0 ad=35.511p pd=48.245u as=35.511p ps=48.245u w=46.725u l=1u
X13906 BAT GATE DVDD DVDD pfet_06v0 ad=35.511p pd=48.245u as=35.511p ps=48.245u w=46.725u l=1u
X13907 DVDD GATE BAT DVDD pfet_06v0 ad=58.1552p pd=78.04u as=58.1552p ps=78.04u w=76.52u l=1u
X13908 BAT GATE DVDD DVDD pfet_06v0 ad=35.511p pd=48.245u as=35.511p ps=48.245u w=46.725u l=1u
X13909 DVDD GATE BAT DVDD pfet_06v0 ad=35.511p pd=48.245u as=35.511p ps=48.245u w=46.725u l=1u
X13910 DVDD GATE BAT DVDD pfet_06v0 ad=58.1172p pd=77.99u as=58.1172p ps=77.99u w=76.47u l=1u
X13911 BAT GATE DVDD DVDD pfet_06v0 ad=58.1134p pd=77.985u as=58.1134p ps=77.985u w=76.465u l=1u
X13912 BAT GATE DVDD DVDD pfet_06v0 ad=58.1134p pd=77.985u as=58.1134p ps=77.985u w=76.465u l=1u
X13913 BAT GATE DVDD DVDD pfet_06v0 ad=35.5072p pd=48.24u as=35.5072p ps=48.24u w=46.72u l=1u
X13914 DVDD GATE BAT DVDD pfet_06v0 ad=35.511p pd=48.245u as=35.511p ps=48.245u w=46.725u l=1u
X13915 BAT GATE DVDD DVDD pfet_06v0 ad=58.1134p pd=77.985u as=58.1134p ps=77.985u w=76.465u l=1u
X13916 DVDD GATE BAT DVDD pfet_06v0 ad=35.511p pd=48.245u as=35.511p ps=48.245u w=46.725u l=1u
X13917 BAT GATE DVDD DVDD pfet_06v0 ad=58.1134p pd=77.985u as=58.1134p ps=77.985u w=76.465u l=1u
X13918 BAT GATE DVDD DVDD pfet_06v0 ad=58.1172p pd=77.99u as=58.1172p ps=77.99u w=76.47u l=1u
X13919 BAT GATE DVDD DVDD pfet_06v0 ad=58.0754p pd=77.935u as=71.8301p ps=0.15471m w=76.41499u l=1u
X13920 DVDD GATE BAT DVDD pfet_06v0 ad=58.1134p pd=77.985u as=58.1134p ps=77.985u w=76.465u l=1u
X13921 DVDD GATE BAT DVDD pfet_06v0 ad=58.1134p pd=77.985u as=58.1134p ps=77.985u w=76.465u l=1u
X13922 BAT GATE DVDD DVDD pfet_06v0 ad=35.511p pd=48.245u as=35.511p ps=48.245u w=46.725u l=1u
X13923 DVDD GATE BAT DVDD pfet_06v0 ad=43.9215p pd=95.32999u as=35.511p ps=48.245u w=46.725u l=1u
X13924 DVDD GATE BAT DVDD pfet_06v0 ad=35.511p pd=48.245u as=35.511p ps=48.245u w=46.725u l=1u
X13925 BAT GATE DVDD DVDD pfet_06v0 ad=35.511p pd=48.245u as=43.9215p ps=95.32999u w=46.725u l=1u
X13926 BAT GATE DVDD DVDD pfet_06v0 ad=58.1134p pd=77.985u as=58.1134p ps=77.985u w=76.465u l=1u
X13927 DVDD GATE BAT DVDD pfet_06v0 ad=71.8771p pd=0.15481m as=58.1134p ps=77.985u w=76.465u l=1u
X13928 BAT GATE DVDD DVDD pfet_06v0 ad=35.5072p pd=48.24u as=35.5072p ps=48.24u w=46.72u l=1u
X13929 BAT GATE DVDD DVDD pfet_06v0 ad=58.1134p pd=77.985u as=58.1134p ps=77.985u w=76.465u l=1u
X13930 DVDD GATE BAT DVDD pfet_06v0 ad=35.511p pd=48.245u as=35.511p ps=48.245u w=46.725u l=1u
X13931 DVDD GATE BAT DVDD pfet_06v0 ad=58.1552p pd=78.04u as=58.1552p ps=78.04u w=76.52u l=1u
X13932 DVDD GATE BAT DVDD pfet_06v0 ad=71.8771p pd=0.15481m as=58.1134p ps=77.985u w=76.465u l=1u
X13933 BAT GATE DVDD DVDD pfet_06v0 ad=35.511p pd=48.245u as=35.511p ps=48.245u w=46.725u l=1u
X13934 DVDD GATE BAT DVDD pfet_06v0 ad=35.511p pd=48.245u as=35.511p ps=48.245u w=46.725u l=1u
X13935 DVDD GATE BAT DVDD pfet_06v0 ad=49.3848p pd=66.5u as=49.3848p ps=66.5u w=64.98u l=1u
X13936 DVDD GATE BAT DVDD pfet_06v0 ad=35.511p pd=48.245u as=35.511p ps=48.245u w=46.725u l=1u
X13937 BAT GATE DVDD DVDD pfet_06v0 ad=58.1134p pd=77.985u as=71.8771p ps=0.15481m w=76.465u l=1u
X13938 DVDD GATE BAT DVDD pfet_06v0 ad=71.8771p pd=0.15481m as=58.1134p ps=77.985u w=76.465u l=1u
X13939 BAT GATE DVDD DVDD pfet_06v0 ad=58.1134p pd=77.985u as=71.8771p ps=0.15481m w=76.465u l=1u
X13940 BAT GATE DVDD DVDD pfet_06v0 ad=58.1134p pd=77.985u as=58.1134p ps=77.985u w=76.465u l=1u
X13941 DVDD GATE BAT DVDD pfet_06v0 ad=58.1552p pd=78.04u as=58.1552p ps=78.04u w=76.52u l=1u
X13942 BAT GATE DVDD DVDD pfet_06v0 ad=58.1134p pd=77.985u as=58.1134p ps=77.985u w=76.465u l=1u
X13943 DVDD GATE BAT DVDD pfet_06v0 ad=58.1172p pd=77.99u as=58.1172p ps=77.99u w=76.47u l=1u
X13944 BAT GATE DVDD DVDD pfet_06v0 ad=58.1096p pd=77.98u as=58.1096p ps=77.98u w=76.46u l=1u
X13945 BAT GATE DVDD DVDD pfet_06v0 ad=58.1096p pd=77.98u as=71.8724p ps=0.1548m w=76.46u l=1u
X13946 DVDD GATE BAT DVDD pfet_06v0 ad=58.1134p pd=77.985u as=58.1134p ps=77.985u w=76.465u l=1u
X13947 DVDD GATE BAT DVDD pfet_06v0 ad=58.1552p pd=78.04u as=58.1552p ps=78.04u w=76.52u l=1u
X13948 BAT GATE DVDD DVDD pfet_06v0 ad=58.1134p pd=77.985u as=71.8771p ps=0.15481m w=76.465u l=1u
X13949 DVDD GATE BAT DVDD pfet_06v0 ad=58.1134p pd=77.985u as=58.1134p ps=77.985u w=76.465u l=1u
X13950 DVDD GATE BAT DVDD pfet_06v0 ad=35.511p pd=48.245u as=35.511p ps=48.245u w=46.725u l=1u
X13951 DVDD GATE BAT DVDD pfet_06v0 ad=71.8818p pd=0.15482m as=58.1172p ps=77.99u w=76.47u l=1u
X13952 DVDD GATE BAT DVDD pfet_06v0 ad=58.1134p pd=77.985u as=58.1134p ps=77.985u w=76.465u l=1u
X13953 DVDD GATE BAT DVDD pfet_06v0 ad=58.1134p pd=77.985u as=58.1134p ps=77.985u w=76.465u l=1u
X13954 BAT GATE DVDD DVDD pfet_06v0 ad=49.3848p pd=66.5u as=49.3848p ps=66.5u w=64.98u l=1u
X13955 DVDD GATE BAT DVDD pfet_06v0 ad=58.1134p pd=77.985u as=58.1134p ps=77.985u w=76.465u l=1u
X13956 DVDD GATE BAT DVDD pfet_06v0 ad=43.9215p pd=95.32999u as=35.511p ps=48.245u w=46.725u l=1u
X13957 DVDD GATE BAT DVDD pfet_06v0 ad=35.511p pd=48.245u as=35.511p ps=48.245u w=46.725u l=1u
X13958 BAT GATE DVDD DVDD pfet_06v0 ad=35.511p pd=48.245u as=43.9215p ps=95.32999u w=46.725u l=1u
X13959 DVDD GATE BAT DVDD pfet_06v0 ad=58.1134p pd=77.985u as=58.1134p ps=77.985u w=76.465u l=1u
X13960 BAT GATE DVDD DVDD pfet_06v0 ad=35.511p pd=48.245u as=35.511p ps=48.245u w=46.725u l=1u
X13961 BAT GATE DVDD DVDD pfet_06v0 ad=58.1172p pd=77.99u as=58.1172p ps=77.99u w=76.47u l=1u
X13962 BAT GATE DVDD DVDD pfet_06v0 ad=58.1134p pd=77.985u as=58.1134p ps=77.985u w=76.465u l=1u
X13963 BAT GATE DVDD DVDD pfet_06v0 ad=35.511p pd=48.245u as=35.511p ps=48.245u w=46.725u l=1u
X13964 BAT GATE DVDD DVDD pfet_06v0 ad=35.511p pd=48.245u as=35.511p ps=48.245u w=46.725u l=1u
X13965 DVDD GATE BAT DVDD pfet_06v0 ad=58.1134p pd=77.985u as=58.1134p ps=77.985u w=76.465u l=1u
X13966 BAT GATE DVDD DVDD pfet_06v0 ad=35.511p pd=48.245u as=35.511p ps=48.245u w=46.725u l=1u
X13967 BAT GATE DVDD DVDD pfet_06v0 ad=58.0754p pd=77.935u as=58.0754p ps=77.935u w=76.41499u l=1u
X13968 DVDD GATE BAT DVDD pfet_06v0 ad=71.8771p pd=0.15481m as=58.1134p ps=77.985u w=76.465u l=1u
X13969 DVDD GATE BAT DVDD pfet_06v0 ad=35.511p pd=48.245u as=35.511p ps=48.245u w=46.725u l=1u
X13970 DVDD GATE BAT DVDD pfet_06v0 ad=35.511p pd=48.245u as=35.511p ps=48.245u w=46.725u l=1u
X13971 DVDD GATE BAT DVDD pfet_06v0 ad=35.511p pd=48.245u as=35.511p ps=48.245u w=46.725u l=1u
X13972 DVDD GATE BAT DVDD pfet_06v0 ad=35.511p pd=48.245u as=35.511p ps=48.245u w=46.725u l=1u
X13973 BAT GATE DVDD DVDD pfet_06v0 ad=58.1134p pd=77.985u as=58.1134p ps=77.985u w=76.465u l=1u
X13974 DVDD GATE BAT DVDD pfet_06v0 ad=35.511p pd=48.245u as=35.511p ps=48.245u w=46.725u l=1u
X13975 DVDD GATE BAT DVDD pfet_06v0 ad=58.1134p pd=77.985u as=58.1134p ps=77.985u w=76.465u l=1u
X13976 DVDD GATE BAT DVDD pfet_06v0 ad=58.0754p pd=77.935u as=58.0754p ps=77.935u w=76.41499u l=1u
X13977 DVDD GATE BAT DVDD pfet_06v0 ad=58.9803p pd=0.12737m as=47.6862p ps=64.265u w=62.745u l=1u
X13978 DVDD GATE BAT DVDD pfet_06v0 ad=35.511p pd=48.245u as=35.511p ps=48.245u w=46.725u l=1u
X13979 BAT GATE DVDD DVDD pfet_06v0 ad=47.6862p pd=64.265u as=47.6862p ps=64.265u w=62.745u l=1u
X13980 BAT GATE DVDD DVDD pfet_06v0 ad=35.511p pd=48.245u as=35.511p ps=48.245u w=46.725u l=1u
X13981 BAT GATE DVDD DVDD pfet_06v0 ad=35.5072p pd=48.24u as=35.5072p ps=48.24u w=46.72u l=1u
X13982 DVDD GATE BAT DVDD pfet_06v0 ad=35.511p pd=48.245u as=35.511p ps=48.245u w=46.725u l=1u
X13983 BAT GATE DVDD DVDD pfet_06v0 ad=58.1134p pd=77.985u as=58.1134p ps=77.985u w=76.465u l=1u
X13984 BAT GATE DVDD DVDD pfet_06v0 ad=35.511p pd=48.245u as=43.9215p ps=95.32999u w=46.725u l=1u
X13985 DVDD GATE BAT DVDD pfet_06v0 ad=35.511p pd=48.245u as=35.511p ps=48.245u w=46.725u l=1u
X13986 DVDD GATE BAT DVDD pfet_06v0 ad=35.511p pd=48.245u as=35.511p ps=48.245u w=46.725u l=1u
X13987 DVDD GATE BAT DVDD pfet_06v0 ad=35.511p pd=48.245u as=35.511p ps=48.245u w=46.725u l=1u
X13988 BAT GATE DVDD DVDD pfet_06v0 ad=58.1096p pd=77.98u as=58.1096p ps=77.98u w=76.46u l=1u
X13989 DVDD GATE BAT DVDD pfet_06v0 ad=58.0754p pd=77.935u as=58.0754p ps=77.935u w=76.41499u l=1u
X13990 DVDD GATE BAT DVDD pfet_06v0 ad=58.1134p pd=77.985u as=58.1134p ps=77.985u w=76.465u l=1u
X13991 DVDD GATE BAT DVDD pfet_06v0 ad=43.9168p pd=95.32u as=35.5072p ps=48.24u w=46.72u l=1u
X13992 DVDD GATE BAT DVDD pfet_06v0 ad=58.1134p pd=77.985u as=58.1134p ps=77.985u w=76.465u l=1u
X13993 DVDD GATE BAT DVDD pfet_06v0 ad=47.6862p pd=64.265u as=47.6862p ps=64.265u w=62.745u l=1u
X13994 DVDD GATE BAT DVDD pfet_06v0 ad=58.1134p pd=77.985u as=58.1134p ps=77.985u w=76.465u l=1u
X13995 DVDD GATE BAT DVDD pfet_06v0 ad=58.1134p pd=77.985u as=58.1134p ps=77.985u w=76.465u l=1u
X13996 BAT GATE DVDD DVDD pfet_06v0 ad=58.0754p pd=77.935u as=58.0754p ps=77.935u w=76.41499u l=1u
X13997 DVDD GATE BAT DVDD pfet_06v0 ad=35.511p pd=48.245u as=35.511p ps=48.245u w=46.725u l=1u
X13998 DVDD GATE BAT DVDD pfet_06v0 ad=35.511p pd=48.245u as=35.511p ps=48.245u w=46.725u l=1u
X13999 BAT GATE DVDD DVDD pfet_06v0 ad=35.5072p pd=48.24u as=35.5072p ps=48.24u w=46.72u l=1u
X14000 DVDD GATE BAT DVDD pfet_06v0 ad=58.1134p pd=77.985u as=58.1134p ps=77.985u w=76.465u l=1u
X14001 DVDD GATE BAT DVDD pfet_06v0 ad=58.1134p pd=77.985u as=58.1134p ps=77.985u w=76.465u l=1u
X14002 BAT GATE DVDD DVDD pfet_06v0 ad=49.3848p pd=66.5u as=61.0812p ps=0.13184m w=64.98u l=1u
X14003 DVDD GATE BAT DVDD pfet_06v0 ad=43.9215p pd=95.32999u as=35.511p ps=48.245u w=46.725u l=1u
X14004 DVDD GATE BAT DVDD pfet_06v0 ad=58.1134p pd=77.985u as=58.1134p ps=77.985u w=76.465u l=1u
X14005 DVDD GATE BAT DVDD pfet_06v0 ad=43.9215p pd=95.32999u as=35.511p ps=48.245u w=46.725u l=1u
X14006 BAT GATE DVDD DVDD pfet_06v0 ad=58.1172p pd=77.99u as=71.8818p ps=0.15482m w=76.47u l=1u
X14007 DVDD GATE BAT DVDD pfet_06v0 ad=35.511p pd=48.245u as=35.511p ps=48.245u w=46.725u l=1u
X14008 BAT GATE DVDD DVDD pfet_06v0 ad=58.1134p pd=77.985u as=58.1134p ps=77.985u w=76.465u l=1u
X14009 BAT GATE DVDD DVDD pfet_06v0 ad=49.3848p pd=66.5u as=49.3848p ps=66.5u w=64.98u l=1u
X14010 DVDD GATE BAT DVDD pfet_06v0 ad=58.1096p pd=77.98u as=58.1096p ps=77.98u w=76.46u l=1u
X14011 BAT GATE DVDD DVDD pfet_06v0 ad=35.511p pd=48.245u as=35.511p ps=48.245u w=46.725u l=1u
X14012 DVDD GATE BAT DVDD pfet_06v0 ad=58.0754p pd=77.935u as=58.0754p ps=77.935u w=76.41499u l=1u
X14013 DVDD GATE BAT DVDD pfet_06v0 ad=35.5072p pd=48.24u as=35.5072p ps=48.24u w=46.72u l=1u
X14014 DVDD GATE BAT DVDD pfet_06v0 ad=58.1134p pd=77.985u as=58.1134p ps=77.985u w=76.465u l=1u
X14015 BAT GATE DVDD DVDD pfet_06v0 ad=58.1552p pd=78.04u as=71.92879p ps=0.15492m w=76.52u l=1u
X14016 BAT GATE DVDD DVDD pfet_06v0 ad=35.511p pd=48.245u as=35.511p ps=48.245u w=46.725u l=1u
X14017 BAT GATE DVDD DVDD pfet_06v0 ad=35.511p pd=48.245u as=43.9215p ps=95.32999u w=46.725u l=1u
X14018 DVDD GATE BAT DVDD pfet_06v0 ad=35.5072p pd=48.24u as=35.5072p ps=48.24u w=46.72u l=1u
X14019 BAT GATE DVDD DVDD pfet_06v0 ad=35.511p pd=48.245u as=35.511p ps=48.245u w=46.725u l=1u
X14020 BAT GATE DVDD DVDD pfet_06v0 ad=35.511p pd=48.245u as=35.511p ps=48.245u w=46.725u l=1u
X14021 BAT GATE DVDD DVDD pfet_06v0 ad=35.511p pd=48.245u as=35.511p ps=48.245u w=46.725u l=1u
X14022 DVDD GATE BAT DVDD pfet_06v0 ad=35.511p pd=48.245u as=35.511p ps=48.245u w=46.725u l=1u
X14023 DVDD GATE BAT DVDD pfet_06v0 ad=58.1134p pd=77.985u as=58.1134p ps=77.985u w=76.465u l=1u
X14024 BAT GATE DVDD DVDD pfet_06v0 ad=35.511p pd=48.245u as=35.511p ps=48.245u w=46.725u l=1u
X14025 DVDD GATE BAT DVDD pfet_06v0 ad=58.1134p pd=77.985u as=58.1134p ps=77.985u w=76.465u l=1u
X14026 DVDD GATE BAT DVDD pfet_06v0 ad=35.511p pd=48.245u as=35.511p ps=48.245u w=46.725u l=1u
X14027 DVDD GATE BAT DVDD pfet_06v0 ad=35.511p pd=48.245u as=35.511p ps=48.245u w=46.725u l=1u
X14028 DVDD GATE BAT DVDD pfet_06v0 ad=58.0754p pd=77.935u as=58.0754p ps=77.935u w=76.41499u l=1u
X14029 DVDD GATE BAT DVDD pfet_06v0 ad=35.511p pd=48.245u as=35.511p ps=48.245u w=46.725u l=1u
X14030 BAT GATE DVDD DVDD pfet_06v0 ad=58.0754p pd=77.935u as=71.8301p ps=0.15471m w=76.41499u l=1u
X14031 BAT GATE DVDD DVDD pfet_06v0 ad=58.1552p pd=78.04u as=58.1552p ps=78.04u w=76.52u l=1u
X14032 DVDD GATE BAT DVDD pfet_06v0 ad=58.1134p pd=77.985u as=58.1134p ps=77.985u w=76.465u l=1u
X14033 BAT GATE DVDD DVDD pfet_06v0 ad=35.511p pd=48.245u as=35.511p ps=48.245u w=46.725u l=1u
X14034 DVDD GATE BAT DVDD pfet_06v0 ad=35.511p pd=48.245u as=35.511p ps=48.245u w=46.725u l=1u
X14035 DVDD GATE BAT DVDD pfet_06v0 ad=35.511p pd=48.245u as=35.511p ps=48.245u w=46.725u l=1u
X14036 BAT GATE DVDD DVDD pfet_06v0 ad=35.511p pd=48.245u as=35.511p ps=48.245u w=46.725u l=1u
X14037 BAT GATE DVDD DVDD pfet_06v0 ad=35.511p pd=48.245u as=35.511p ps=48.245u w=46.725u l=1u
X14038 BAT GATE DVDD DVDD pfet_06v0 ad=35.511p pd=48.245u as=35.511p ps=48.245u w=46.725u l=1u
X14039 BAT GATE DVDD DVDD pfet_06v0 ad=35.511p pd=48.245u as=35.511p ps=48.245u w=46.725u l=1u
X14040 DVDD GATE BAT DVDD pfet_06v0 ad=58.1172p pd=77.99u as=58.1172p ps=77.99u w=76.47u l=1u
X14041 DVDD GATE BAT DVDD pfet_06v0 ad=58.1134p pd=77.985u as=58.1134p ps=77.985u w=76.465u l=1u
X14042 DVDD GATE BAT DVDD pfet_06v0 ad=35.511p pd=48.245u as=35.511p ps=48.245u w=46.725u l=1u
X14043 BAT GATE DVDD DVDD pfet_06v0 ad=58.1134p pd=77.985u as=58.1134p ps=77.985u w=76.465u l=1u
X14044 BAT GATE DVDD DVDD pfet_06v0 ad=58.1134p pd=77.985u as=58.1134p ps=77.985u w=76.465u l=1u
X14045 BAT GATE DVDD DVDD pfet_06v0 ad=58.1552p pd=78.04u as=71.92879p ps=0.15492m w=76.52u l=1u
X14046 BAT GATE DVDD DVDD pfet_06v0 ad=35.511p pd=48.245u as=43.9215p ps=95.32999u w=46.725u l=1u
X14047 BAT GATE DVDD DVDD pfet_06v0 ad=35.511p pd=48.245u as=43.9215p ps=95.32999u w=46.725u l=1u
X14048 BAT GATE DVDD DVDD pfet_06v0 ad=58.1134p pd=77.985u as=58.1134p ps=77.985u w=76.465u l=1u
X14049 BAT GATE DVDD DVDD pfet_06v0 ad=35.511p pd=48.245u as=35.511p ps=48.245u w=46.725u l=1u
X14050 BAT GATE DVDD DVDD pfet_06v0 ad=58.1134p pd=77.985u as=58.1134p ps=77.985u w=76.465u l=1u
X14051 BAT GATE DVDD DVDD pfet_06v0 ad=58.1134p pd=77.985u as=58.1134p ps=77.985u w=76.465u l=1u
X14052 BAT GATE DVDD DVDD pfet_06v0 ad=35.511p pd=48.245u as=35.511p ps=48.245u w=46.725u l=1u
X14053 DVDD GATE BAT DVDD pfet_06v0 ad=58.1134p pd=77.985u as=58.1134p ps=77.985u w=76.465u l=1u
X14054 DVDD GATE BAT DVDD pfet_06v0 ad=35.511p pd=48.245u as=35.511p ps=48.245u w=46.725u l=1u
X14055 BAT GATE DVDD DVDD pfet_06v0 ad=58.1134p pd=77.985u as=58.1134p ps=77.985u w=76.465u l=1u
X14056 BAT GATE DVDD DVDD pfet_06v0 ad=58.1552p pd=78.04u as=58.1552p ps=78.04u w=76.52u l=1u
X14057 BAT GATE DVDD DVDD pfet_06v0 ad=47.6862p pd=64.265u as=47.6862p ps=64.265u w=62.745u l=1u
X14058 DVDD GATE BAT DVDD pfet_06v0 ad=35.511p pd=48.245u as=35.511p ps=48.245u w=46.725u l=1u
X14059 BAT GATE DVDD DVDD pfet_06v0 ad=58.1134p pd=77.985u as=58.1134p ps=77.985u w=76.465u l=1u
X14060 DVDD GATE BAT DVDD pfet_06v0 ad=35.511p pd=48.245u as=35.511p ps=48.245u w=46.725u l=1u
X14061 BAT GATE DVDD DVDD pfet_06v0 ad=35.511p pd=48.245u as=35.511p ps=48.245u w=46.725u l=1u
X14062 BAT GATE DVDD DVDD pfet_06v0 ad=35.511p pd=48.245u as=35.511p ps=48.245u w=46.725u l=1u
X14063 DVDD GATE BAT DVDD pfet_06v0 ad=58.1172p pd=77.99u as=58.1172p ps=77.99u w=76.47u l=1u
X14064 DVDD GATE BAT DVDD pfet_06v0 ad=58.1134p pd=77.985u as=58.1134p ps=77.985u w=76.465u l=1u
X14065 BAT GATE DVDD DVDD pfet_06v0 ad=35.511p pd=48.245u as=43.9215p ps=95.32999u w=46.725u l=1u
X14066 BAT GATE DVDD DVDD pfet_06v0 ad=35.511p pd=48.245u as=35.511p ps=48.245u w=46.725u l=1u
X14067 DVDD GATE BAT DVDD pfet_06v0 ad=35.511p pd=48.245u as=35.511p ps=48.245u w=46.725u l=1u
X14068 DVDD GATE BAT DVDD pfet_06v0 ad=71.92879p pd=0.15492m as=58.1552p ps=78.04u w=76.52u l=1u
X14069 BAT GATE DVDD DVDD pfet_06v0 ad=58.1134p pd=77.985u as=58.1134p ps=77.985u w=76.465u l=1u
X14070 BAT GATE DVDD DVDD pfet_06v0 ad=35.511p pd=48.245u as=43.9215p ps=95.32999u w=46.725u l=1u
X14071 DVDD GATE BAT DVDD pfet_06v0 ad=58.1134p pd=77.985u as=58.1134p ps=77.985u w=76.465u l=1u
X14072 BAT GATE DVDD DVDD pfet_06v0 ad=49.3848p pd=66.5u as=49.3848p ps=66.5u w=64.98u l=1u
X14073 DVDD GATE BAT DVDD pfet_06v0 ad=58.1134p pd=77.985u as=58.1134p ps=77.985u w=76.465u l=1u
X14074 BAT GATE DVDD DVDD pfet_06v0 ad=58.0754p pd=77.935u as=58.0754p ps=77.935u w=76.41499u l=1u
X14075 DVDD GATE BAT DVDD pfet_06v0 ad=35.511p pd=48.245u as=35.511p ps=48.245u w=46.725u l=1u
X14076 DVDD GATE BAT DVDD pfet_06v0 ad=35.511p pd=48.245u as=35.511p ps=48.245u w=46.725u l=1u
X14077 DVDD GATE BAT DVDD pfet_06v0 ad=58.1552p pd=78.04u as=58.1552p ps=78.04u w=76.52u l=1u
X14078 DVDD GATE BAT DVDD pfet_06v0 ad=35.511p pd=48.245u as=35.511p ps=48.245u w=46.725u l=1u
X14079 BAT GATE DVDD DVDD pfet_06v0 ad=35.511p pd=48.245u as=35.511p ps=48.245u w=46.725u l=1u
X14080 BAT GATE DVDD DVDD pfet_06v0 ad=58.1134p pd=77.985u as=71.8771p ps=0.15481m w=76.465u l=1u
X14081 BAT GATE DVDD DVDD pfet_06v0 ad=35.511p pd=48.245u as=35.511p ps=48.245u w=46.725u l=1u
X14082 BAT GATE DVDD DVDD pfet_06v0 ad=35.511p pd=48.245u as=35.511p ps=48.245u w=46.725u l=1u
X14083 DVDD GATE BAT DVDD pfet_06v0 ad=58.0754p pd=77.935u as=58.0754p ps=77.935u w=76.41499u l=1u
X14084 BAT GATE DVDD DVDD pfet_06v0 ad=35.511p pd=48.245u as=43.9215p ps=95.32999u w=46.725u l=1u
X14085 DVDD GATE BAT DVDD pfet_06v0 ad=58.1096p pd=77.98u as=58.1096p ps=77.98u w=76.46u l=1u
X14086 BAT GATE DVDD DVDD pfet_06v0 ad=58.0754p pd=77.935u as=58.0754p ps=77.935u w=76.41499u l=1u
X14087 BAT GATE DVDD DVDD pfet_06v0 ad=58.1134p pd=77.985u as=71.8771p ps=0.15481m w=76.465u l=1u
X14088 BAT GATE DVDD DVDD pfet_06v0 ad=58.1134p pd=77.985u as=58.1134p ps=77.985u w=76.465u l=1u
X14089 BAT GATE DVDD DVDD pfet_06v0 ad=58.0754p pd=77.935u as=58.0754p ps=77.935u w=76.41499u l=1u
X14090 BAT GATE DVDD DVDD pfet_06v0 ad=47.6862p pd=64.265u as=47.6862p ps=64.265u w=62.745u l=1u
X14091 BAT GATE DVDD DVDD pfet_06v0 ad=58.1134p pd=77.985u as=58.1134p ps=77.985u w=76.465u l=1u
X14092 BAT GATE DVDD DVDD pfet_06v0 ad=58.1134p pd=77.985u as=58.1134p ps=77.985u w=76.465u l=1u
X14093 DVDD GATE BAT DVDD pfet_06v0 ad=58.0754p pd=77.935u as=58.0754p ps=77.935u w=76.41499u l=1u
X14094 BAT GATE DVDD DVDD pfet_06v0 ad=35.511p pd=48.245u as=43.9215p ps=95.32999u w=46.725u l=1u
X14095 DVDD GATE BAT DVDD pfet_06v0 ad=58.1172p pd=77.99u as=58.1172p ps=77.99u w=76.47u l=1u
X14096 DVDD GATE BAT DVDD pfet_06v0 ad=35.5072p pd=48.24u as=35.5072p ps=48.24u w=46.72u l=1u
X14097 BAT GATE DVDD DVDD pfet_06v0 ad=58.1134p pd=77.985u as=58.1134p ps=77.985u w=76.465u l=1u
X14098 DVDD GATE BAT DVDD pfet_06v0 ad=35.511p pd=48.245u as=35.511p ps=48.245u w=46.725u l=1u
X14099 BAT GATE DVDD DVDD pfet_06v0 ad=35.511p pd=48.245u as=35.511p ps=48.245u w=46.725u l=1u
X14100 DVDD GATE BAT DVDD pfet_06v0 ad=58.0754p pd=77.935u as=58.0754p ps=77.935u w=76.41499u l=1u
X14101 BAT GATE DVDD DVDD pfet_06v0 ad=35.511p pd=48.245u as=35.511p ps=48.245u w=46.725u l=1u
X14102 BAT GATE DVDD DVDD pfet_06v0 ad=47.6862p pd=64.265u as=47.6862p ps=64.265u w=62.745u l=1u
X14103 BAT GATE DVDD DVDD pfet_06v0 ad=58.1096p pd=77.98u as=58.1096p ps=77.98u w=76.46u l=1u
X14104 DVDD GATE BAT DVDD pfet_06v0 ad=35.511p pd=48.245u as=35.511p ps=48.245u w=46.725u l=1u
X14105 BAT GATE DVDD DVDD pfet_06v0 ad=58.1134p pd=77.985u as=58.1134p ps=77.985u w=76.465u l=1u
X14106 DVDD GATE BAT DVDD pfet_06v0 ad=43.9215p pd=95.32999u as=35.511p ps=48.245u w=46.725u l=1u
X14107 BAT GATE DVDD DVDD pfet_06v0 ad=58.1096p pd=77.98u as=58.1096p ps=77.98u w=76.46u l=1u
X14108 BAT GATE DVDD DVDD pfet_06v0 ad=35.511p pd=48.245u as=35.511p ps=48.245u w=46.725u l=1u
X14109 DVDD GATE BAT DVDD pfet_06v0 ad=58.1552p pd=78.04u as=58.1552p ps=78.04u w=76.52u l=1u
X14110 BAT GATE DVDD DVDD pfet_06v0 ad=58.0754p pd=77.935u as=58.0754p ps=77.935u w=76.41499u l=1u
X14111 BAT GATE DVDD DVDD pfet_06v0 ad=49.3848p pd=66.5u as=49.3848p ps=66.5u w=64.98u l=1u
X14112 BAT GATE DVDD DVDD pfet_06v0 ad=35.511p pd=48.245u as=35.511p ps=48.245u w=46.725u l=1u
X14113 DVDD GATE BAT DVDD pfet_06v0 ad=35.511p pd=48.245u as=35.511p ps=48.245u w=46.725u l=1u
X14114 BAT GATE DVDD DVDD pfet_06v0 ad=58.1134p pd=77.985u as=71.8771p ps=0.15481m w=76.465u l=1u
X14115 DVDD GATE BAT DVDD pfet_06v0 ad=47.6862p pd=64.265u as=47.6862p ps=64.265u w=62.745u l=1u
X14116 DVDD GATE BAT DVDD pfet_06v0 ad=58.1552p pd=78.04u as=58.1552p ps=78.04u w=76.52u l=1u
X14117 BAT GATE DVDD DVDD pfet_06v0 ad=58.1134p pd=77.985u as=58.1134p ps=77.985u w=76.465u l=1u
X14118 BAT GATE DVDD DVDD pfet_06v0 ad=58.0754p pd=77.935u as=58.0754p ps=77.935u w=76.41499u l=1u
X14119 DVDD GATE BAT DVDD pfet_06v0 ad=43.9215p pd=95.32999u as=35.511p ps=48.245u w=46.725u l=1u
X14120 BAT GATE DVDD DVDD pfet_06v0 ad=58.1134p pd=77.985u as=58.1134p ps=77.985u w=76.465u l=1u
X14121 BAT GATE DVDD DVDD pfet_06v0 ad=58.1172p pd=77.99u as=58.1172p ps=77.99u w=76.47u l=1u
X14122 BAT GATE DVDD DVDD pfet_06v0 ad=58.1134p pd=77.985u as=71.8771p ps=0.15481m w=76.465u l=1u
X14123 BAT GATE DVDD DVDD pfet_06v0 ad=58.1172p pd=77.99u as=58.1172p ps=77.99u w=76.47u l=1u
X14124 DVDD GATE BAT DVDD pfet_06v0 ad=35.511p pd=48.245u as=35.511p ps=48.245u w=46.725u l=1u
X14125 DVDD GATE BAT DVDD pfet_06v0 ad=71.8771p pd=0.15481m as=58.1134p ps=77.985u w=76.465u l=1u
X14126 DVDD GATE BAT DVDD pfet_06v0 ad=58.1134p pd=77.985u as=58.1134p ps=77.985u w=76.465u l=1u
X14127 BAT GATE DVDD DVDD pfet_06v0 ad=58.1134p pd=77.985u as=71.8771p ps=0.15481m w=76.465u l=1u
X14128 BAT GATE DVDD DVDD pfet_06v0 ad=58.1134p pd=77.985u as=58.1134p ps=77.985u w=76.465u l=1u
X14129 DVDD GATE BAT DVDD pfet_06v0 ad=35.511p pd=48.245u as=35.511p ps=48.245u w=46.725u l=1u
X14130 DVDD GATE BAT DVDD pfet_06v0 ad=35.511p pd=48.245u as=35.511p ps=48.245u w=46.725u l=1u
X14131 DVDD GATE BAT DVDD pfet_06v0 ad=58.1172p pd=77.99u as=58.1172p ps=77.99u w=76.47u l=1u
X14132 DVDD GATE BAT DVDD pfet_06v0 ad=58.1134p pd=77.985u as=58.1134p ps=77.985u w=76.465u l=1u
X14133 DVDD GATE BAT DVDD pfet_06v0 ad=58.1134p pd=77.985u as=58.1134p ps=77.985u w=76.465u l=1u
X14134 DVDD GATE BAT DVDD pfet_06v0 ad=35.511p pd=48.245u as=35.511p ps=48.245u w=46.725u l=1u
X14135 BAT GATE DVDD DVDD pfet_06v0 ad=58.1134p pd=77.985u as=58.1134p ps=77.985u w=76.465u l=1u
X14136 DVDD GATE BAT DVDD pfet_06v0 ad=35.5072p pd=48.24u as=35.5072p ps=48.24u w=46.72u l=1u
X14137 BAT GATE DVDD DVDD pfet_06v0 ad=35.511p pd=48.245u as=35.511p ps=48.245u w=46.725u l=1u
X14138 BAT GATE DVDD DVDD pfet_06v0 ad=35.511p pd=48.245u as=35.511p ps=48.245u w=46.725u l=1u
X14139 DVDD GATE BAT DVDD pfet_06v0 ad=47.6862p pd=64.265u as=47.6862p ps=64.265u w=62.745u l=1u
X14140 BAT GATE DVDD DVDD pfet_06v0 ad=58.1134p pd=77.985u as=58.1134p ps=77.985u w=76.465u l=1u
X14141 DVDD GATE BAT DVDD pfet_06v0 ad=71.8771p pd=0.15481m as=58.1134p ps=77.985u w=76.465u l=1u
X14142 BAT GATE DVDD DVDD pfet_06v0 ad=49.3848p pd=66.5u as=49.3848p ps=66.5u w=64.98u l=1u
X14143 DVDD GATE BAT DVDD pfet_06v0 ad=58.1134p pd=77.985u as=58.1134p ps=77.985u w=76.465u l=1u
X14144 BAT GATE DVDD DVDD pfet_06v0 ad=35.511p pd=48.245u as=35.511p ps=48.245u w=46.725u l=1u
X14145 DVDD GATE BAT DVDD pfet_06v0 ad=35.511p pd=48.245u as=35.511p ps=48.245u w=46.725u l=1u
X14146 DVDD GATE BAT DVDD pfet_06v0 ad=58.1134p pd=77.985u as=58.1134p ps=77.985u w=76.465u l=1u
X14147 DVDD GATE BAT DVDD pfet_06v0 ad=58.1134p pd=77.985u as=58.1134p ps=77.985u w=76.465u l=1u
X14148 BAT GATE DVDD DVDD pfet_06v0 ad=58.1134p pd=77.985u as=58.1134p ps=77.985u w=76.465u l=1u
X14149 DVDD GATE BAT DVDD pfet_06v0 ad=35.511p pd=48.245u as=35.511p ps=48.245u w=46.725u l=1u
X14150 BAT GATE DVDD DVDD pfet_06v0 ad=35.511p pd=48.245u as=35.511p ps=48.245u w=46.725u l=1u
X14151 DVDD GATE BAT DVDD pfet_06v0 ad=58.1134p pd=77.985u as=58.1134p ps=77.985u w=76.465u l=1u
X14152 BAT GATE DVDD DVDD pfet_06v0 ad=58.1552p pd=78.04u as=58.1552p ps=78.04u w=76.52u l=1u
X14153 DVDD GATE BAT DVDD pfet_06v0 ad=71.8771p pd=0.15481m as=58.1134p ps=77.985u w=76.465u l=1u
X14154 DVDD GATE BAT DVDD pfet_06v0 ad=47.6862p pd=64.265u as=47.6862p ps=64.265u w=62.745u l=1u
X14155 DVDD GATE BAT DVDD pfet_06v0 ad=35.511p pd=48.245u as=35.511p ps=48.245u w=46.725u l=1u
X14156 DVDD GATE BAT DVDD pfet_06v0 ad=58.1134p pd=77.985u as=58.1134p ps=77.985u w=76.465u l=1u
X14157 DVDD GATE BAT DVDD pfet_06v0 ad=35.511p pd=48.245u as=35.511p ps=48.245u w=46.725u l=1u
X14158 DVDD GATE BAT DVDD pfet_06v0 ad=43.9215p pd=95.32999u as=35.511p ps=48.245u w=46.725u l=1u
X14159 DVDD GATE BAT DVDD pfet_06v0 ad=35.511p pd=48.245u as=35.511p ps=48.245u w=46.725u l=1u
X14160 DVDD GATE BAT DVDD pfet_06v0 ad=35.511p pd=48.245u as=35.511p ps=48.245u w=46.725u l=1u
X14161 BAT GATE DVDD DVDD pfet_06v0 ad=58.1134p pd=77.985u as=71.8771p ps=0.15481m w=76.465u l=1u
X14162 BAT GATE DVDD DVDD pfet_06v0 ad=58.1172p pd=77.99u as=58.1172p ps=77.99u w=76.47u l=1u
X14163 BAT GATE DVDD DVDD pfet_06v0 ad=58.1172p pd=77.99u as=58.1172p ps=77.99u w=76.47u l=1u
X14164 BAT GATE DVDD DVDD pfet_06v0 ad=58.1096p pd=77.98u as=58.1096p ps=77.98u w=76.46u l=1u
X14165 DVDD GATE BAT DVDD pfet_06v0 ad=58.9803p pd=0.12737m as=47.6862p ps=64.265u w=62.745u l=1u
X14166 DVDD GATE BAT DVDD pfet_06v0 ad=58.1134p pd=77.985u as=58.1134p ps=77.985u w=76.465u l=1u
X14167 DVDD GATE BAT DVDD pfet_06v0 ad=35.511p pd=48.245u as=35.511p ps=48.245u w=46.725u l=1u
X14168 BAT GATE DVDD DVDD pfet_06v0 ad=35.511p pd=48.245u as=35.511p ps=48.245u w=46.725u l=1u
X14169 BAT GATE DVDD DVDD pfet_06v0 ad=35.511p pd=48.245u as=35.511p ps=48.245u w=46.725u l=1u
X14170 DVDD GATE BAT DVDD pfet_06v0 ad=35.511p pd=48.245u as=35.511p ps=48.245u w=46.725u l=1u
X14171 DVDD GATE BAT DVDD pfet_06v0 ad=71.8771p pd=0.15481m as=58.1134p ps=77.985u w=76.465u l=1u
X14172 BAT GATE DVDD DVDD pfet_06v0 ad=58.1134p pd=77.985u as=58.1134p ps=77.985u w=76.465u l=1u
X14173 DVDD GATE BAT DVDD pfet_06v0 ad=58.0754p pd=77.935u as=58.0754p ps=77.935u w=76.41499u l=1u
X14174 DVDD GATE BAT DVDD pfet_06v0 ad=49.3848p pd=66.5u as=49.3848p ps=66.5u w=64.98u l=1u
X14175 DVDD GATE BAT DVDD pfet_06v0 ad=71.8724p pd=0.1548m as=58.1096p ps=77.98u w=76.46u l=1u
X14176 DVDD GATE BAT DVDD pfet_06v0 ad=58.0754p pd=77.935u as=58.0754p ps=77.935u w=76.41499u l=1u
X14177 BAT GATE DVDD DVDD pfet_06v0 ad=35.511p pd=48.245u as=43.9215p ps=95.32999u w=46.725u l=1u
X14178 DVDD GATE BAT DVDD pfet_06v0 ad=43.9215p pd=95.32999u as=35.511p ps=48.245u w=46.725u l=1u
X14179 DVDD GATE BAT DVDD pfet_06v0 ad=35.511p pd=48.245u as=35.511p ps=48.245u w=46.725u l=1u
X14180 BAT GATE DVDD DVDD pfet_06v0 ad=35.511p pd=48.245u as=43.9215p ps=95.32999u w=46.725u l=1u
X14181 DVDD GATE BAT DVDD pfet_06v0 ad=49.3848p pd=66.5u as=49.3848p ps=66.5u w=64.98u l=1u
X14182 DVDD GATE BAT DVDD pfet_06v0 ad=58.1134p pd=77.985u as=58.1134p ps=77.985u w=76.465u l=1u
X14183 BAT GATE DVDD DVDD pfet_06v0 ad=58.0754p pd=77.935u as=58.0754p ps=77.935u w=76.41499u l=1u
X14184 BAT GATE DVDD DVDD pfet_06v0 ad=58.1134p pd=77.985u as=58.1134p ps=77.985u w=76.465u l=1u
X14185 DVDD GATE BAT DVDD pfet_06v0 ad=43.9168p pd=95.32u as=35.5072p ps=48.24u w=46.72u l=1u
X14186 BAT GATE DVDD DVDD pfet_06v0 ad=58.1096p pd=77.98u as=58.1096p ps=77.98u w=76.46u l=1u
X14187 DVDD GATE BAT DVDD pfet_06v0 ad=61.0812p pd=0.13184m as=49.3848p ps=66.5u w=64.98u l=1u
X14188 DVDD GATE BAT DVDD pfet_06v0 ad=35.511p pd=48.245u as=35.511p ps=48.245u w=46.725u l=1u
X14189 DVDD GATE BAT DVDD pfet_06v0 ad=58.1134p pd=77.985u as=58.1134p ps=77.985u w=76.465u l=1u
X14190 BAT GATE DVDD DVDD pfet_06v0 ad=47.6862p pd=64.265u as=47.6862p ps=64.265u w=62.745u l=1u
X14191 BAT GATE DVDD DVDD pfet_06v0 ad=58.1134p pd=77.985u as=71.8771p ps=0.15481m w=76.465u l=1u
X14192 DVDD GATE BAT DVDD pfet_06v0 ad=47.6862p pd=64.265u as=47.6862p ps=64.265u w=62.745u l=1u
X14193 BAT GATE DVDD DVDD pfet_06v0 ad=35.511p pd=48.245u as=35.511p ps=48.245u w=46.725u l=1u
X14194 DVDD GATE BAT DVDD pfet_06v0 ad=58.1134p pd=77.985u as=58.1134p ps=77.985u w=76.465u l=1u
X14195 DVDD GATE BAT DVDD pfet_06v0 ad=35.511p pd=48.245u as=35.511p ps=48.245u w=46.725u l=1u
X14196 DVDD GATE BAT DVDD pfet_06v0 ad=35.511p pd=48.245u as=35.511p ps=48.245u w=46.725u l=1u
X14197 BAT GATE DVDD DVDD pfet_06v0 ad=58.1172p pd=77.99u as=58.1172p ps=77.99u w=76.47u l=1u
X14198 DVDD GATE BAT DVDD pfet_06v0 ad=58.1134p pd=77.985u as=58.1134p ps=77.985u w=76.465u l=1u
X14199 BAT GATE DVDD DVDD pfet_06v0 ad=35.5072p pd=48.24u as=35.5072p ps=48.24u w=46.72u l=1u
X14200 DVDD GATE BAT DVDD pfet_06v0 ad=58.1134p pd=77.985u as=58.1134p ps=77.985u w=76.465u l=1u
X14201 DVDD GATE BAT DVDD pfet_06v0 ad=35.511p pd=48.245u as=35.511p ps=48.245u w=46.725u l=1u
X14202 BAT GATE DVDD DVDD pfet_06v0 ad=58.0754p pd=77.935u as=58.0754p ps=77.935u w=76.41499u l=1u
X14203 BAT GATE DVDD DVDD pfet_06v0 ad=58.1134p pd=77.985u as=71.8771p ps=0.15481m w=76.465u l=1u
X14204 DVDD GATE BAT DVDD pfet_06v0 ad=58.1096p pd=77.98u as=58.1096p ps=77.98u w=76.46u l=1u
X14205 DVDD GATE BAT DVDD pfet_06v0 ad=35.511p pd=48.245u as=35.511p ps=48.245u w=46.725u l=1u
X14206 DVDD GATE BAT DVDD pfet_06v0 ad=35.511p pd=48.245u as=35.511p ps=48.245u w=46.725u l=1u
X14207 BAT GATE DVDD DVDD pfet_06v0 ad=35.5072p pd=48.24u as=43.9168p ps=95.32u w=46.72u l=1u
X14208 BAT GATE DVDD DVDD pfet_06v0 ad=35.511p pd=48.245u as=35.511p ps=48.245u w=46.725u l=1u
X14209 BAT GATE DVDD DVDD pfet_06v0 ad=35.5072p pd=48.24u as=35.5072p ps=48.24u w=46.72u l=1u
X14210 DVDD GATE BAT DVDD pfet_06v0 ad=58.1096p pd=77.98u as=58.1096p ps=77.98u w=76.46u l=1u
X14211 DVDD GATE BAT DVDD pfet_06v0 ad=58.1096p pd=77.98u as=58.1096p ps=77.98u w=76.46u l=1u
X14212 BAT GATE DVDD DVDD pfet_06v0 ad=58.1134p pd=77.985u as=58.1134p ps=77.985u w=76.465u l=1u
X14213 DVDD GATE BAT DVDD pfet_06v0 ad=35.511p pd=48.245u as=35.511p ps=48.245u w=46.725u l=1u
X14214 BAT GATE DVDD DVDD pfet_06v0 ad=35.5072p pd=48.24u as=35.5072p ps=48.24u w=46.72u l=1u
X14215 DVDD GATE BAT DVDD pfet_06v0 ad=58.1134p pd=77.985u as=58.1134p ps=77.985u w=76.465u l=1u
X14216 DVDD GATE BAT DVDD pfet_06v0 ad=35.511p pd=48.245u as=35.511p ps=48.245u w=46.725u l=1u
X14217 BAT GATE DVDD DVDD pfet_06v0 ad=35.511p pd=48.245u as=43.9215p ps=95.32999u w=46.725u l=1u
X14218 DVDD GATE BAT DVDD pfet_06v0 ad=35.5072p pd=48.24u as=35.5072p ps=48.24u w=46.72u l=1u
X14219 BAT GATE DVDD DVDD pfet_06v0 ad=58.1172p pd=77.99u as=71.8818p ps=0.15482m w=76.47u l=1u
X14220 DVDD GATE BAT DVDD pfet_06v0 ad=71.8771p pd=0.15481m as=58.1134p ps=77.985u w=76.465u l=1u
X14221 DVDD GATE BAT DVDD pfet_06v0 ad=35.5072p pd=48.24u as=35.5072p ps=48.24u w=46.72u l=1u
X14222 DVDD GATE BAT DVDD pfet_06v0 ad=61.0812p pd=0.13184m as=49.3848p ps=66.5u w=64.98u l=1u
X14223 BAT GATE DVDD DVDD pfet_06v0 ad=58.1134p pd=77.985u as=58.1134p ps=77.985u w=76.465u l=1u
X14224 BAT GATE DVDD DVDD pfet_06v0 ad=35.511p pd=48.245u as=35.511p ps=48.245u w=46.725u l=1u
X14225 BAT GATE DVDD DVDD pfet_06v0 ad=47.6862p pd=64.265u as=47.6862p ps=64.265u w=62.745u l=1u
X14226 BAT GATE DVDD DVDD pfet_06v0 ad=35.511p pd=48.245u as=35.511p ps=48.245u w=46.725u l=1u
X14227 BAT GATE DVDD DVDD pfet_06v0 ad=58.1552p pd=78.04u as=58.1552p ps=78.04u w=76.52u l=1u
X14228 DVDD GATE BAT DVDD pfet_06v0 ad=58.0754p pd=77.935u as=58.0754p ps=77.935u w=76.41499u l=1u
X14229 BAT GATE DVDD DVDD pfet_06v0 ad=35.511p pd=48.245u as=35.511p ps=48.245u w=46.725u l=1u
X14230 DVDD GATE BAT DVDD pfet_06v0 ad=71.8771p pd=0.15481m as=58.1134p ps=77.985u w=76.465u l=1u
X14231 DVDD GATE BAT DVDD pfet_06v0 ad=58.1172p pd=77.99u as=58.1172p ps=77.99u w=76.47u l=1u
X14232 BAT GATE DVDD DVDD pfet_06v0 ad=58.1134p pd=77.985u as=58.1134p ps=77.985u w=76.465u l=1u
X14233 BAT GATE DVDD DVDD pfet_06v0 ad=58.1134p pd=77.985u as=58.1134p ps=77.985u w=76.465u l=1u
X14234 DVDD GATE BAT DVDD pfet_06v0 ad=58.1134p pd=77.985u as=58.1134p ps=77.985u w=76.465u l=1u
X14235 DVDD GATE BAT DVDD pfet_06v0 ad=71.8771p pd=0.15481m as=58.1134p ps=77.985u w=76.465u l=1u
X14236 BAT GATE DVDD DVDD pfet_06v0 ad=58.1134p pd=77.985u as=71.8771p ps=0.15481m w=76.465u l=1u
X14237 DVDD GATE BAT DVDD pfet_06v0 ad=35.511p pd=48.245u as=35.511p ps=48.245u w=46.725u l=1u
X14238 BAT GATE DVDD DVDD pfet_06v0 ad=58.1134p pd=77.985u as=58.1134p ps=77.985u w=76.465u l=1u
X14239 DVDD GATE BAT DVDD pfet_06v0 ad=58.1134p pd=77.985u as=58.1134p ps=77.985u w=76.465u l=1u
X14240 DVDD GATE BAT DVDD pfet_06v0 ad=35.511p pd=48.245u as=35.511p ps=48.245u w=46.725u l=1u
X14241 DVDD GATE BAT DVDD pfet_06v0 ad=35.511p pd=48.245u as=35.511p ps=48.245u w=46.725u l=1u
X14242 DVDD GATE BAT DVDD pfet_06v0 ad=58.1134p pd=77.985u as=58.1134p ps=77.985u w=76.465u l=1u
X14243 DVDD GATE BAT DVDD pfet_06v0 ad=35.511p pd=48.245u as=35.511p ps=48.245u w=46.725u l=1u
X14244 DVDD GATE BAT DVDD pfet_06v0 ad=58.1134p pd=77.985u as=58.1134p ps=77.985u w=76.465u l=1u
X14245 BAT GATE DVDD DVDD pfet_06v0 ad=58.1134p pd=77.985u as=58.1134p ps=77.985u w=76.465u l=1u
X14246 BAT GATE DVDD DVDD pfet_06v0 ad=35.511p pd=48.245u as=35.511p ps=48.245u w=46.725u l=1u
X14247 DVDD GATE BAT DVDD pfet_06v0 ad=49.3848p pd=66.5u as=49.3848p ps=66.5u w=64.98u l=1u
X14248 DVDD GATE BAT DVDD pfet_06v0 ad=35.511p pd=48.245u as=35.511p ps=48.245u w=46.725u l=1u
X14249 DVDD GATE BAT DVDD pfet_06v0 ad=35.511p pd=48.245u as=35.511p ps=48.245u w=46.725u l=1u
X14250 DVDD GATE BAT DVDD pfet_06v0 ad=58.1552p pd=78.04u as=58.1552p ps=78.04u w=76.52u l=1u
X14251 BAT GATE DVDD DVDD pfet_06v0 ad=35.511p pd=48.245u as=35.511p ps=48.245u w=46.725u l=1u
X14252 DVDD GATE BAT DVDD pfet_06v0 ad=58.1134p pd=77.985u as=58.1134p ps=77.985u w=76.465u l=1u
X14253 BAT GATE DVDD DVDD pfet_06v0 ad=35.511p pd=48.245u as=43.9215p ps=95.32999u w=46.725u l=1u
X14254 DVDD GATE BAT DVDD pfet_06v0 ad=35.511p pd=48.245u as=35.511p ps=48.245u w=46.725u l=1u
X14255 BAT GATE DVDD DVDD pfet_06v0 ad=58.1134p pd=77.985u as=58.1134p ps=77.985u w=76.465u l=1u
X14256 BAT GATE DVDD DVDD pfet_06v0 ad=58.1096p pd=77.98u as=71.8724p ps=0.1548m w=76.46u l=1u
X14257 BAT GATE DVDD DVDD pfet_06v0 ad=35.511p pd=48.245u as=43.9215p ps=95.32999u w=46.725u l=1u
X14258 DVDD GATE BAT DVDD pfet_06v0 ad=58.1134p pd=77.985u as=58.1134p ps=77.985u w=76.465u l=1u
X14259 DVDD GATE BAT DVDD pfet_06v0 ad=35.511p pd=48.245u as=35.511p ps=48.245u w=46.725u l=1u
X14260 DVDD GATE BAT DVDD pfet_06v0 ad=58.1172p pd=77.99u as=58.1172p ps=77.99u w=76.47u l=1u
X14261 DVDD GATE BAT DVDD pfet_06v0 ad=58.1134p pd=77.985u as=58.1134p ps=77.985u w=76.465u l=1u
X14262 BAT GATE DVDD DVDD pfet_06v0 ad=49.3848p pd=66.5u as=61.0812p ps=0.13184m w=64.98u l=1u
X14263 BAT GATE DVDD DVDD pfet_06v0 ad=49.3848p pd=66.5u as=49.3848p ps=66.5u w=64.98u l=1u
X14264 BAT GATE DVDD DVDD pfet_06v0 ad=58.1134p pd=77.985u as=58.1134p ps=77.985u w=76.465u l=1u
X14265 BAT GATE DVDD DVDD pfet_06v0 ad=47.6862p pd=64.265u as=47.6862p ps=64.265u w=62.745u l=1u
X14266 BAT GATE DVDD DVDD pfet_06v0 ad=58.1134p pd=77.985u as=58.1134p ps=77.985u w=76.465u l=1u
X14267 BAT GATE DVDD DVDD pfet_06v0 ad=35.511p pd=48.245u as=43.9215p ps=95.32999u w=46.725u l=1u
X14268 BAT GATE DVDD DVDD pfet_06v0 ad=35.511p pd=48.245u as=43.9215p ps=95.32999u w=46.725u l=1u
X14269 BAT GATE DVDD DVDD pfet_06v0 ad=35.511p pd=48.245u as=35.511p ps=48.245u w=46.725u l=1u
X14270 BAT GATE DVDD DVDD pfet_06v0 ad=49.3848p pd=66.5u as=49.3848p ps=66.5u w=64.98u l=1u
X14271 BAT GATE DVDD DVDD pfet_06v0 ad=49.3848p pd=66.5u as=49.3848p ps=66.5u w=64.98u l=1u
X14272 BAT GATE DVDD DVDD pfet_06v0 ad=58.1134p pd=77.985u as=71.8771p ps=0.15481m w=76.465u l=1u
X14273 BAT GATE DVDD DVDD pfet_06v0 ad=35.511p pd=48.245u as=35.511p ps=48.245u w=46.725u l=1u
X14274 BAT GATE DVDD DVDD pfet_06v0 ad=35.511p pd=48.245u as=35.511p ps=48.245u w=46.725u l=1u
X14275 DVDD GATE BAT DVDD pfet_06v0 ad=58.1134p pd=77.985u as=58.1134p ps=77.985u w=76.465u l=1u
X14276 DVDD GATE BAT DVDD pfet_06v0 ad=71.8771p pd=0.15481m as=58.1134p ps=77.985u w=76.465u l=1u
X14277 DVDD GATE BAT DVDD pfet_06v0 ad=58.0754p pd=77.935u as=58.0754p ps=77.935u w=76.41499u l=1u
X14278 DVDD GATE BAT DVDD pfet_06v0 ad=71.8771p pd=0.15481m as=58.1134p ps=77.985u w=76.465u l=1u
X14279 DVDD GATE BAT DVDD pfet_06v0 ad=47.6862p pd=64.265u as=47.6862p ps=64.265u w=62.745u l=1u
X14280 DVDD GATE BAT DVDD pfet_06v0 ad=35.511p pd=48.245u as=35.511p ps=48.245u w=46.725u l=1u
X14281 BAT GATE DVDD DVDD pfet_06v0 ad=47.6862p pd=64.265u as=58.9803p ps=0.12737m w=62.745u l=1u
X14282 BAT GATE DVDD DVDD pfet_06v0 ad=35.511p pd=48.245u as=35.511p ps=48.245u w=46.725u l=1u
X14283 DVDD GATE BAT DVDD pfet_06v0 ad=43.9215p pd=95.32999u as=35.511p ps=48.245u w=46.725u l=1u
X14284 BAT GATE DVDD DVDD pfet_06v0 ad=35.5072p pd=48.24u as=43.9168p ps=95.32u w=46.72u l=1u
X14285 BAT GATE DVDD DVDD pfet_06v0 ad=58.1552p pd=78.04u as=58.1552p ps=78.04u w=76.52u l=1u
X14286 BAT GATE DVDD DVDD pfet_06v0 ad=35.511p pd=48.245u as=35.511p ps=48.245u w=46.725u l=1u
X14287 BAT GATE DVDD DVDD pfet_06v0 ad=35.511p pd=48.245u as=35.511p ps=48.245u w=46.725u l=1u
X14288 DVDD GATE BAT DVDD pfet_06v0 ad=35.511p pd=48.245u as=35.511p ps=48.245u w=46.725u l=1u
X14289 DVDD GATE BAT DVDD pfet_06v0 ad=71.8818p pd=0.15482m as=58.1172p ps=77.99u w=76.47u l=1u
X14290 DVDD GATE BAT DVDD pfet_06v0 ad=58.0754p pd=77.935u as=58.0754p ps=77.935u w=76.41499u l=1u
X14291 DVDD GATE BAT DVDD pfet_06v0 ad=47.6862p pd=64.265u as=47.6862p ps=64.265u w=62.745u l=1u
X14292 DVDD GATE BAT DVDD pfet_06v0 ad=35.5072p pd=48.24u as=35.5072p ps=48.24u w=46.72u l=1u
X14293 DVDD GATE BAT DVDD pfet_06v0 ad=35.511p pd=48.245u as=35.511p ps=48.245u w=46.725u l=1u
X14294 DVDD GATE BAT DVDD pfet_06v0 ad=35.511p pd=48.245u as=35.511p ps=48.245u w=46.725u l=1u
X14295 DVDD GATE BAT DVDD pfet_06v0 ad=58.1134p pd=77.985u as=58.1134p ps=77.985u w=76.465u l=1u
X14296 DVDD GATE BAT DVDD pfet_06v0 ad=58.1134p pd=77.985u as=58.1134p ps=77.985u w=76.465u l=1u
X14297 BAT GATE DVDD DVDD pfet_06v0 ad=58.1134p pd=77.985u as=71.8771p ps=0.15481m w=76.465u l=1u
X14298 DVDD GATE BAT DVDD pfet_06v0 ad=35.511p pd=48.245u as=35.511p ps=48.245u w=46.725u l=1u
X14299 DVDD GATE BAT DVDD pfet_06v0 ad=71.8771p pd=0.15481m as=58.1134p ps=77.985u w=76.465u l=1u
X14300 DVDD GATE BAT DVDD pfet_06v0 ad=58.1134p pd=77.985u as=58.1134p ps=77.985u w=76.465u l=1u
X14301 DVDD GATE BAT DVDD pfet_06v0 ad=35.511p pd=48.245u as=35.511p ps=48.245u w=46.725u l=1u
X14302 DVDD GATE BAT DVDD pfet_06v0 ad=71.8771p pd=0.15481m as=58.1134p ps=77.985u w=76.465u l=1u
X14303 DVDD GATE BAT DVDD pfet_06v0 ad=35.511p pd=48.245u as=35.511p ps=48.245u w=46.725u l=1u
X14304 BAT GATE DVDD DVDD pfet_06v0 ad=58.1134p pd=77.985u as=58.1134p ps=77.985u w=76.465u l=1u
X14305 DVDD GATE BAT DVDD pfet_06v0 ad=43.9215p pd=95.32999u as=35.511p ps=48.245u w=46.725u l=1u
X14306 BAT GATE DVDD DVDD pfet_06v0 ad=35.511p pd=48.245u as=35.511p ps=48.245u w=46.725u l=1u
X14307 BAT GATE DVDD DVDD pfet_06v0 ad=35.511p pd=48.245u as=43.9215p ps=95.32999u w=46.725u l=1u
X14308 BAT GATE DVDD DVDD pfet_06v0 ad=35.511p pd=48.245u as=35.511p ps=48.245u w=46.725u l=1u
X14309 DVDD GATE BAT DVDD pfet_06v0 ad=58.1096p pd=77.98u as=58.1096p ps=77.98u w=76.46u l=1u
X14310 DVDD GATE BAT DVDD pfet_06v0 ad=58.0754p pd=77.935u as=58.0754p ps=77.935u w=76.41499u l=1u
X14311 BAT GATE DVDD DVDD pfet_06v0 ad=35.511p pd=48.245u as=43.9215p ps=95.32999u w=46.725u l=1u
X14312 BAT GATE DVDD DVDD pfet_06v0 ad=58.1552p pd=78.04u as=58.1552p ps=78.04u w=76.52u l=1u
X14313 BAT GATE DVDD DVDD pfet_06v0 ad=35.511p pd=48.245u as=35.511p ps=48.245u w=46.725u l=1u
X14314 DVDD GATE BAT DVDD pfet_06v0 ad=43.9215p pd=95.32999u as=35.511p ps=48.245u w=46.725u l=1u
X14315 DVDD GATE BAT DVDD pfet_06v0 ad=58.1134p pd=77.985u as=58.1134p ps=77.985u w=76.465u l=1u
X14316 BAT GATE DVDD DVDD pfet_06v0 ad=35.5072p pd=48.24u as=35.5072p ps=48.24u w=46.72u l=1u
X14317 DVDD GATE BAT DVDD pfet_06v0 ad=61.0812p pd=0.13184m as=49.3848p ps=66.5u w=64.98u l=1u
X14318 DVDD GATE BAT DVDD pfet_06v0 ad=58.0754p pd=77.935u as=58.0754p ps=77.935u w=76.41499u l=1u
X14319 BAT GATE DVDD DVDD pfet_06v0 ad=35.511p pd=48.245u as=35.511p ps=48.245u w=46.725u l=1u
X14320 BAT GATE DVDD DVDD pfet_06v0 ad=35.511p pd=48.245u as=35.511p ps=48.245u w=46.725u l=1u
X14321 DVDD GATE BAT DVDD pfet_06v0 ad=35.511p pd=48.245u as=35.511p ps=48.245u w=46.725u l=1u
X14322 BAT GATE DVDD DVDD pfet_06v0 ad=35.511p pd=48.245u as=43.9215p ps=95.32999u w=46.725u l=1u
X14323 DVDD GATE BAT DVDD pfet_06v0 ad=35.511p pd=48.245u as=35.511p ps=48.245u w=46.725u l=1u
X14324 DVDD GATE BAT DVDD pfet_06v0 ad=58.1134p pd=77.985u as=58.1134p ps=77.985u w=76.465u l=1u
X14325 DVDD GATE BAT DVDD pfet_06v0 ad=58.0754p pd=77.935u as=58.0754p ps=77.935u w=76.41499u l=1u
X14326 BAT GATE DVDD DVDD pfet_06v0 ad=35.511p pd=48.245u as=35.511p ps=48.245u w=46.725u l=1u
X14327 DVDD GATE BAT DVDD pfet_06v0 ad=58.0754p pd=77.935u as=58.0754p ps=77.935u w=76.41499u l=1u
X14328 BAT GATE DVDD DVDD pfet_06v0 ad=35.511p pd=48.245u as=35.511p ps=48.245u w=46.725u l=1u
X14329 BAT GATE DVDD DVDD pfet_06v0 ad=35.511p pd=48.245u as=35.511p ps=48.245u w=46.725u l=1u
X14330 BAT GATE DVDD DVDD pfet_06v0 ad=35.511p pd=48.245u as=43.9215p ps=95.32999u w=46.725u l=1u
X14331 BAT GATE DVDD DVDD pfet_06v0 ad=58.1552p pd=78.04u as=58.1552p ps=78.04u w=76.52u l=1u
X14332 DVDD GATE BAT DVDD pfet_06v0 ad=58.1134p pd=77.985u as=58.1134p ps=77.985u w=76.465u l=1u
X14333 DVDD GATE BAT DVDD pfet_06v0 ad=43.9215p pd=95.32999u as=35.511p ps=48.245u w=46.725u l=1u
X14334 BAT GATE DVDD DVDD pfet_06v0 ad=35.511p pd=48.245u as=35.511p ps=48.245u w=46.725u l=1u
X14335 BAT GATE DVDD DVDD pfet_06v0 ad=58.1134p pd=77.985u as=58.1134p ps=77.985u w=76.465u l=1u
X14336 BAT GATE DVDD DVDD pfet_06v0 ad=35.511p pd=48.245u as=35.511p ps=48.245u w=46.725u l=1u
X14337 BAT GATE DVDD DVDD pfet_06v0 ad=35.511p pd=48.245u as=43.9215p ps=95.32999u w=46.725u l=1u
X14338 BAT GATE DVDD DVDD pfet_06v0 ad=35.511p pd=48.245u as=35.511p ps=48.245u w=46.725u l=1u
X14339 DVDD GATE BAT DVDD pfet_06v0 ad=58.1172p pd=77.99u as=58.1172p ps=77.99u w=76.47u l=1u
X14340 BAT GATE DVDD DVDD pfet_06v0 ad=35.511p pd=48.245u as=43.9215p ps=95.32999u w=46.725u l=1u
X14341 BAT GATE DVDD DVDD pfet_06v0 ad=58.1134p pd=77.985u as=58.1134p ps=77.985u w=76.465u l=1u
X14342 BAT GATE DVDD DVDD pfet_06v0 ad=58.1134p pd=77.985u as=58.1134p ps=77.985u w=76.465u l=1u
X14343 BAT GATE DVDD DVDD pfet_06v0 ad=58.1134p pd=77.985u as=71.8771p ps=0.15481m w=76.465u l=1u
X14344 BAT GATE DVDD DVDD pfet_06v0 ad=58.1134p pd=77.985u as=58.1134p ps=77.985u w=76.465u l=1u
X14345 BAT GATE DVDD DVDD pfet_06v0 ad=35.511p pd=48.245u as=35.511p ps=48.245u w=46.725u l=1u
X14346 BAT GATE DVDD DVDD pfet_06v0 ad=58.1134p pd=77.985u as=58.1134p ps=77.985u w=76.465u l=1u
X14347 DVDD GATE BAT DVDD pfet_06v0 ad=71.8771p pd=0.15481m as=58.1134p ps=77.985u w=76.465u l=1u
X14348 BAT GATE DVDD DVDD pfet_06v0 ad=35.511p pd=48.245u as=35.511p ps=48.245u w=46.725u l=1u
X14349 BAT GATE DVDD DVDD pfet_06v0 ad=58.1134p pd=77.985u as=71.8771p ps=0.15481m w=76.465u l=1u
X14350 BAT GATE DVDD DVDD pfet_06v0 ad=58.1134p pd=77.985u as=58.1134p ps=77.985u w=76.465u l=1u
X14351 DVDD GATE BAT DVDD pfet_06v0 ad=35.511p pd=48.245u as=35.511p ps=48.245u w=46.725u l=1u
X14352 BAT GATE DVDD DVDD pfet_06v0 ad=58.1552p pd=78.04u as=71.92879p ps=0.15492m w=76.52u l=1u
X14353 BAT GATE DVDD DVDD pfet_06v0 ad=47.6862p pd=64.265u as=47.6862p ps=64.265u w=62.745u l=1u
X14354 BAT GATE DVDD DVDD pfet_06v0 ad=58.1134p pd=77.985u as=58.1134p ps=77.985u w=76.465u l=1u
X14355 BAT GATE DVDD DVDD pfet_06v0 ad=35.511p pd=48.245u as=35.511p ps=48.245u w=46.725u l=1u
X14356 BAT GATE DVDD DVDD pfet_06v0 ad=35.511p pd=48.245u as=35.511p ps=48.245u w=46.725u l=1u
X14357 BAT GATE DVDD DVDD pfet_06v0 ad=35.511p pd=48.245u as=35.511p ps=48.245u w=46.725u l=1u
X14358 DVDD GATE BAT DVDD pfet_06v0 ad=35.511p pd=48.245u as=35.511p ps=48.245u w=46.725u l=1u
X14359 DVDD GATE BAT DVDD pfet_06v0 ad=58.1552p pd=78.04u as=58.1552p ps=78.04u w=76.52u l=1u
X14360 BAT GATE DVDD DVDD pfet_06v0 ad=58.1134p pd=77.985u as=58.1134p ps=77.985u w=76.465u l=1u
X14361 BAT GATE DVDD DVDD pfet_06v0 ad=58.1096p pd=77.98u as=71.8724p ps=0.1548m w=76.46u l=1u
X14362 BAT GATE DVDD DVDD pfet_06v0 ad=58.1096p pd=77.98u as=58.1096p ps=77.98u w=76.46u l=1u
X14363 DVDD GATE BAT DVDD pfet_06v0 ad=58.1172p pd=77.99u as=58.1172p ps=77.99u w=76.47u l=1u
X14364 DVDD GATE BAT DVDD pfet_06v0 ad=58.1134p pd=77.985u as=58.1134p ps=77.985u w=76.465u l=1u
X14365 BAT GATE DVDD DVDD pfet_06v0 ad=35.511p pd=48.245u as=35.511p ps=48.245u w=46.725u l=1u
X14366 BAT GATE DVDD DVDD pfet_06v0 ad=58.1134p pd=77.985u as=58.1134p ps=77.985u w=76.465u l=1u
X14367 DVDD GATE BAT DVDD pfet_06v0 ad=58.1134p pd=77.985u as=58.1134p ps=77.985u w=76.465u l=1u
X14368 DVDD GATE BAT DVDD pfet_06v0 ad=35.511p pd=48.245u as=35.511p ps=48.245u w=46.725u l=1u
X14369 BAT GATE DVDD DVDD pfet_06v0 ad=58.1096p pd=77.98u as=58.1096p ps=77.98u w=76.46u l=1u
X14370 DVDD GATE BAT DVDD pfet_06v0 ad=43.9215p pd=95.32999u as=35.511p ps=48.245u w=46.725u l=1u
X14371 DVDD GATE BAT DVDD pfet_06v0 ad=58.1552p pd=78.04u as=58.1552p ps=78.04u w=76.52u l=1u
X14372 BAT GATE DVDD DVDD pfet_06v0 ad=58.0754p pd=77.935u as=58.0754p ps=77.935u w=76.41499u l=1u
X14373 BAT GATE DVDD DVDD pfet_06v0 ad=35.511p pd=48.245u as=35.511p ps=48.245u w=46.725u l=1u
X14374 DVDD GATE BAT DVDD pfet_06v0 ad=58.1096p pd=77.98u as=58.1096p ps=77.98u w=76.46u l=1u
X14375 BAT GATE DVDD DVDD pfet_06v0 ad=35.511p pd=48.245u as=35.511p ps=48.245u w=46.725u l=1u
X14376 DVDD GATE BAT DVDD pfet_06v0 ad=35.511p pd=48.245u as=35.511p ps=48.245u w=46.725u l=1u
X14377 BAT GATE DVDD DVDD pfet_06v0 ad=35.511p pd=48.245u as=43.9215p ps=95.32999u w=46.725u l=1u
X14378 DVDD GATE BAT DVDD pfet_06v0 ad=43.9215p pd=95.32999u as=35.511p ps=48.245u w=46.725u l=1u
X14379 DVDD GATE BAT DVDD pfet_06v0 ad=35.511p pd=48.245u as=35.511p ps=48.245u w=46.725u l=1u
X14380 DVDD GATE BAT DVDD pfet_06v0 ad=43.9215p pd=95.32999u as=35.511p ps=48.245u w=46.725u l=1u
X14381 BAT GATE DVDD DVDD pfet_06v0 ad=35.511p pd=48.245u as=43.9215p ps=95.32999u w=46.725u l=1u
X14382 BAT GATE DVDD DVDD pfet_06v0 ad=58.1134p pd=77.985u as=58.1134p ps=77.985u w=76.465u l=1u
X14383 BAT GATE DVDD DVDD pfet_06v0 ad=58.0754p pd=77.935u as=58.0754p ps=77.935u w=76.41499u l=1u
X14384 BAT GATE DVDD DVDD pfet_06v0 ad=58.0754p pd=77.935u as=58.0754p ps=77.935u w=76.41499u l=1u
X14385 BAT GATE DVDD DVDD pfet_06v0 ad=47.6862p pd=64.265u as=58.9803p ps=0.12737m w=62.745u l=1u
X14386 BAT GATE DVDD DVDD pfet_06v0 ad=58.1134p pd=77.985u as=58.1134p ps=77.985u w=76.465u l=1u
X14387 DVDD GATE BAT DVDD pfet_06v0 ad=43.9215p pd=95.32999u as=35.511p ps=48.245u w=46.725u l=1u
X14388 DVDD GATE BAT DVDD pfet_06v0 ad=43.9215p pd=95.32999u as=35.511p ps=48.245u w=46.725u l=1u
X14389 DVDD GATE BAT DVDD pfet_06v0 ad=58.9803p pd=0.12737m as=47.6862p ps=64.265u w=62.745u l=1u
X14390 DVDD GATE BAT DVDD pfet_06v0 ad=58.1172p pd=77.99u as=58.1172p ps=77.99u w=76.47u l=1u
X14391 DVDD GATE BAT DVDD pfet_06v0 ad=35.511p pd=48.245u as=35.511p ps=48.245u w=46.725u l=1u
X14392 BAT GATE DVDD DVDD pfet_06v0 ad=58.1134p pd=77.985u as=71.8771p ps=0.15481m w=76.465u l=1u
X14393 BAT GATE DVDD DVDD pfet_06v0 ad=35.511p pd=48.245u as=35.511p ps=48.245u w=46.725u l=1u
X14394 DVDD GATE BAT DVDD pfet_06v0 ad=58.0754p pd=77.935u as=58.0754p ps=77.935u w=76.41499u l=1u
X14395 DVDD GATE BAT DVDD pfet_06v0 ad=58.1552p pd=78.04u as=58.1552p ps=78.04u w=76.52u l=1u
X14396 BAT GATE DVDD DVDD pfet_06v0 ad=58.1134p pd=77.985u as=58.1134p ps=77.985u w=76.465u l=1u
X14397 BAT GATE DVDD DVDD pfet_06v0 ad=35.511p pd=48.245u as=35.511p ps=48.245u w=46.725u l=1u
X14398 BAT GATE DVDD DVDD pfet_06v0 ad=47.6862p pd=64.265u as=47.6862p ps=64.265u w=62.745u l=1u
X14399 BAT GATE DVDD DVDD pfet_06v0 ad=58.1134p pd=77.985u as=58.1134p ps=77.985u w=76.465u l=1u
X14400 BAT GATE DVDD DVDD pfet_06v0 ad=35.511p pd=48.245u as=35.511p ps=48.245u w=46.725u l=1u
X14401 DVDD GATE BAT DVDD pfet_06v0 ad=43.9215p pd=95.32999u as=35.511p ps=48.245u w=46.725u l=1u
X14402 BAT GATE DVDD DVDD pfet_06v0 ad=58.1134p pd=77.985u as=58.1134p ps=77.985u w=76.465u l=1u
X14403 DVDD GATE BAT DVDD pfet_06v0 ad=58.1134p pd=77.985u as=58.1134p ps=77.985u w=76.465u l=1u
X14404 BAT GATE DVDD DVDD pfet_06v0 ad=58.1134p pd=77.985u as=58.1134p ps=77.985u w=76.465u l=1u
X14405 DVDD GATE BAT DVDD pfet_06v0 ad=49.3848p pd=66.5u as=49.3848p ps=66.5u w=64.98u l=1u
X14406 DVDD GATE BAT DVDD pfet_06v0 ad=35.511p pd=48.245u as=35.511p ps=48.245u w=46.725u l=1u
X14407 BAT GATE DVDD DVDD pfet_06v0 ad=58.1134p pd=77.985u as=58.1134p ps=77.985u w=76.465u l=1u
X14408 BAT GATE DVDD DVDD pfet_06v0 ad=35.511p pd=48.245u as=35.511p ps=48.245u w=46.725u l=1u
X14409 BAT GATE DVDD DVDD pfet_06v0 ad=35.5072p pd=48.24u as=43.9168p ps=95.32u w=46.72u l=1u
X14410 DVDD GATE BAT DVDD pfet_06v0 ad=71.8771p pd=0.15481m as=58.1134p ps=77.985u w=76.465u l=1u
X14411 DVDD GATE BAT DVDD pfet_06v0 ad=58.1552p pd=78.04u as=58.1552p ps=78.04u w=76.52u l=1u
X14412 BAT GATE DVDD DVDD pfet_06v0 ad=58.1134p pd=77.985u as=71.8771p ps=0.15481m w=76.465u l=1u
X14413 BAT GATE DVDD DVDD pfet_06v0 ad=58.0754p pd=77.935u as=71.8301p ps=0.15471m w=76.41499u l=1u
X14414 BAT GATE DVDD DVDD pfet_06v0 ad=35.511p pd=48.245u as=35.511p ps=48.245u w=46.725u l=1u
X14415 DVDD GATE BAT DVDD pfet_06v0 ad=35.511p pd=48.245u as=35.511p ps=48.245u w=46.725u l=1u
X14416 DVDD GATE BAT DVDD pfet_06v0 ad=71.8771p pd=0.15481m as=58.1134p ps=77.985u w=76.465u l=1u
X14417 DVDD GATE BAT DVDD pfet_06v0 ad=71.8771p pd=0.15481m as=58.1134p ps=77.985u w=76.465u l=1u
X14418 BAT GATE DVDD DVDD pfet_06v0 ad=35.511p pd=48.245u as=35.511p ps=48.245u w=46.725u l=1u
X14419 BAT GATE DVDD DVDD pfet_06v0 ad=58.1134p pd=77.985u as=58.1134p ps=77.985u w=76.465u l=1u
X14420 DVDD GATE BAT DVDD pfet_06v0 ad=58.1552p pd=78.04u as=58.1552p ps=78.04u w=76.52u l=1u
X14421 BAT GATE DVDD DVDD pfet_06v0 ad=58.1134p pd=77.985u as=71.8771p ps=0.15481m w=76.465u l=1u
X14422 BAT GATE DVDD DVDD pfet_06v0 ad=35.511p pd=48.245u as=35.511p ps=48.245u w=46.725u l=1u
X14423 BAT GATE DVDD DVDD pfet_06v0 ad=58.1134p pd=77.985u as=58.1134p ps=77.985u w=76.465u l=1u
X14424 DVDD GATE BAT DVDD pfet_06v0 ad=58.1134p pd=77.985u as=58.1134p ps=77.985u w=76.465u l=1u
X14425 DVDD GATE BAT DVDD pfet_06v0 ad=43.9215p pd=95.32999u as=35.511p ps=48.245u w=46.725u l=1u
X14426 BAT GATE DVDD DVDD pfet_06v0 ad=58.1134p pd=77.985u as=58.1134p ps=77.985u w=76.465u l=1u
X14427 BAT GATE DVDD DVDD pfet_06v0 ad=58.1172p pd=77.99u as=71.8818p ps=0.15482m w=76.47u l=1u
X14428 BAT GATE DVDD DVDD pfet_06v0 ad=58.1172p pd=77.99u as=58.1172p ps=77.99u w=76.47u l=1u
X14429 DVDD GATE BAT DVDD pfet_06v0 ad=35.511p pd=48.245u as=35.511p ps=48.245u w=46.725u l=1u
X14430 BAT GATE DVDD DVDD pfet_06v0 ad=35.511p pd=48.245u as=35.511p ps=48.245u w=46.725u l=1u
X14431 DVDD GATE BAT DVDD pfet_06v0 ad=71.8771p pd=0.15481m as=58.1134p ps=77.985u w=76.465u l=1u
X14432 DVDD GATE BAT DVDD pfet_06v0 ad=58.1134p pd=77.985u as=58.1134p ps=77.985u w=76.465u l=1u
X14433 DVDD GATE BAT DVDD pfet_06v0 ad=35.511p pd=48.245u as=35.511p ps=48.245u w=46.725u l=1u
X14434 DVDD GATE BAT DVDD pfet_06v0 ad=35.511p pd=48.245u as=35.511p ps=48.245u w=46.725u l=1u
X14435 BAT GATE DVDD DVDD pfet_06v0 ad=58.1134p pd=77.985u as=58.1134p ps=77.985u w=76.465u l=1u
X14436 BAT GATE DVDD DVDD pfet_06v0 ad=35.511p pd=48.245u as=43.9215p ps=95.32999u w=46.725u l=1u
X14437 DVDD GATE BAT DVDD pfet_06v0 ad=35.5072p pd=48.24u as=35.5072p ps=48.24u w=46.72u l=1u
X14438 DVDD GATE BAT DVDD pfet_06v0 ad=58.1134p pd=77.985u as=58.1134p ps=77.985u w=76.465u l=1u
X14439 BAT GATE DVDD DVDD pfet_06v0 ad=58.1134p pd=77.985u as=58.1134p ps=77.985u w=76.465u l=1u
X14440 DVDD GATE BAT DVDD pfet_06v0 ad=71.8301p pd=0.15471m as=58.0754p ps=77.935u w=76.41499u l=1u
X14441 BAT GATE DVDD DVDD pfet_06v0 ad=58.1134p pd=77.985u as=58.1134p ps=77.985u w=76.465u l=1u
X14442 DVDD GATE BAT DVDD pfet_06v0 ad=58.1134p pd=77.985u as=58.1134p ps=77.985u w=76.465u l=1u
X14443 BAT GATE DVDD DVDD pfet_06v0 ad=35.511p pd=48.245u as=35.511p ps=48.245u w=46.725u l=1u
X14444 BAT GATE DVDD DVDD pfet_06v0 ad=49.3848p pd=66.5u as=49.3848p ps=66.5u w=64.98u l=1u
X14445 DVDD GATE BAT DVDD pfet_06v0 ad=58.1134p pd=77.985u as=58.1134p ps=77.985u w=76.465u l=1u
X14446 DVDD GATE BAT DVDD pfet_06v0 ad=35.511p pd=48.245u as=35.511p ps=48.245u w=46.725u l=1u
X14447 BAT GATE DVDD DVDD pfet_06v0 ad=58.1134p pd=77.985u as=58.1134p ps=77.985u w=76.465u l=1u
X14448 DVDD GATE BAT DVDD pfet_06v0 ad=35.511p pd=48.245u as=35.511p ps=48.245u w=46.725u l=1u
X14449 DVDD GATE BAT DVDD pfet_06v0 ad=58.1134p pd=77.985u as=58.1134p ps=77.985u w=76.465u l=1u
X14450 BAT GATE DVDD DVDD pfet_06v0 ad=35.511p pd=48.245u as=43.9215p ps=95.32999u w=46.725u l=1u
X14451 DVDD GATE BAT DVDD pfet_06v0 ad=58.1134p pd=77.985u as=58.1134p ps=77.985u w=76.465u l=1u
X14452 DVDD GATE BAT DVDD pfet_06v0 ad=71.8301p pd=0.15471m as=58.0754p ps=77.935u w=76.41499u l=1u
X14453 DVDD GATE BAT DVDD pfet_06v0 ad=47.6862p pd=64.265u as=47.6862p ps=64.265u w=62.745u l=1u
X14454 DVDD GATE BAT DVDD pfet_06v0 ad=58.1134p pd=77.985u as=58.1134p ps=77.985u w=76.465u l=1u
X14455 DVDD GATE BAT DVDD pfet_06v0 ad=35.511p pd=48.245u as=35.511p ps=48.245u w=46.725u l=1u
X14456 DVDD GATE BAT DVDD pfet_06v0 ad=35.511p pd=48.245u as=35.511p ps=48.245u w=46.725u l=1u
X14457 BAT GATE DVDD DVDD pfet_06v0 ad=35.511p pd=48.245u as=43.9215p ps=95.32999u w=46.725u l=1u
X14458 DVDD GATE BAT DVDD pfet_06v0 ad=35.511p pd=48.245u as=35.511p ps=48.245u w=46.725u l=1u
X14459 DVDD GATE BAT DVDD pfet_06v0 ad=43.9215p pd=95.32999u as=35.511p ps=48.245u w=46.725u l=1u
X14460 BAT GATE DVDD DVDD pfet_06v0 ad=58.1172p pd=77.99u as=58.1172p ps=77.99u w=76.47u l=1u
X14461 BAT GATE DVDD DVDD pfet_06v0 ad=58.0754p pd=77.935u as=58.0754p ps=77.935u w=76.41499u l=1u
X14462 DVDD GATE BAT DVDD pfet_06v0 ad=58.1134p pd=77.985u as=58.1134p ps=77.985u w=76.465u l=1u
X14463 BAT GATE DVDD DVDD pfet_06v0 ad=58.1096p pd=77.98u as=71.8724p ps=0.1548m w=76.46u l=1u
X14464 DVDD GATE BAT DVDD pfet_06v0 ad=47.6862p pd=64.265u as=47.6862p ps=64.265u w=62.745u l=1u
X14465 DVDD GATE BAT DVDD pfet_06v0 ad=58.1134p pd=77.985u as=58.1134p ps=77.985u w=76.465u l=1u
X14466 BAT GATE DVDD DVDD pfet_06v0 ad=35.511p pd=48.245u as=35.511p ps=48.245u w=46.725u l=1u
X14467 DVDD GATE BAT DVDD pfet_06v0 ad=58.1134p pd=77.985u as=58.1134p ps=77.985u w=76.465u l=1u
X14468 DVDD GATE BAT DVDD pfet_06v0 ad=35.511p pd=48.245u as=35.511p ps=48.245u w=46.725u l=1u
X14469 DVDD GATE BAT DVDD pfet_06v0 ad=35.511p pd=48.245u as=35.511p ps=48.245u w=46.725u l=1u
X14470 DVDD GATE BAT DVDD pfet_06v0 ad=35.5072p pd=48.24u as=35.5072p ps=48.24u w=46.72u l=1u
X14471 BAT GATE DVDD DVDD pfet_06v0 ad=35.511p pd=48.245u as=35.511p ps=48.245u w=46.725u l=1u
X14472 BAT GATE DVDD DVDD pfet_06v0 ad=58.1134p pd=77.985u as=71.8771p ps=0.15481m w=76.465u l=1u
X14473 DVDD GATE BAT DVDD pfet_06v0 ad=58.1134p pd=77.985u as=58.1134p ps=77.985u w=76.465u l=1u
X14474 DVDD GATE BAT DVDD pfet_06v0 ad=58.1096p pd=77.98u as=58.1096p ps=77.98u w=76.46u l=1u
X14475 DVDD GATE BAT DVDD pfet_06v0 ad=35.511p pd=48.245u as=35.511p ps=48.245u w=46.725u l=1u
X14476 BAT GATE DVDD DVDD pfet_06v0 ad=58.1134p pd=77.985u as=58.1134p ps=77.985u w=76.465u l=1u
X14477 BAT GATE DVDD DVDD pfet_06v0 ad=58.1552p pd=78.04u as=58.1552p ps=78.04u w=76.52u l=1u
X14478 DVDD GATE BAT DVDD pfet_06v0 ad=49.3848p pd=66.5u as=49.3848p ps=66.5u w=64.98u l=1u
X14479 DVDD GATE BAT DVDD pfet_06v0 ad=35.511p pd=48.245u as=35.511p ps=48.245u w=46.725u l=1u
X14480 DVDD GATE BAT DVDD pfet_06v0 ad=61.0812p pd=0.13184m as=49.3848p ps=66.5u w=64.98u l=1u
X14481 BAT GATE DVDD DVDD pfet_06v0 ad=35.5072p pd=48.24u as=35.5072p ps=48.24u w=46.72u l=1u
X14482 DVDD GATE BAT DVDD pfet_06v0 ad=35.5072p pd=48.24u as=35.5072p ps=48.24u w=46.72u l=1u
X14483 DVDD GATE BAT DVDD pfet_06v0 ad=58.1134p pd=77.985u as=58.1134p ps=77.985u w=76.465u l=1u
X14484 BAT GATE DVDD DVDD pfet_06v0 ad=35.511p pd=48.245u as=35.511p ps=48.245u w=46.725u l=1u
X14485 BAT GATE DVDD DVDD pfet_06v0 ad=47.6862p pd=64.265u as=47.6862p ps=64.265u w=62.745u l=1u
X14486 BAT GATE DVDD DVDD pfet_06v0 ad=35.511p pd=48.245u as=35.511p ps=48.245u w=46.725u l=1u
X14487 BAT GATE DVDD DVDD pfet_06v0 ad=35.511p pd=48.245u as=35.511p ps=48.245u w=46.725u l=1u
X14488 DVDD GATE BAT DVDD pfet_06v0 ad=58.1134p pd=77.985u as=58.1134p ps=77.985u w=76.465u l=1u
X14489 BAT GATE DVDD DVDD pfet_06v0 ad=47.6862p pd=64.265u as=47.6862p ps=64.265u w=62.745u l=1u
X14490 BAT GATE DVDD DVDD pfet_06v0 ad=35.511p pd=48.245u as=43.9215p ps=95.32999u w=46.725u l=1u
X14491 DVDD GATE BAT DVDD pfet_06v0 ad=58.1134p pd=77.985u as=58.1134p ps=77.985u w=76.465u l=1u
X14492 DVDD GATE BAT DVDD pfet_06v0 ad=35.511p pd=48.245u as=35.511p ps=48.245u w=46.725u l=1u
X14493 DVDD GATE BAT DVDD pfet_06v0 ad=71.8301p pd=0.15471m as=58.0754p ps=77.935u w=76.41499u l=1u
X14494 DVDD GATE BAT DVDD pfet_06v0 ad=58.1134p pd=77.985u as=58.1134p ps=77.985u w=76.465u l=1u
X14495 BAT GATE DVDD DVDD pfet_06v0 ad=35.511p pd=48.245u as=43.9215p ps=95.32999u w=46.725u l=1u
X14496 DVDD GATE BAT DVDD pfet_06v0 ad=58.1134p pd=77.985u as=58.1134p ps=77.985u w=76.465u l=1u
X14497 BAT GATE DVDD DVDD pfet_06v0 ad=58.1134p pd=77.985u as=58.1134p ps=77.985u w=76.465u l=1u
X14498 DVDD GATE BAT DVDD pfet_06v0 ad=35.511p pd=48.245u as=35.511p ps=48.245u w=46.725u l=1u
X14499 BAT GATE DVDD DVDD pfet_06v0 ad=35.511p pd=48.245u as=35.511p ps=48.245u w=46.725u l=1u
X14500 BAT GATE DVDD DVDD pfet_06v0 ad=58.1096p pd=77.98u as=58.1096p ps=77.98u w=76.46u l=1u
X14501 BAT GATE DVDD DVDD pfet_06v0 ad=58.1134p pd=77.985u as=58.1134p ps=77.985u w=76.465u l=1u
X14502 BAT GATE DVDD DVDD pfet_06v0 ad=35.5072p pd=48.24u as=35.5072p ps=48.24u w=46.72u l=1u
X14503 DVDD GATE BAT DVDD pfet_06v0 ad=35.511p pd=48.245u as=35.511p ps=48.245u w=46.725u l=1u
X14504 BAT GATE DVDD DVDD pfet_06v0 ad=35.511p pd=48.245u as=43.9215p ps=95.32999u w=46.725u l=1u
X14505 DVDD GATE BAT DVDD pfet_06v0 ad=35.511p pd=48.245u as=35.511p ps=48.245u w=46.725u l=1u
X14506 BAT GATE DVDD DVDD pfet_06v0 ad=35.511p pd=48.245u as=35.511p ps=48.245u w=46.725u l=1u
X14507 DVDD GATE BAT DVDD pfet_06v0 ad=61.0812p pd=0.13184m as=49.3848p ps=66.5u w=64.98u l=1u
X14508 BAT GATE DVDD DVDD pfet_06v0 ad=58.1134p pd=77.985u as=58.1134p ps=77.985u w=76.465u l=1u
X14509 DVDD GATE BAT DVDD pfet_06v0 ad=43.9215p pd=95.32999u as=35.511p ps=48.245u w=46.725u l=1u
X14510 BAT GATE DVDD DVDD pfet_06v0 ad=35.511p pd=48.245u as=35.511p ps=48.245u w=46.725u l=1u
X14511 BAT GATE DVDD DVDD pfet_06v0 ad=58.1134p pd=77.985u as=58.1134p ps=77.985u w=76.465u l=1u
X14512 BAT GATE DVDD DVDD pfet_06v0 ad=58.1134p pd=77.985u as=58.1134p ps=77.985u w=76.465u l=1u
X14513 BAT GATE DVDD DVDD pfet_06v0 ad=35.511p pd=48.245u as=35.511p ps=48.245u w=46.725u l=1u
X14514 DVDD GATE BAT DVDD pfet_06v0 ad=49.3848p pd=66.5u as=49.3848p ps=66.5u w=64.98u l=1u
X14515 BAT GATE DVDD DVDD pfet_06v0 ad=35.511p pd=48.245u as=43.9215p ps=95.32999u w=46.725u l=1u
X14516 DVDD GATE BAT DVDD pfet_06v0 ad=71.92879p pd=0.15492m as=58.1552p ps=78.04u w=76.52u l=1u
X14517 BAT GATE DVDD DVDD pfet_06v0 ad=58.1134p pd=77.985u as=58.1134p ps=77.985u w=76.465u l=1u
X14518 DVDD GATE BAT DVDD pfet_06v0 ad=58.0754p pd=77.935u as=58.0754p ps=77.935u w=76.41499u l=1u
X14519 DVDD GATE BAT DVDD pfet_06v0 ad=58.1134p pd=77.985u as=58.1134p ps=77.985u w=76.465u l=1u
X14520 BAT GATE DVDD DVDD pfet_06v0 ad=35.511p pd=48.245u as=35.511p ps=48.245u w=46.725u l=1u
X14521 BAT GATE DVDD DVDD pfet_06v0 ad=35.511p pd=48.245u as=35.511p ps=48.245u w=46.725u l=1u
X14522 DVDD GATE BAT DVDD pfet_06v0 ad=71.8301p pd=0.15471m as=58.0754p ps=77.935u w=76.41499u l=1u
X14523 BAT GATE DVDD DVDD pfet_06v0 ad=35.511p pd=48.245u as=35.511p ps=48.245u w=46.725u l=1u
X14524 BAT GATE DVDD DVDD pfet_06v0 ad=35.511p pd=48.245u as=35.511p ps=48.245u w=46.725u l=1u
X14525 BAT GATE DVDD DVDD pfet_06v0 ad=58.1134p pd=77.985u as=58.1134p ps=77.985u w=76.465u l=1u
X14526 DVDD GATE BAT DVDD pfet_06v0 ad=58.1134p pd=77.985u as=58.1134p ps=77.985u w=76.465u l=1u
X14527 BAT GATE DVDD DVDD pfet_06v0 ad=35.511p pd=48.245u as=35.511p ps=48.245u w=46.725u l=1u
X14528 DVDD GATE BAT DVDD pfet_06v0 ad=43.9215p pd=95.32999u as=35.511p ps=48.245u w=46.725u l=1u
X14529 BAT GATE DVDD DVDD pfet_06v0 ad=58.1134p pd=77.985u as=58.1134p ps=77.985u w=76.465u l=1u
X14530 BAT GATE DVDD DVDD pfet_06v0 ad=35.511p pd=48.245u as=35.511p ps=48.245u w=46.725u l=1u
X14531 DVDD GATE BAT DVDD pfet_06v0 ad=58.1134p pd=77.985u as=58.1134p ps=77.985u w=76.465u l=1u
X14532 DVDD GATE BAT DVDD pfet_06v0 ad=58.1134p pd=77.985u as=58.1134p ps=77.985u w=76.465u l=1u
X14533 BAT GATE DVDD DVDD pfet_06v0 ad=58.0754p pd=77.935u as=58.0754p ps=77.935u w=76.41499u l=1u
X14534 BAT GATE DVDD DVDD pfet_06v0 ad=58.1134p pd=77.985u as=58.1134p ps=77.985u w=76.465u l=1u
X14535 BAT GATE DVDD DVDD pfet_06v0 ad=58.1134p pd=77.985u as=58.1134p ps=77.985u w=76.465u l=1u
X14536 BAT GATE DVDD DVDD pfet_06v0 ad=35.511p pd=48.245u as=35.511p ps=48.245u w=46.725u l=1u
X14537 DVDD GATE BAT DVDD pfet_06v0 ad=49.3848p pd=66.5u as=49.3848p ps=66.5u w=64.98u l=1u
X14538 DVDD GATE BAT DVDD pfet_06v0 ad=35.511p pd=48.245u as=35.511p ps=48.245u w=46.725u l=1u
X14539 BAT GATE DVDD DVDD pfet_06v0 ad=49.3848p pd=66.5u as=49.3848p ps=66.5u w=64.98u l=1u
X14540 DVDD GATE BAT DVDD pfet_06v0 ad=58.1552p pd=78.04u as=58.1552p ps=78.04u w=76.52u l=1u
X14541 BAT GATE DVDD DVDD pfet_06v0 ad=58.1134p pd=77.985u as=58.1134p ps=77.985u w=76.465u l=1u
X14542 BAT GATE DVDD DVDD pfet_06v0 ad=35.511p pd=48.245u as=35.511p ps=48.245u w=46.725u l=1u
X14543 DVDD GATE BAT DVDD pfet_06v0 ad=58.1134p pd=77.985u as=58.1134p ps=77.985u w=76.465u l=1u
X14544 DVDD GATE BAT DVDD pfet_06v0 ad=71.8724p pd=0.1548m as=58.1096p ps=77.98u w=76.46u l=1u
X14545 BAT GATE DVDD DVDD pfet_06v0 ad=35.511p pd=48.245u as=35.511p ps=48.245u w=46.725u l=1u
X14546 BAT GATE DVDD DVDD pfet_06v0 ad=58.1134p pd=77.985u as=58.1134p ps=77.985u w=76.465u l=1u
X14547 DVDD GATE BAT DVDD pfet_06v0 ad=71.8301p pd=0.15471m as=58.0754p ps=77.935u w=76.41499u l=1u
X14548 BAT GATE DVDD DVDD pfet_06v0 ad=58.1134p pd=77.985u as=71.8771p ps=0.15481m w=76.465u l=1u
X14549 BAT GATE DVDD DVDD pfet_06v0 ad=58.1172p pd=77.99u as=58.1172p ps=77.99u w=76.47u l=1u
X14550 DVDD GATE BAT DVDD pfet_06v0 ad=35.511p pd=48.245u as=35.511p ps=48.245u w=46.725u l=1u
X14551 BAT GATE DVDD DVDD pfet_06v0 ad=58.0754p pd=77.935u as=58.0754p ps=77.935u w=76.41499u l=1u
X14552 BAT GATE DVDD DVDD pfet_06v0 ad=58.1134p pd=77.985u as=71.8771p ps=0.15481m w=76.465u l=1u
X14553 BAT GATE DVDD DVDD pfet_06v0 ad=58.1134p pd=77.985u as=71.8771p ps=0.15481m w=76.465u l=1u
X14554 BAT GATE DVDD DVDD pfet_06v0 ad=35.511p pd=48.245u as=35.511p ps=48.245u w=46.725u l=1u
X14555 BAT GATE DVDD DVDD pfet_06v0 ad=35.511p pd=48.245u as=35.511p ps=48.245u w=46.725u l=1u
X14556 BAT GATE DVDD DVDD pfet_06v0 ad=58.1172p pd=77.99u as=58.1172p ps=77.99u w=76.47u l=1u
X14557 DVDD GATE BAT DVDD pfet_06v0 ad=58.1134p pd=77.985u as=58.1134p ps=77.985u w=76.465u l=1u
X14558 DVDD GATE BAT DVDD pfet_06v0 ad=43.9168p pd=95.32u as=35.5072p ps=48.24u w=46.72u l=1u
X14559 DVDD GATE BAT DVDD pfet_06v0 ad=58.1172p pd=77.99u as=58.1172p ps=77.99u w=76.47u l=1u
X14560 DVDD GATE BAT DVDD pfet_06v0 ad=58.0754p pd=77.935u as=58.0754p ps=77.935u w=76.41499u l=1u
X14561 DVDD GATE BAT DVDD pfet_06v0 ad=58.1134p pd=77.985u as=58.1134p ps=77.985u w=76.465u l=1u
X14562 BAT GATE DVDD DVDD pfet_06v0 ad=35.511p pd=48.245u as=35.511p ps=48.245u w=46.725u l=1u
X14563 DVDD GATE BAT DVDD pfet_06v0 ad=43.9215p pd=95.32999u as=35.511p ps=48.245u w=46.725u l=1u
X14564 BAT GATE DVDD DVDD pfet_06v0 ad=58.1134p pd=77.985u as=58.1134p ps=77.985u w=76.465u l=1u
X14565 BAT GATE DVDD DVDD pfet_06v0 ad=58.1134p pd=77.985u as=58.1134p ps=77.985u w=76.465u l=1u
X14566 DVDD GATE BAT DVDD pfet_06v0 ad=49.3848p pd=66.5u as=49.3848p ps=66.5u w=64.98u l=1u
X14567 BAT GATE DVDD DVDD pfet_06v0 ad=49.3848p pd=66.5u as=61.0812p ps=0.13184m w=64.98u l=1u
X14568 BAT GATE DVDD DVDD pfet_06v0 ad=35.511p pd=48.245u as=35.511p ps=48.245u w=46.725u l=1u
X14569 DVDD GATE BAT DVDD pfet_06v0 ad=35.511p pd=48.245u as=35.511p ps=48.245u w=46.725u l=1u
X14570 BAT GATE DVDD DVDD pfet_06v0 ad=35.5072p pd=48.24u as=35.5072p ps=48.24u w=46.72u l=1u
X14571 BAT GATE DVDD DVDD pfet_06v0 ad=35.511p pd=48.245u as=35.511p ps=48.245u w=46.725u l=1u
X14572 BAT GATE DVDD DVDD pfet_06v0 ad=58.1552p pd=78.04u as=58.1552p ps=78.04u w=76.52u l=1u
X14573 DVDD GATE BAT DVDD pfet_06v0 ad=58.1134p pd=77.985u as=58.1134p ps=77.985u w=76.465u l=1u
X14574 DVDD GATE BAT DVDD pfet_06v0 ad=58.1134p pd=77.985u as=58.1134p ps=77.985u w=76.465u l=1u
X14575 DVDD GATE BAT DVDD pfet_06v0 ad=47.6862p pd=64.265u as=47.6862p ps=64.265u w=62.745u l=1u
X14576 DVDD GATE BAT DVDD pfet_06v0 ad=43.9215p pd=95.32999u as=35.511p ps=48.245u w=46.725u l=1u
X14577 DVDD GATE BAT DVDD pfet_06v0 ad=35.511p pd=48.245u as=35.511p ps=48.245u w=46.725u l=1u
X14578 BAT GATE DVDD DVDD pfet_06v0 ad=58.1172p pd=77.99u as=58.1172p ps=77.99u w=76.47u l=1u
X14579 DVDD GATE BAT DVDD pfet_06v0 ad=35.511p pd=48.245u as=35.511p ps=48.245u w=46.725u l=1u
X14580 DVDD GATE BAT DVDD pfet_06v0 ad=71.92879p pd=0.15492m as=58.1552p ps=78.04u w=76.52u l=1u
X14581 DVDD GATE BAT DVDD pfet_06v0 ad=58.1134p pd=77.985u as=58.1134p ps=77.985u w=76.465u l=1u
X14582 BAT GATE DVDD DVDD pfet_06v0 ad=35.511p pd=48.245u as=35.511p ps=48.245u w=46.725u l=1u
X14583 DVDD GATE BAT DVDD pfet_06v0 ad=43.9215p pd=95.32999u as=35.511p ps=48.245u w=46.725u l=1u
X14584 DVDD GATE BAT DVDD pfet_06v0 ad=35.511p pd=48.245u as=35.511p ps=48.245u w=46.725u l=1u
X14585 BAT GATE DVDD DVDD pfet_06v0 ad=58.1552p pd=78.04u as=58.1552p ps=78.04u w=76.52u l=1u
X14586 BAT GATE DVDD DVDD pfet_06v0 ad=35.511p pd=48.245u as=35.511p ps=48.245u w=46.725u l=1u
X14587 BAT GATE DVDD DVDD pfet_06v0 ad=35.511p pd=48.245u as=35.511p ps=48.245u w=46.725u l=1u
X14588 BAT GATE DVDD DVDD pfet_06v0 ad=58.1096p pd=77.98u as=71.8724p ps=0.1548m w=76.46u l=1u
X14589 BAT GATE DVDD DVDD pfet_06v0 ad=35.511p pd=48.245u as=35.511p ps=48.245u w=46.725u l=1u
X14590 DVDD GATE BAT DVDD pfet_06v0 ad=58.0754p pd=77.935u as=58.0754p ps=77.935u w=76.41499u l=1u
X14591 BAT GATE DVDD DVDD pfet_06v0 ad=49.3848p pd=66.5u as=49.3848p ps=66.5u w=64.98u l=1u
X14592 BAT GATE DVDD DVDD pfet_06v0 ad=35.511p pd=48.245u as=35.511p ps=48.245u w=46.725u l=1u
X14593 BAT GATE DVDD DVDD pfet_06v0 ad=35.511p pd=48.245u as=35.511p ps=48.245u w=46.725u l=1u
X14594 DVDD GATE BAT DVDD pfet_06v0 ad=43.9215p pd=95.32999u as=35.511p ps=48.245u w=46.725u l=1u
X14595 DVDD GATE BAT DVDD pfet_06v0 ad=35.511p pd=48.245u as=35.511p ps=48.245u w=46.725u l=1u
X14596 BAT GATE DVDD DVDD pfet_06v0 ad=35.511p pd=48.245u as=35.511p ps=48.245u w=46.725u l=1u
X14597 DVDD GATE BAT DVDD pfet_06v0 ad=35.511p pd=48.245u as=35.511p ps=48.245u w=46.725u l=1u
X14598 BAT GATE DVDD DVDD pfet_06v0 ad=49.3848p pd=66.5u as=49.3848p ps=66.5u w=64.98u l=1u
X14599 BAT GATE DVDD DVDD pfet_06v0 ad=35.511p pd=48.245u as=35.511p ps=48.245u w=46.725u l=1u
X14600 BAT GATE DVDD DVDD pfet_06v0 ad=58.1552p pd=78.04u as=58.1552p ps=78.04u w=76.52u l=1u
X14601 DVDD GATE BAT DVDD pfet_06v0 ad=58.1134p pd=77.985u as=58.1134p ps=77.985u w=76.465u l=1u
X14602 DVDD GATE BAT DVDD pfet_06v0 ad=35.511p pd=48.245u as=35.511p ps=48.245u w=46.725u l=1u
X14603 DVDD GATE BAT DVDD pfet_06v0 ad=47.6862p pd=64.265u as=47.6862p ps=64.265u w=62.745u l=1u
X14604 BAT GATE DVDD DVDD pfet_06v0 ad=35.511p pd=48.245u as=35.511p ps=48.245u w=46.725u l=1u
X14605 DVDD GATE BAT DVDD pfet_06v0 ad=58.1134p pd=77.985u as=58.1134p ps=77.985u w=76.465u l=1u
X14606 DVDD GATE BAT DVDD pfet_06v0 ad=35.511p pd=48.245u as=35.511p ps=48.245u w=46.725u l=1u
X14607 BAT GATE DVDD DVDD pfet_06v0 ad=58.1134p pd=77.985u as=71.8771p ps=0.15481m w=76.465u l=1u
X14608 DVDD GATE BAT DVDD pfet_06v0 ad=58.1134p pd=77.985u as=58.1134p ps=77.985u w=76.465u l=1u
X14609 BAT GATE DVDD DVDD pfet_06v0 ad=35.511p pd=48.245u as=43.9215p ps=95.32999u w=46.725u l=1u
X14610 DVDD GATE BAT DVDD pfet_06v0 ad=58.1096p pd=77.98u as=58.1096p ps=77.98u w=76.46u l=1u
X14611 BAT GATE DVDD DVDD pfet_06v0 ad=58.1172p pd=77.99u as=71.8818p ps=0.15482m w=76.47u l=1u
X14612 DVDD GATE BAT DVDD pfet_06v0 ad=35.511p pd=48.245u as=35.511p ps=48.245u w=46.725u l=1u
X14613 BAT GATE DVDD DVDD pfet_06v0 ad=58.1134p pd=77.985u as=58.1134p ps=77.985u w=76.465u l=1u
X14614 BAT GATE DVDD DVDD pfet_06v0 ad=35.511p pd=48.245u as=35.511p ps=48.245u w=46.725u l=1u
X14615 BAT GATE DVDD DVDD pfet_06v0 ad=58.1552p pd=78.04u as=58.1552p ps=78.04u w=76.52u l=1u
X14616 DVDD GATE BAT DVDD pfet_06v0 ad=35.511p pd=48.245u as=35.511p ps=48.245u w=46.725u l=1u
X14617 DVDD GATE BAT DVDD pfet_06v0 ad=35.511p pd=48.245u as=35.511p ps=48.245u w=46.725u l=1u
X14618 DVDD GATE BAT DVDD pfet_06v0 ad=58.1134p pd=77.985u as=58.1134p ps=77.985u w=76.465u l=1u
X14619 BAT GATE DVDD DVDD pfet_06v0 ad=35.5072p pd=48.24u as=35.5072p ps=48.24u w=46.72u l=1u
X14620 BAT GATE DVDD DVDD pfet_06v0 ad=58.1134p pd=77.985u as=58.1134p ps=77.985u w=76.465u l=1u
X14621 DVDD GATE BAT DVDD pfet_06v0 ad=49.3848p pd=66.5u as=49.3848p ps=66.5u w=64.98u l=1u
X14622 DVDD GATE BAT DVDD pfet_06v0 ad=35.511p pd=48.245u as=35.511p ps=48.245u w=46.725u l=1u
X14623 DVDD GATE BAT DVDD pfet_06v0 ad=58.0754p pd=77.935u as=58.0754p ps=77.935u w=76.41499u l=1u
X14624 DVDD GATE BAT DVDD pfet_06v0 ad=58.1134p pd=77.985u as=58.1134p ps=77.985u w=76.465u l=1u
X14625 BAT GATE DVDD DVDD pfet_06v0 ad=35.511p pd=48.245u as=43.9215p ps=95.32999u w=46.725u l=1u
X14626 DVDD GATE BAT DVDD pfet_06v0 ad=35.511p pd=48.245u as=35.511p ps=48.245u w=46.725u l=1u
X14627 DVDD GATE BAT DVDD pfet_06v0 ad=35.511p pd=48.245u as=35.511p ps=48.245u w=46.725u l=1u
X14628 BAT GATE DVDD DVDD pfet_06v0 ad=35.511p pd=48.245u as=35.511p ps=48.245u w=46.725u l=1u
X14629 DVDD GATE BAT DVDD pfet_06v0 ad=58.1552p pd=78.04u as=58.1552p ps=78.04u w=76.52u l=1u
X14630 BAT GATE DVDD DVDD pfet_06v0 ad=35.511p pd=48.245u as=35.511p ps=48.245u w=46.725u l=1u
X14631 BAT GATE DVDD DVDD pfet_06v0 ad=58.1134p pd=77.985u as=58.1134p ps=77.985u w=76.465u l=1u
X14632 DVDD GATE BAT DVDD pfet_06v0 ad=49.3848p pd=66.5u as=49.3848p ps=66.5u w=64.98u l=1u
X14633 BAT GATE DVDD DVDD pfet_06v0 ad=58.1552p pd=78.04u as=71.92879p ps=0.15492m w=76.52u l=1u
X14634 DVDD GATE BAT DVDD pfet_06v0 ad=58.1134p pd=77.985u as=58.1134p ps=77.985u w=76.465u l=1u
X14635 DVDD GATE BAT DVDD pfet_06v0 ad=35.511p pd=48.245u as=35.511p ps=48.245u w=46.725u l=1u
X14636 DVDD GATE BAT DVDD pfet_06v0 ad=35.511p pd=48.245u as=35.511p ps=48.245u w=46.725u l=1u
X14637 BAT GATE DVDD DVDD pfet_06v0 ad=35.511p pd=48.245u as=35.511p ps=48.245u w=46.725u l=1u
X14638 BAT GATE DVDD DVDD pfet_06v0 ad=58.1134p pd=77.985u as=58.1134p ps=77.985u w=76.465u l=1u
X14639 DVDD GATE BAT DVDD pfet_06v0 ad=35.511p pd=48.245u as=35.511p ps=48.245u w=46.725u l=1u
X14640 DVDD GATE BAT DVDD pfet_06v0 ad=58.1134p pd=77.985u as=58.1134p ps=77.985u w=76.465u l=1u
X14641 BAT GATE DVDD DVDD pfet_06v0 ad=35.511p pd=48.245u as=35.511p ps=48.245u w=46.725u l=1u
X14642 BAT GATE DVDD DVDD pfet_06v0 ad=58.1552p pd=78.04u as=58.1552p ps=78.04u w=76.52u l=1u
X14643 DVDD GATE BAT DVDD pfet_06v0 ad=58.1134p pd=77.985u as=58.1134p ps=77.985u w=76.465u l=1u
X14644 BAT GATE DVDD DVDD pfet_06v0 ad=58.0754p pd=77.935u as=58.0754p ps=77.935u w=76.41499u l=1u
X14645 BAT GATE DVDD DVDD pfet_06v0 ad=35.511p pd=48.245u as=35.511p ps=48.245u w=46.725u l=1u
X14646 DVDD GATE BAT DVDD pfet_06v0 ad=58.1172p pd=77.99u as=58.1172p ps=77.99u w=76.47u l=1u
X14647 DVDD GATE BAT DVDD pfet_06v0 ad=58.1096p pd=77.98u as=58.1096p ps=77.98u w=76.46u l=1u
X14648 DVDD GATE BAT DVDD pfet_06v0 ad=35.511p pd=48.245u as=35.511p ps=48.245u w=46.725u l=1u
X14649 DVDD GATE BAT DVDD pfet_06v0 ad=35.511p pd=48.245u as=35.511p ps=48.245u w=46.725u l=1u
X14650 DVDD GATE BAT DVDD pfet_06v0 ad=43.9215p pd=95.32999u as=35.511p ps=48.245u w=46.725u l=1u
X14651 BAT GATE DVDD DVDD pfet_06v0 ad=58.1134p pd=77.985u as=58.1134p ps=77.985u w=76.465u l=1u
X14652 DVDD GATE BAT DVDD pfet_06v0 ad=43.9215p pd=95.32999u as=35.511p ps=48.245u w=46.725u l=1u
X14653 DVDD GATE BAT DVDD pfet_06v0 ad=58.1552p pd=78.04u as=58.1552p ps=78.04u w=76.52u l=1u
X14654 BAT GATE DVDD DVDD pfet_06v0 ad=58.1134p pd=77.985u as=58.1134p ps=77.985u w=76.465u l=1u
X14655 DVDD GATE BAT DVDD pfet_06v0 ad=35.511p pd=48.245u as=35.511p ps=48.245u w=46.725u l=1u
X14656 BAT GATE DVDD DVDD pfet_06v0 ad=58.1134p pd=77.985u as=58.1134p ps=77.985u w=76.465u l=1u
X14657 DVDD GATE BAT DVDD pfet_06v0 ad=35.511p pd=48.245u as=35.511p ps=48.245u w=46.725u l=1u
X14658 DVDD GATE BAT DVDD pfet_06v0 ad=35.511p pd=48.245u as=35.511p ps=48.245u w=46.725u l=1u
X14659 BAT GATE DVDD DVDD pfet_06v0 ad=35.511p pd=48.245u as=35.511p ps=48.245u w=46.725u l=1u
X14660 BAT GATE DVDD DVDD pfet_06v0 ad=58.1096p pd=77.98u as=58.1096p ps=77.98u w=76.46u l=1u
X14661 DVDD GATE BAT DVDD pfet_06v0 ad=43.9215p pd=95.32999u as=35.511p ps=48.245u w=46.725u l=1u
X14662 BAT GATE DVDD DVDD pfet_06v0 ad=58.1134p pd=77.985u as=58.1134p ps=77.985u w=76.465u l=1u
X14663 BAT GATE DVDD DVDD pfet_06v0 ad=49.3848p pd=66.5u as=61.0812p ps=0.13184m w=64.98u l=1u
X14664 BAT GATE DVDD DVDD pfet_06v0 ad=47.6862p pd=64.265u as=47.6862p ps=64.265u w=62.745u l=1u
X14665 BAT GATE DVDD DVDD pfet_06v0 ad=35.511p pd=48.245u as=35.511p ps=48.245u w=46.725u l=1u
X14666 BAT GATE DVDD DVDD pfet_06v0 ad=35.511p pd=48.245u as=35.511p ps=48.245u w=46.725u l=1u
X14667 BAT GATE DVDD DVDD pfet_06v0 ad=35.511p pd=48.245u as=35.511p ps=48.245u w=46.725u l=1u
X14668 BAT GATE DVDD DVDD pfet_06v0 ad=35.511p pd=48.245u as=35.511p ps=48.245u w=46.725u l=1u
X14669 DVDD GATE BAT DVDD pfet_06v0 ad=35.511p pd=48.245u as=35.511p ps=48.245u w=46.725u l=1u
X14670 DVDD GATE BAT DVDD pfet_06v0 ad=71.8771p pd=0.15481m as=58.1134p ps=77.985u w=76.465u l=1u
X14671 BAT GATE DVDD DVDD pfet_06v0 ad=58.1134p pd=77.985u as=58.1134p ps=77.985u w=76.465u l=1u
X14672 BAT GATE DVDD DVDD pfet_06v0 ad=58.1134p pd=77.985u as=58.1134p ps=77.985u w=76.465u l=1u
X14673 BAT GATE DVDD DVDD pfet_06v0 ad=58.1134p pd=77.985u as=58.1134p ps=77.985u w=76.465u l=1u
X14674 BAT GATE DVDD DVDD pfet_06v0 ad=35.5072p pd=48.24u as=43.9168p ps=95.32u w=46.72u l=1u
X14675 DVDD GATE BAT DVDD pfet_06v0 ad=58.1172p pd=77.99u as=58.1172p ps=77.99u w=76.47u l=1u
X14676 BAT GATE DVDD DVDD pfet_06v0 ad=35.511p pd=48.245u as=35.511p ps=48.245u w=46.725u l=1u
X14677 BAT GATE DVDD DVDD pfet_06v0 ad=58.1134p pd=77.985u as=58.1134p ps=77.985u w=76.465u l=1u
X14678 DVDD GATE BAT DVDD pfet_06v0 ad=71.8771p pd=0.15481m as=58.1134p ps=77.985u w=76.465u l=1u
X14679 DVDD GATE BAT DVDD pfet_06v0 ad=71.8301p pd=0.15471m as=58.0754p ps=77.935u w=76.41499u l=1u
X14680 BAT GATE DVDD DVDD pfet_06v0 ad=58.1096p pd=77.98u as=58.1096p ps=77.98u w=76.46u l=1u
X14681 DVDD GATE BAT DVDD pfet_06v0 ad=35.511p pd=48.245u as=35.511p ps=48.245u w=46.725u l=1u
X14682 BAT GATE DVDD DVDD pfet_06v0 ad=35.511p pd=48.245u as=35.511p ps=48.245u w=46.725u l=1u
X14683 DVDD GATE BAT DVDD pfet_06v0 ad=58.1552p pd=78.04u as=58.1552p ps=78.04u w=76.52u l=1u
X14684 BAT GATE DVDD DVDD pfet_06v0 ad=58.0754p pd=77.935u as=58.0754p ps=77.935u w=76.41499u l=1u
X14685 DVDD GATE BAT DVDD pfet_06v0 ad=71.8818p pd=0.15482m as=58.1172p ps=77.99u w=76.47u l=1u
X14686 DVDD GATE BAT DVDD pfet_06v0 ad=35.511p pd=48.245u as=35.511p ps=48.245u w=46.725u l=1u
X14687 BAT GATE DVDD DVDD pfet_06v0 ad=35.511p pd=48.245u as=35.511p ps=48.245u w=46.725u l=1u
X14688 BAT GATE DVDD DVDD pfet_06v0 ad=35.511p pd=48.245u as=43.9215p ps=95.32999u w=46.725u l=1u
X14689 DVDD GATE BAT DVDD pfet_06v0 ad=35.5072p pd=48.24u as=35.5072p ps=48.24u w=46.72u l=1u
X14690 DVDD GATE BAT DVDD pfet_06v0 ad=35.511p pd=48.245u as=35.511p ps=48.245u w=46.725u l=1u
X14691 DVDD GATE BAT DVDD pfet_06v0 ad=35.511p pd=48.245u as=35.511p ps=48.245u w=46.725u l=1u
X14692 BAT GATE DVDD DVDD pfet_06v0 ad=35.511p pd=48.245u as=35.511p ps=48.245u w=46.725u l=1u
X14693 DVDD GATE BAT DVDD pfet_06v0 ad=71.8771p pd=0.15481m as=58.1134p ps=77.985u w=76.465u l=1u
X14694 BAT GATE DVDD DVDD pfet_06v0 ad=58.0754p pd=77.935u as=71.8301p ps=0.15471m w=76.41499u l=1u
X14695 BAT GATE DVDD DVDD pfet_06v0 ad=58.1134p pd=77.985u as=58.1134p ps=77.985u w=76.465u l=1u
X14696 BAT GATE DVDD DVDD pfet_06v0 ad=35.511p pd=48.245u as=35.511p ps=48.245u w=46.725u l=1u
X14697 BAT GATE DVDD DVDD pfet_06v0 ad=58.0754p pd=77.935u as=58.0754p ps=77.935u w=76.41499u l=1u
X14698 BAT GATE DVDD DVDD pfet_06v0 ad=58.1134p pd=77.985u as=58.1134p ps=77.985u w=76.465u l=1u
X14699 BAT GATE DVDD DVDD pfet_06v0 ad=58.1172p pd=77.99u as=58.1172p ps=77.99u w=76.47u l=1u
X14700 BAT GATE DVDD DVDD pfet_06v0 ad=58.0754p pd=77.935u as=58.0754p ps=77.935u w=76.41499u l=1u
X14701 BAT GATE DVDD DVDD pfet_06v0 ad=58.0754p pd=77.935u as=58.0754p ps=77.935u w=76.41499u l=1u
X14702 DVDD GATE BAT DVDD pfet_06v0 ad=35.511p pd=48.245u as=35.511p ps=48.245u w=46.725u l=1u
X14703 DVDD GATE BAT DVDD pfet_06v0 ad=35.511p pd=48.245u as=35.511p ps=48.245u w=46.725u l=1u
X14704 BAT GATE DVDD DVDD pfet_06v0 ad=35.511p pd=48.245u as=35.511p ps=48.245u w=46.725u l=1u
X14705 BAT GATE DVDD DVDD pfet_06v0 ad=58.1134p pd=77.985u as=58.1134p ps=77.985u w=76.465u l=1u
X14706 DVDD GATE BAT DVDD pfet_06v0 ad=58.1552p pd=78.04u as=58.1552p ps=78.04u w=76.52u l=1u
X14707 DVDD GATE BAT DVDD pfet_06v0 ad=35.511p pd=48.245u as=35.511p ps=48.245u w=46.725u l=1u
X14708 BAT GATE DVDD DVDD pfet_06v0 ad=58.1134p pd=77.985u as=58.1134p ps=77.985u w=76.465u l=1u
X14709 BAT GATE DVDD DVDD pfet_06v0 ad=58.1134p pd=77.985u as=58.1134p ps=77.985u w=76.465u l=1u
X14710 BAT GATE DVDD DVDD pfet_06v0 ad=47.6862p pd=64.265u as=58.9803p ps=0.12737m w=62.745u l=1u
X14711 BAT GATE DVDD DVDD pfet_06v0 ad=35.511p pd=48.245u as=35.511p ps=48.245u w=46.725u l=1u
X14712 DVDD GATE BAT DVDD pfet_06v0 ad=35.511p pd=48.245u as=35.511p ps=48.245u w=46.725u l=1u
X14713 DVDD GATE BAT DVDD pfet_06v0 ad=43.9215p pd=95.32999u as=35.511p ps=48.245u w=46.725u l=1u
X14714 DVDD GATE BAT DVDD pfet_06v0 ad=43.9215p pd=95.32999u as=35.511p ps=48.245u w=46.725u l=1u
X14715 BAT GATE DVDD DVDD pfet_06v0 ad=58.1134p pd=77.985u as=71.8771p ps=0.15481m w=76.465u l=1u
X14716 BAT GATE DVDD DVDD pfet_06v0 ad=35.511p pd=48.245u as=35.511p ps=48.245u w=46.725u l=1u
X14717 BAT GATE DVDD DVDD pfet_06v0 ad=58.1134p pd=77.985u as=71.8771p ps=0.15481m w=76.465u l=1u
X14718 BAT GATE DVDD DVDD pfet_06v0 ad=35.511p pd=48.245u as=35.511p ps=48.245u w=46.725u l=1u
X14719 DVDD GATE BAT DVDD pfet_06v0 ad=58.1134p pd=77.985u as=58.1134p ps=77.985u w=76.465u l=1u
X14720 DVDD GATE BAT DVDD pfet_06v0 ad=58.1552p pd=78.04u as=58.1552p ps=78.04u w=76.52u l=1u
X14721 DVDD GATE BAT DVDD pfet_06v0 ad=35.511p pd=48.245u as=35.511p ps=48.245u w=46.725u l=1u
X14722 BAT GATE DVDD DVDD pfet_06v0 ad=35.511p pd=48.245u as=35.511p ps=48.245u w=46.725u l=1u
X14723 BAT GATE DVDD DVDD pfet_06v0 ad=35.511p pd=48.245u as=43.9215p ps=95.32999u w=46.725u l=1u
X14724 BAT GATE DVDD DVDD pfet_06v0 ad=58.1552p pd=78.04u as=71.92879p ps=0.15492m w=76.52u l=1u
X14725 DVDD GATE BAT DVDD pfet_06v0 ad=58.1134p pd=77.985u as=58.1134p ps=77.985u w=76.465u l=1u
X14726 DVDD GATE BAT DVDD pfet_06v0 ad=43.9215p pd=95.32999u as=35.511p ps=48.245u w=46.725u l=1u
X14727 BAT GATE DVDD DVDD pfet_06v0 ad=35.511p pd=48.245u as=43.9215p ps=95.32999u w=46.725u l=1u
X14728 DVDD GATE BAT DVDD pfet_06v0 ad=43.9215p pd=95.32999u as=35.511p ps=48.245u w=46.725u l=1u
X14729 BAT GATE DVDD DVDD pfet_06v0 ad=58.1134p pd=77.985u as=58.1134p ps=77.985u w=76.465u l=1u
X14730 DVDD GATE BAT DVDD pfet_06v0 ad=58.1134p pd=77.985u as=58.1134p ps=77.985u w=76.465u l=1u
X14731 DVDD GATE BAT DVDD pfet_06v0 ad=58.1134p pd=77.985u as=58.1134p ps=77.985u w=76.465u l=1u
X14732 BAT GATE DVDD DVDD pfet_06v0 ad=58.0754p pd=77.935u as=58.0754p ps=77.935u w=76.41499u l=1u
X14733 DVDD GATE BAT DVDD pfet_06v0 ad=71.8771p pd=0.15481m as=58.1134p ps=77.985u w=76.465u l=1u
X14734 BAT GATE DVDD DVDD pfet_06v0 ad=49.3848p pd=66.5u as=49.3848p ps=66.5u w=64.98u l=1u
X14735 BAT GATE DVDD DVDD pfet_06v0 ad=35.511p pd=48.245u as=35.511p ps=48.245u w=46.725u l=1u
X14736 DVDD GATE BAT DVDD pfet_06v0 ad=58.1552p pd=78.04u as=58.1552p ps=78.04u w=76.52u l=1u
X14737 BAT GATE DVDD DVDD pfet_06v0 ad=35.511p pd=48.245u as=35.511p ps=48.245u w=46.725u l=1u
X14738 DVDD GATE BAT DVDD pfet_06v0 ad=58.9803p pd=0.12737m as=47.6862p ps=64.265u w=62.745u l=1u
X14739 BAT GATE DVDD DVDD pfet_06v0 ad=58.0754p pd=77.935u as=58.0754p ps=77.935u w=76.41499u l=1u
X14740 BAT GATE DVDD DVDD pfet_06v0 ad=58.1134p pd=77.985u as=58.1134p ps=77.985u w=76.465u l=1u
X14741 DVDD GATE BAT DVDD pfet_06v0 ad=58.1134p pd=77.985u as=58.1134p ps=77.985u w=76.465u l=1u
X14742 BAT GATE DVDD DVDD pfet_06v0 ad=35.511p pd=48.245u as=35.511p ps=48.245u w=46.725u l=1u
X14743 DVDD GATE BAT DVDD pfet_06v0 ad=35.511p pd=48.245u as=35.511p ps=48.245u w=46.725u l=1u
X14744 BAT GATE DVDD DVDD pfet_06v0 ad=58.1134p pd=77.985u as=58.1134p ps=77.985u w=76.465u l=1u
X14745 DVDD GATE BAT DVDD pfet_06v0 ad=58.1134p pd=77.985u as=58.1134p ps=77.985u w=76.465u l=1u
X14746 BAT GATE DVDD DVDD pfet_06v0 ad=35.511p pd=48.245u as=35.511p ps=48.245u w=46.725u l=1u
X14747 DVDD GATE BAT DVDD pfet_06v0 ad=58.1134p pd=77.985u as=58.1134p ps=77.985u w=76.465u l=1u
X14748 BAT GATE DVDD DVDD pfet_06v0 ad=35.511p pd=48.245u as=35.511p ps=48.245u w=46.725u l=1u
X14749 DVDD GATE BAT DVDD pfet_06v0 ad=43.9215p pd=95.32999u as=35.511p ps=48.245u w=46.725u l=1u
X14750 BAT GATE DVDD DVDD pfet_06v0 ad=58.1134p pd=77.985u as=58.1134p ps=77.985u w=76.465u l=1u
X14751 DVDD GATE BAT DVDD pfet_06v0 ad=35.511p pd=48.245u as=35.511p ps=48.245u w=46.725u l=1u
X14752 BAT GATE DVDD DVDD pfet_06v0 ad=58.1172p pd=77.99u as=58.1172p ps=77.99u w=76.47u l=1u
X14753 BAT GATE DVDD DVDD pfet_06v0 ad=58.1134p pd=77.985u as=58.1134p ps=77.985u w=76.465u l=1u
X14754 DVDD GATE BAT DVDD pfet_06v0 ad=43.9215p pd=95.32999u as=35.511p ps=48.245u w=46.725u l=1u
X14755 BAT GATE DVDD DVDD pfet_06v0 ad=58.1134p pd=77.985u as=58.1134p ps=77.985u w=76.465u l=1u
X14756 BAT GATE DVDD DVDD pfet_06v0 ad=35.511p pd=48.245u as=35.511p ps=48.245u w=46.725u l=1u
X14757 DVDD GATE BAT DVDD pfet_06v0 ad=58.1134p pd=77.985u as=58.1134p ps=77.985u w=76.465u l=1u
X14758 DVDD GATE BAT DVDD pfet_06v0 ad=71.8818p pd=0.15482m as=58.1172p ps=77.99u w=76.47u l=1u
X14759 BAT GATE DVDD DVDD pfet_06v0 ad=49.3848p pd=66.5u as=49.3848p ps=66.5u w=64.98u l=1u
X14760 BAT GATE DVDD DVDD pfet_06v0 ad=35.511p pd=48.245u as=35.511p ps=48.245u w=46.725u l=1u
X14761 DVDD GATE BAT DVDD pfet_06v0 ad=43.9215p pd=95.32999u as=35.511p ps=48.245u w=46.725u l=1u
X14762 BAT GATE DVDD DVDD pfet_06v0 ad=58.1096p pd=77.98u as=58.1096p ps=77.98u w=76.46u l=1u
X14763 DVDD GATE BAT DVDD pfet_06v0 ad=58.1134p pd=77.985u as=58.1134p ps=77.985u w=76.465u l=1u
X14764 DVDD GATE BAT DVDD pfet_06v0 ad=35.511p pd=48.245u as=35.511p ps=48.245u w=46.725u l=1u
X14765 DVDD GATE BAT DVDD pfet_06v0 ad=58.1172p pd=77.99u as=58.1172p ps=77.99u w=76.47u l=1u
X14766 DVDD GATE BAT DVDD pfet_06v0 ad=35.511p pd=48.245u as=35.511p ps=48.245u w=46.725u l=1u
X14767 DVDD GATE BAT DVDD pfet_06v0 ad=35.511p pd=48.245u as=35.511p ps=48.245u w=46.725u l=1u
X14768 DVDD GATE BAT DVDD pfet_06v0 ad=58.1134p pd=77.985u as=58.1134p ps=77.985u w=76.465u l=1u
X14769 DVDD GATE BAT DVDD pfet_06v0 ad=61.0812p pd=0.13184m as=49.3848p ps=66.5u w=64.98u l=1u
X14770 DVDD GATE BAT DVDD pfet_06v0 ad=58.0754p pd=77.935u as=58.0754p ps=77.935u w=76.41499u l=1u
X14771 DVDD GATE BAT DVDD pfet_06v0 ad=47.6862p pd=64.265u as=47.6862p ps=64.265u w=62.745u l=1u
X14772 DVDD GATE BAT DVDD pfet_06v0 ad=71.8818p pd=0.15482m as=58.1172p ps=77.99u w=76.47u l=1u
X14773 DVDD GATE BAT DVDD pfet_06v0 ad=35.511p pd=48.245u as=35.511p ps=48.245u w=46.725u l=1u
X14774 DVDD GATE BAT DVDD pfet_06v0 ad=35.511p pd=48.245u as=35.511p ps=48.245u w=46.725u l=1u
X14775 BAT GATE DVDD DVDD pfet_06v0 ad=58.1172p pd=77.99u as=58.1172p ps=77.99u w=76.47u l=1u
X14776 DVDD GATE BAT DVDD pfet_06v0 ad=58.1134p pd=77.985u as=58.1134p ps=77.985u w=76.465u l=1u
X14777 BAT GATE DVDD DVDD pfet_06v0 ad=58.0754p pd=77.935u as=58.0754p ps=77.935u w=76.41499u l=1u
X14778 BAT GATE DVDD DVDD pfet_06v0 ad=58.1096p pd=77.98u as=58.1096p ps=77.98u w=76.46u l=1u
X14779 DVDD GATE BAT DVDD pfet_06v0 ad=58.1134p pd=77.985u as=58.1134p ps=77.985u w=76.465u l=1u
X14780 DVDD GATE BAT DVDD pfet_06v0 ad=47.6862p pd=64.265u as=47.6862p ps=64.265u w=62.745u l=1u
X14781 DVDD GATE BAT DVDD pfet_06v0 ad=58.1134p pd=77.985u as=58.1134p ps=77.985u w=76.465u l=1u
X14782 DVDD GATE BAT DVDD pfet_06v0 ad=35.511p pd=48.245u as=35.511p ps=48.245u w=46.725u l=1u
X14783 DVDD GATE BAT DVDD pfet_06v0 ad=58.1134p pd=77.985u as=58.1134p ps=77.985u w=76.465u l=1u
X14784 BAT GATE DVDD DVDD pfet_06v0 ad=58.1134p pd=77.985u as=58.1134p ps=77.985u w=76.465u l=1u
X14785 DVDD GATE BAT DVDD pfet_06v0 ad=71.8771p pd=0.15481m as=58.1134p ps=77.985u w=76.465u l=1u
X14786 DVDD GATE BAT DVDD pfet_06v0 ad=43.9215p pd=95.32999u as=35.511p ps=48.245u w=46.725u l=1u
X14787 BAT GATE DVDD DVDD pfet_06v0 ad=35.5072p pd=48.24u as=35.5072p ps=48.24u w=46.72u l=1u
X14788 DVDD GATE BAT DVDD pfet_06v0 ad=58.1134p pd=77.985u as=58.1134p ps=77.985u w=76.465u l=1u
X14789 BAT GATE DVDD DVDD pfet_06v0 ad=35.511p pd=48.245u as=35.511p ps=48.245u w=46.725u l=1u
X14790 BAT GATE DVDD DVDD pfet_06v0 ad=58.1552p pd=78.04u as=58.1552p ps=78.04u w=76.52u l=1u
X14791 BAT GATE DVDD DVDD pfet_06v0 ad=58.1172p pd=77.99u as=58.1172p ps=77.99u w=76.47u l=1u
X14792 DVDD GATE BAT DVDD pfet_06v0 ad=35.511p pd=48.245u as=35.511p ps=48.245u w=46.725u l=1u
X14793 BAT GATE DVDD DVDD pfet_06v0 ad=35.511p pd=48.245u as=35.511p ps=48.245u w=46.725u l=1u
X14794 BAT GATE DVDD DVDD pfet_06v0 ad=35.5072p pd=48.24u as=35.5072p ps=48.24u w=46.72u l=1u
X14795 DVDD GATE BAT DVDD pfet_06v0 ad=35.511p pd=48.245u as=35.511p ps=48.245u w=46.725u l=1u
X14796 DVDD GATE BAT DVDD pfet_06v0 ad=58.1134p pd=77.985u as=58.1134p ps=77.985u w=76.465u l=1u
X14797 BAT GATE DVDD DVDD pfet_06v0 ad=35.511p pd=48.245u as=35.511p ps=48.245u w=46.725u l=1u
X14798 BAT GATE DVDD DVDD pfet_06v0 ad=35.511p pd=48.245u as=43.9215p ps=95.32999u w=46.725u l=1u
X14799 DVDD GATE BAT DVDD pfet_06v0 ad=58.1134p pd=77.985u as=58.1134p ps=77.985u w=76.465u l=1u
X14800 BAT GATE DVDD DVDD pfet_06v0 ad=47.6862p pd=64.265u as=58.9803p ps=0.12737m w=62.745u l=1u
X14801 BAT GATE DVDD DVDD pfet_06v0 ad=35.511p pd=48.245u as=35.511p ps=48.245u w=46.725u l=1u
X14802 BAT GATE DVDD DVDD pfet_06v0 ad=58.1552p pd=78.04u as=58.1552p ps=78.04u w=76.52u l=1u
X14803 DVDD GATE BAT DVDD pfet_06v0 ad=47.6862p pd=64.265u as=47.6862p ps=64.265u w=62.745u l=1u
X14804 DVDD GATE BAT DVDD pfet_06v0 ad=58.1134p pd=77.985u as=58.1134p ps=77.985u w=76.465u l=1u
X14805 DVDD GATE BAT DVDD pfet_06v0 ad=43.9215p pd=95.32999u as=35.511p ps=48.245u w=46.725u l=1u
X14806 DVDD GATE BAT DVDD pfet_06v0 ad=35.511p pd=48.245u as=35.511p ps=48.245u w=46.725u l=1u
X14807 BAT GATE DVDD DVDD pfet_06v0 ad=35.511p pd=48.245u as=35.511p ps=48.245u w=46.725u l=1u
X14808 BAT GATE DVDD DVDD pfet_06v0 ad=58.1134p pd=77.985u as=58.1134p ps=77.985u w=76.465u l=1u
X14809 DVDD GATE BAT DVDD pfet_06v0 ad=58.1134p pd=77.985u as=58.1134p ps=77.985u w=76.465u l=1u
X14810 BAT GATE DVDD DVDD pfet_06v0 ad=35.511p pd=48.245u as=43.9215p ps=95.32999u w=46.725u l=1u
X14811 DVDD GATE BAT DVDD pfet_06v0 ad=58.1134p pd=77.985u as=58.1134p ps=77.985u w=76.465u l=1u
X14812 DVDD GATE BAT DVDD pfet_06v0 ad=35.511p pd=48.245u as=35.511p ps=48.245u w=46.725u l=1u
X14813 BAT GATE DVDD DVDD pfet_06v0 ad=58.1096p pd=77.98u as=58.1096p ps=77.98u w=76.46u l=1u
X14814 DVDD GATE BAT DVDD pfet_06v0 ad=43.9215p pd=95.32999u as=35.511p ps=48.245u w=46.725u l=1u
X14815 BAT GATE DVDD DVDD pfet_06v0 ad=35.511p pd=48.245u as=35.511p ps=48.245u w=46.725u l=1u
X14816 BAT GATE DVDD DVDD pfet_06v0 ad=58.1134p pd=77.985u as=58.1134p ps=77.985u w=76.465u l=1u
X14817 DVDD GATE BAT DVDD pfet_06v0 ad=35.511p pd=48.245u as=35.511p ps=48.245u w=46.725u l=1u
X14818 BAT GATE DVDD DVDD pfet_06v0 ad=35.511p pd=48.245u as=35.511p ps=48.245u w=46.725u l=1u
X14819 DVDD GATE BAT DVDD pfet_06v0 ad=71.8771p pd=0.15481m as=58.1134p ps=77.985u w=76.465u l=1u
X14820 DVDD GATE BAT DVDD pfet_06v0 ad=71.8771p pd=0.15481m as=58.1134p ps=77.985u w=76.465u l=1u
X14821 DVDD GATE BAT DVDD pfet_06v0 ad=35.511p pd=48.245u as=35.511p ps=48.245u w=46.725u l=1u
X14822 BAT GATE DVDD DVDD pfet_06v0 ad=35.5072p pd=48.24u as=35.5072p ps=48.24u w=46.72u l=1u
X14823 BAT GATE DVDD DVDD pfet_06v0 ad=35.511p pd=48.245u as=35.511p ps=48.245u w=46.725u l=1u
X14824 BAT GATE DVDD DVDD pfet_06v0 ad=35.511p pd=48.245u as=35.511p ps=48.245u w=46.725u l=1u
X14825 DVDD GATE BAT DVDD pfet_06v0 ad=35.511p pd=48.245u as=35.511p ps=48.245u w=46.725u l=1u
X14826 BAT GATE DVDD DVDD pfet_06v0 ad=35.511p pd=48.245u as=35.511p ps=48.245u w=46.725u l=1u
X14827 DVDD GATE BAT DVDD pfet_06v0 ad=49.3848p pd=66.5u as=49.3848p ps=66.5u w=64.98u l=1u
X14828 BAT GATE DVDD DVDD pfet_06v0 ad=58.1134p pd=77.985u as=58.1134p ps=77.985u w=76.465u l=1u
X14829 DVDD GATE BAT DVDD pfet_06v0 ad=35.511p pd=48.245u as=35.511p ps=48.245u w=46.725u l=1u
X14830 DVDD GATE BAT DVDD pfet_06v0 ad=35.511p pd=48.245u as=35.511p ps=48.245u w=46.725u l=1u
X14831 BAT GATE DVDD DVDD pfet_06v0 ad=58.1134p pd=77.985u as=58.1134p ps=77.985u w=76.465u l=1u
X14832 BAT GATE DVDD DVDD pfet_06v0 ad=35.511p pd=48.245u as=35.511p ps=48.245u w=46.725u l=1u
X14833 DVDD GATE BAT DVDD pfet_06v0 ad=71.8771p pd=0.15481m as=58.1134p ps=77.985u w=76.465u l=1u
X14834 BAT GATE DVDD DVDD pfet_06v0 ad=35.511p pd=48.245u as=35.511p ps=48.245u w=46.725u l=1u
X14835 DVDD GATE BAT DVDD pfet_06v0 ad=35.511p pd=48.245u as=35.511p ps=48.245u w=46.725u l=1u
X14836 DVDD GATE BAT DVDD pfet_06v0 ad=49.3848p pd=66.5u as=49.3848p ps=66.5u w=64.98u l=1u
X14837 BAT GATE DVDD DVDD pfet_06v0 ad=58.1134p pd=77.985u as=71.8771p ps=0.15481m w=76.465u l=1u
X14838 BAT GATE DVDD DVDD pfet_06v0 ad=58.1134p pd=77.985u as=58.1134p ps=77.985u w=76.465u l=1u
X14839 DVDD GATE BAT DVDD pfet_06v0 ad=58.0754p pd=77.935u as=58.0754p ps=77.935u w=76.41499u l=1u
X14840 BAT GATE DVDD DVDD pfet_06v0 ad=47.6862p pd=64.265u as=47.6862p ps=64.265u w=62.745u l=1u
X14841 DVDD GATE BAT DVDD pfet_06v0 ad=58.1134p pd=77.985u as=58.1134p ps=77.985u w=76.465u l=1u
X14842 BAT GATE DVDD DVDD pfet_06v0 ad=35.511p pd=48.245u as=35.511p ps=48.245u w=46.725u l=1u
X14843 DVDD GATE BAT DVDD pfet_06v0 ad=58.1172p pd=77.99u as=58.1172p ps=77.99u w=76.47u l=1u
X14844 BAT GATE DVDD DVDD pfet_06v0 ad=35.511p pd=48.245u as=35.511p ps=48.245u w=46.725u l=1u
X14845 DVDD GATE BAT DVDD pfet_06v0 ad=58.0754p pd=77.935u as=58.0754p ps=77.935u w=76.41499u l=1u
X14846 BAT GATE DVDD DVDD pfet_06v0 ad=58.1134p pd=77.985u as=58.1134p ps=77.985u w=76.465u l=1u
X14847 BAT GATE DVDD DVDD pfet_06v0 ad=35.511p pd=48.245u as=43.9215p ps=95.32999u w=46.725u l=1u
X14848 DVDD GATE BAT DVDD pfet_06v0 ad=35.511p pd=48.245u as=35.511p ps=48.245u w=46.725u l=1u
X14849 BAT GATE DVDD DVDD pfet_06v0 ad=35.511p pd=48.245u as=35.511p ps=48.245u w=46.725u l=1u
X14850 BAT GATE DVDD DVDD pfet_06v0 ad=58.1134p pd=77.985u as=58.1134p ps=77.985u w=76.465u l=1u
X14851 BAT GATE DVDD DVDD pfet_06v0 ad=58.1134p pd=77.985u as=58.1134p ps=77.985u w=76.465u l=1u
X14852 BAT GATE DVDD DVDD pfet_06v0 ad=58.1134p pd=77.985u as=71.8771p ps=0.15481m w=76.465u l=1u
X14853 DVDD GATE BAT DVDD pfet_06v0 ad=58.1134p pd=77.985u as=58.1134p ps=77.985u w=76.465u l=1u
X14854 BAT GATE DVDD DVDD pfet_06v0 ad=58.1134p pd=77.985u as=58.1134p ps=77.985u w=76.465u l=1u
X14855 BAT GATE DVDD DVDD pfet_06v0 ad=35.511p pd=48.245u as=35.511p ps=48.245u w=46.725u l=1u
X14856 BAT GATE DVDD DVDD pfet_06v0 ad=35.511p pd=48.245u as=35.511p ps=48.245u w=46.725u l=1u
X14857 DVDD GATE BAT DVDD pfet_06v0 ad=35.511p pd=48.245u as=35.511p ps=48.245u w=46.725u l=1u
X14858 DVDD GATE BAT DVDD pfet_06v0 ad=58.1134p pd=77.985u as=58.1134p ps=77.985u w=76.465u l=1u
X14859 BAT GATE DVDD DVDD pfet_06v0 ad=35.5072p pd=48.24u as=35.5072p ps=48.24u w=46.72u l=1u
X14860 DVDD GATE BAT DVDD pfet_06v0 ad=58.1134p pd=77.985u as=58.1134p ps=77.985u w=76.465u l=1u
X14861 BAT GATE DVDD DVDD pfet_06v0 ad=58.1552p pd=78.04u as=58.1552p ps=78.04u w=76.52u l=1u
X14862 BAT GATE DVDD DVDD pfet_06v0 ad=58.1134p pd=77.985u as=71.8771p ps=0.15481m w=76.465u l=1u
X14863 DVDD GATE BAT DVDD pfet_06v0 ad=35.511p pd=48.245u as=35.511p ps=48.245u w=46.725u l=1u
X14864 BAT GATE DVDD DVDD pfet_06v0 ad=35.511p pd=48.245u as=35.511p ps=48.245u w=46.725u l=1u
X14865 DVDD GATE BAT DVDD pfet_06v0 ad=58.1134p pd=77.985u as=58.1134p ps=77.985u w=76.465u l=1u
X14866 BAT GATE DVDD DVDD pfet_06v0 ad=49.3848p pd=66.5u as=49.3848p ps=66.5u w=64.98u l=1u
X14867 BAT GATE DVDD DVDD pfet_06v0 ad=58.1134p pd=77.985u as=58.1134p ps=77.985u w=76.465u l=1u
X14868 BAT GATE DVDD DVDD pfet_06v0 ad=35.511p pd=48.245u as=35.511p ps=48.245u w=46.725u l=1u
X14869 BAT GATE DVDD DVDD pfet_06v0 ad=58.1172p pd=77.99u as=58.1172p ps=77.99u w=76.47u l=1u
X14870 DVDD GATE BAT DVDD pfet_06v0 ad=58.1134p pd=77.985u as=58.1134p ps=77.985u w=76.465u l=1u
X14871 DVDD GATE BAT DVDD pfet_06v0 ad=35.511p pd=48.245u as=35.511p ps=48.245u w=46.725u l=1u
X14872 BAT GATE DVDD DVDD pfet_06v0 ad=58.1134p pd=77.985u as=58.1134p ps=77.985u w=76.465u l=1u
X14873 BAT GATE DVDD DVDD pfet_06v0 ad=58.1172p pd=77.99u as=71.8818p ps=0.15482m w=76.47u l=1u
X14874 DVDD GATE BAT DVDD pfet_06v0 ad=35.511p pd=48.245u as=35.511p ps=48.245u w=46.725u l=1u
X14875 BAT GATE DVDD DVDD pfet_06v0 ad=35.511p pd=48.245u as=35.511p ps=48.245u w=46.725u l=1u
X14876 DVDD GATE BAT DVDD pfet_06v0 ad=58.1134p pd=77.985u as=58.1134p ps=77.985u w=76.465u l=1u
X14877 BAT GATE DVDD DVDD pfet_06v0 ad=58.1096p pd=77.98u as=71.8724p ps=0.1548m w=76.46u l=1u
X14878 BAT GATE DVDD DVDD pfet_06v0 ad=35.511p pd=48.245u as=35.511p ps=48.245u w=46.725u l=1u
X14879 BAT GATE DVDD DVDD pfet_06v0 ad=35.511p pd=48.245u as=35.511p ps=48.245u w=46.725u l=1u
X14880 BAT GATE DVDD DVDD pfet_06v0 ad=35.511p pd=48.245u as=35.511p ps=48.245u w=46.725u l=1u
X14881 BAT GATE DVDD DVDD pfet_06v0 ad=58.1134p pd=77.985u as=58.1134p ps=77.985u w=76.465u l=1u
X14882 BAT GATE DVDD DVDD pfet_06v0 ad=58.1134p pd=77.985u as=71.8771p ps=0.15481m w=76.465u l=1u
X14883 DVDD GATE BAT DVDD pfet_06v0 ad=35.511p pd=48.245u as=35.511p ps=48.245u w=46.725u l=1u
X14884 BAT GATE DVDD DVDD pfet_06v0 ad=58.1134p pd=77.985u as=71.8771p ps=0.15481m w=76.465u l=1u
X14885 DVDD GATE BAT DVDD pfet_06v0 ad=58.1096p pd=77.98u as=58.1096p ps=77.98u w=76.46u l=1u
X14886 BAT GATE DVDD DVDD pfet_06v0 ad=35.511p pd=48.245u as=35.511p ps=48.245u w=46.725u l=1u
X14887 BAT GATE DVDD DVDD pfet_06v0 ad=35.511p pd=48.245u as=35.511p ps=48.245u w=46.725u l=1u
X14888 BAT GATE DVDD DVDD pfet_06v0 ad=35.511p pd=48.245u as=35.511p ps=48.245u w=46.725u l=1u
X14889 DVDD GATE BAT DVDD pfet_06v0 ad=35.511p pd=48.245u as=35.511p ps=48.245u w=46.725u l=1u
X14890 BAT GATE DVDD DVDD pfet_06v0 ad=35.5072p pd=48.24u as=35.5072p ps=48.24u w=46.72u l=1u
X14891 BAT GATE DVDD DVDD pfet_06v0 ad=58.1134p pd=77.985u as=58.1134p ps=77.985u w=76.465u l=1u
X14892 DVDD GATE BAT DVDD pfet_06v0 ad=35.511p pd=48.245u as=35.511p ps=48.245u w=46.725u l=1u
X14893 DVDD GATE BAT DVDD pfet_06v0 ad=43.9215p pd=95.32999u as=35.511p ps=48.245u w=46.725u l=1u
X14894 DVDD GATE BAT DVDD pfet_06v0 ad=35.511p pd=48.245u as=35.511p ps=48.245u w=46.725u l=1u
X14895 DVDD GATE BAT DVDD pfet_06v0 ad=35.511p pd=48.245u as=35.511p ps=48.245u w=46.725u l=1u
X14896 DVDD GATE BAT DVDD pfet_06v0 ad=35.511p pd=48.245u as=35.511p ps=48.245u w=46.725u l=1u
X14897 DVDD GATE BAT DVDD pfet_06v0 ad=58.1134p pd=77.985u as=58.1134p ps=77.985u w=76.465u l=1u
X14898 DVDD GATE BAT DVDD pfet_06v0 ad=43.9215p pd=95.32999u as=35.511p ps=48.245u w=46.725u l=1u
X14899 DVDD GATE BAT DVDD pfet_06v0 ad=35.511p pd=48.245u as=35.511p ps=48.245u w=46.725u l=1u
X14900 BAT GATE DVDD DVDD pfet_06v0 ad=58.1172p pd=77.99u as=71.8818p ps=0.15482m w=76.47u l=1u
X14901 DVDD GATE BAT DVDD pfet_06v0 ad=35.511p pd=48.245u as=35.511p ps=48.245u w=46.725u l=1u
X14902 DVDD GATE BAT DVDD pfet_06v0 ad=43.9215p pd=95.32999u as=35.511p ps=48.245u w=46.725u l=1u
X14903 DVDD GATE BAT DVDD pfet_06v0 ad=35.511p pd=48.245u as=35.511p ps=48.245u w=46.725u l=1u
X14904 BAT GATE DVDD DVDD pfet_06v0 ad=35.511p pd=48.245u as=35.511p ps=48.245u w=46.725u l=1u
X14905 DVDD GATE BAT DVDD pfet_06v0 ad=71.8771p pd=0.15481m as=58.1134p ps=77.985u w=76.465u l=1u
X14906 BAT GATE DVDD DVDD pfet_06v0 ad=58.0754p pd=77.935u as=58.0754p ps=77.935u w=76.41499u l=1u
X14907 BAT GATE DVDD DVDD pfet_06v0 ad=35.511p pd=48.245u as=35.511p ps=48.245u w=46.725u l=1u
X14908 DVDD GATE BAT DVDD pfet_06v0 ad=35.511p pd=48.245u as=35.511p ps=48.245u w=46.725u l=1u
X14909 DVDD GATE BAT DVDD pfet_06v0 ad=35.511p pd=48.245u as=35.511p ps=48.245u w=46.725u l=1u
X14910 DVDD GATE BAT DVDD pfet_06v0 ad=35.511p pd=48.245u as=35.511p ps=48.245u w=46.725u l=1u
X14911 DVDD GATE BAT DVDD pfet_06v0 ad=35.511p pd=48.245u as=35.511p ps=48.245u w=46.725u l=1u
X14912 BAT GATE DVDD DVDD pfet_06v0 ad=35.511p pd=48.245u as=43.9215p ps=95.32999u w=46.725u l=1u
X14913 DVDD GATE BAT DVDD pfet_06v0 ad=35.5072p pd=48.24u as=35.5072p ps=48.24u w=46.72u l=1u
X14914 BAT GATE DVDD DVDD pfet_06v0 ad=35.511p pd=48.245u as=43.9215p ps=95.32999u w=46.725u l=1u
X14915 BAT GATE DVDD DVDD pfet_06v0 ad=35.511p pd=48.245u as=43.9215p ps=95.32999u w=46.725u l=1u
X14916 BAT GATE DVDD DVDD pfet_06v0 ad=35.511p pd=48.245u as=35.511p ps=48.245u w=46.725u l=1u
X14917 BAT GATE DVDD DVDD pfet_06v0 ad=58.1134p pd=77.985u as=58.1134p ps=77.985u w=76.465u l=1u
X14918 DVDD GATE BAT DVDD pfet_06v0 ad=35.511p pd=48.245u as=35.511p ps=48.245u w=46.725u l=1u
X14919 BAT GATE DVDD DVDD pfet_06v0 ad=58.1134p pd=77.985u as=58.1134p ps=77.985u w=76.465u l=1u
X14920 BAT GATE DVDD DVDD pfet_06v0 ad=35.511p pd=48.245u as=35.511p ps=48.245u w=46.725u l=1u
X14921 BAT GATE DVDD DVDD pfet_06v0 ad=49.3848p pd=66.5u as=49.3848p ps=66.5u w=64.98u l=1u
X14922 DVDD GATE BAT DVDD pfet_06v0 ad=58.0754p pd=77.935u as=58.0754p ps=77.935u w=76.41499u l=1u
X14923 BAT GATE DVDD DVDD pfet_06v0 ad=58.1134p pd=77.985u as=58.1134p ps=77.985u w=76.465u l=1u
X14924 BAT GATE DVDD DVDD pfet_06v0 ad=35.511p pd=48.245u as=35.511p ps=48.245u w=46.725u l=1u
X14925 DVDD GATE BAT DVDD pfet_06v0 ad=58.1172p pd=77.99u as=58.1172p ps=77.99u w=76.47u l=1u
X14926 DVDD GATE BAT DVDD pfet_06v0 ad=71.8771p pd=0.15481m as=58.1134p ps=77.985u w=76.465u l=1u
X14927 DVDD GATE BAT DVDD pfet_06v0 ad=35.511p pd=48.245u as=35.511p ps=48.245u w=46.725u l=1u
X14928 BAT GATE DVDD DVDD pfet_06v0 ad=35.511p pd=48.245u as=43.9215p ps=95.32999u w=46.725u l=1u
X14929 DVDD GATE BAT DVDD pfet_06v0 ad=35.511p pd=48.245u as=35.511p ps=48.245u w=46.725u l=1u
X14930 BAT GATE DVDD DVDD pfet_06v0 ad=49.3848p pd=66.5u as=49.3848p ps=66.5u w=64.98u l=1u
X14931 BAT GATE DVDD DVDD pfet_06v0 ad=35.511p pd=48.245u as=43.9215p ps=95.32999u w=46.725u l=1u
X14932 BAT GATE DVDD DVDD pfet_06v0 ad=35.511p pd=48.245u as=35.511p ps=48.245u w=46.725u l=1u
X14933 BAT GATE DVDD DVDD pfet_06v0 ad=58.1552p pd=78.04u as=58.1552p ps=78.04u w=76.52u l=1u
X14934 DVDD GATE BAT DVDD pfet_06v0 ad=58.1134p pd=77.985u as=58.1134p ps=77.985u w=76.465u l=1u
X14935 BAT GATE DVDD DVDD pfet_06v0 ad=58.1134p pd=77.985u as=58.1134p ps=77.985u w=76.465u l=1u
X14936 DVDD GATE BAT DVDD pfet_06v0 ad=58.1134p pd=77.985u as=58.1134p ps=77.985u w=76.465u l=1u
X14937 DVDD GATE BAT DVDD pfet_06v0 ad=35.511p pd=48.245u as=35.511p ps=48.245u w=46.725u l=1u
X14938 BAT GATE DVDD DVDD pfet_06v0 ad=35.511p pd=48.245u as=35.511p ps=48.245u w=46.725u l=1u
X14939 DVDD GATE BAT DVDD pfet_06v0 ad=47.6862p pd=64.265u as=47.6862p ps=64.265u w=62.745u l=1u
X14940 DVDD GATE BAT DVDD pfet_06v0 ad=58.1134p pd=77.985u as=58.1134p ps=77.985u w=76.465u l=1u
X14941 DVDD GATE BAT DVDD pfet_06v0 ad=58.1134p pd=77.985u as=58.1134p ps=77.985u w=76.465u l=1u
X14942 DVDD GATE BAT DVDD pfet_06v0 ad=58.1172p pd=77.99u as=58.1172p ps=77.99u w=76.47u l=1u
X14943 BAT GATE DVDD DVDD pfet_06v0 ad=58.0754p pd=77.935u as=58.0754p ps=77.935u w=76.41499u l=1u
X14944 BAT GATE DVDD DVDD pfet_06v0 ad=58.1134p pd=77.985u as=58.1134p ps=77.985u w=76.465u l=1u
X14945 BAT GATE DVDD DVDD pfet_06v0 ad=58.1552p pd=78.04u as=71.92879p ps=0.15492m w=76.52u l=1u
X14946 DVDD GATE BAT DVDD pfet_06v0 ad=35.511p pd=48.245u as=35.511p ps=48.245u w=46.725u l=1u
X14947 DVDD GATE BAT DVDD pfet_06v0 ad=58.1134p pd=77.985u as=58.1134p ps=77.985u w=76.465u l=1u
X14948 BAT GATE DVDD DVDD pfet_06v0 ad=58.1134p pd=77.985u as=58.1134p ps=77.985u w=76.465u l=1u
X14949 BAT GATE DVDD DVDD pfet_06v0 ad=35.5072p pd=48.24u as=43.9168p ps=95.32u w=46.72u l=1u
X14950 DVDD GATE BAT DVDD pfet_06v0 ad=58.1134p pd=77.985u as=58.1134p ps=77.985u w=76.465u l=1u
X14951 BAT GATE DVDD DVDD pfet_06v0 ad=58.1134p pd=77.985u as=71.8771p ps=0.15481m w=76.465u l=1u
X14952 DVDD GATE BAT DVDD pfet_06v0 ad=35.511p pd=48.245u as=35.511p ps=48.245u w=46.725u l=1u
X14953 DVDD GATE BAT DVDD pfet_06v0 ad=49.3848p pd=66.5u as=49.3848p ps=66.5u w=64.98u l=1u
X14954 BAT GATE DVDD DVDD pfet_06v0 ad=49.3848p pd=66.5u as=49.3848p ps=66.5u w=64.98u l=1u
X14955 DVDD GATE BAT DVDD pfet_06v0 ad=58.0754p pd=77.935u as=58.0754p ps=77.935u w=76.41499u l=1u
X14956 BAT GATE DVDD DVDD pfet_06v0 ad=58.1134p pd=77.985u as=58.1134p ps=77.985u w=76.465u l=1u
X14957 BAT GATE DVDD DVDD pfet_06v0 ad=35.511p pd=48.245u as=35.511p ps=48.245u w=46.725u l=1u
X14958 DVDD GATE BAT DVDD pfet_06v0 ad=35.511p pd=48.245u as=35.511p ps=48.245u w=46.725u l=1u
X14959 DVDD GATE BAT DVDD pfet_06v0 ad=58.1552p pd=78.04u as=58.1552p ps=78.04u w=76.52u l=1u
X14960 BAT GATE DVDD DVDD pfet_06v0 ad=35.511p pd=48.245u as=43.9215p ps=95.32999u w=46.725u l=1u
X14961 BAT GATE DVDD DVDD pfet_06v0 ad=35.511p pd=48.245u as=35.511p ps=48.245u w=46.725u l=1u
X14962 DVDD GATE BAT DVDD pfet_06v0 ad=58.1134p pd=77.985u as=58.1134p ps=77.985u w=76.465u l=1u
X14963 DVDD GATE BAT DVDD pfet_06v0 ad=71.92879p pd=0.15492m as=58.1552p ps=78.04u w=76.52u l=1u
X14964 BAT GATE DVDD DVDD pfet_06v0 ad=58.1134p pd=77.985u as=58.1134p ps=77.985u w=76.465u l=1u
X14965 DVDD GATE BAT DVDD pfet_06v0 ad=35.511p pd=48.245u as=35.511p ps=48.245u w=46.725u l=1u
X14966 DVDD GATE BAT DVDD pfet_06v0 ad=35.511p pd=48.245u as=35.511p ps=48.245u w=46.725u l=1u
X14967 BAT GATE DVDD DVDD pfet_06v0 ad=35.511p pd=48.245u as=43.9215p ps=95.32999u w=46.725u l=1u
X14968 BAT GATE DVDD DVDD pfet_06v0 ad=58.1134p pd=77.985u as=58.1134p ps=77.985u w=76.465u l=1u
X14969 DVDD GATE BAT DVDD pfet_06v0 ad=71.8301p pd=0.15471m as=58.0754p ps=77.935u w=76.41499u l=1u
X14970 BAT GATE DVDD DVDD pfet_06v0 ad=35.511p pd=48.245u as=35.511p ps=48.245u w=46.725u l=1u
X14971 BAT GATE DVDD DVDD pfet_06v0 ad=35.511p pd=48.245u as=43.9215p ps=95.32999u w=46.725u l=1u
X14972 BAT GATE DVDD DVDD pfet_06v0 ad=35.511p pd=48.245u as=35.511p ps=48.245u w=46.725u l=1u
X14973 BAT GATE DVDD DVDD pfet_06v0 ad=35.511p pd=48.245u as=35.511p ps=48.245u w=46.725u l=1u
X14974 DVDD GATE BAT DVDD pfet_06v0 ad=58.1172p pd=77.99u as=58.1172p ps=77.99u w=76.47u l=1u
X14975 BAT GATE DVDD DVDD pfet_06v0 ad=35.511p pd=48.245u as=35.511p ps=48.245u w=46.725u l=1u
X14976 DVDD GATE BAT DVDD pfet_06v0 ad=35.511p pd=48.245u as=35.511p ps=48.245u w=46.725u l=1u
X14977 BAT GATE DVDD DVDD pfet_06v0 ad=47.6862p pd=64.265u as=47.6862p ps=64.265u w=62.745u l=1u
X14978 DVDD GATE BAT DVDD pfet_06v0 ad=35.511p pd=48.245u as=35.511p ps=48.245u w=46.725u l=1u
X14979 DVDD GATE BAT DVDD pfet_06v0 ad=35.511p pd=48.245u as=35.511p ps=48.245u w=46.725u l=1u
X14980 BAT GATE DVDD DVDD pfet_06v0 ad=58.1134p pd=77.985u as=58.1134p ps=77.985u w=76.465u l=1u
X14981 DVDD GATE BAT DVDD pfet_06v0 ad=35.511p pd=48.245u as=35.511p ps=48.245u w=46.725u l=1u
X14982 DVDD GATE BAT DVDD pfet_06v0 ad=58.1552p pd=78.04u as=58.1552p ps=78.04u w=76.52u l=1u
X14983 DVDD GATE BAT DVDD pfet_06v0 ad=35.511p pd=48.245u as=35.511p ps=48.245u w=46.725u l=1u
X14984 DVDD GATE BAT DVDD pfet_06v0 ad=35.511p pd=48.245u as=35.511p ps=48.245u w=46.725u l=1u
X14985 BAT GATE DVDD DVDD pfet_06v0 ad=58.1134p pd=77.985u as=58.1134p ps=77.985u w=76.465u l=1u
X14986 BAT GATE DVDD DVDD pfet_06v0 ad=35.511p pd=48.245u as=35.511p ps=48.245u w=46.725u l=1u
X14987 BAT GATE DVDD DVDD pfet_06v0 ad=58.1096p pd=77.98u as=58.1096p ps=77.98u w=76.46u l=1u
X14988 DVDD GATE BAT DVDD pfet_06v0 ad=35.511p pd=48.245u as=35.511p ps=48.245u w=46.725u l=1u
X14989 BAT GATE DVDD DVDD pfet_06v0 ad=35.511p pd=48.245u as=35.511p ps=48.245u w=46.725u l=1u
X14990 BAT GATE DVDD DVDD pfet_06v0 ad=47.6862p pd=64.265u as=47.6862p ps=64.265u w=62.745u l=1u
X14991 DVDD GATE BAT DVDD pfet_06v0 ad=43.9215p pd=95.32999u as=35.511p ps=48.245u w=46.725u l=1u
X14992 BAT GATE DVDD DVDD pfet_06v0 ad=58.1172p pd=77.99u as=58.1172p ps=77.99u w=76.47u l=1u
X14993 BAT GATE DVDD DVDD pfet_06v0 ad=35.511p pd=48.245u as=43.9215p ps=95.32999u w=46.725u l=1u
X14994 BAT GATE DVDD DVDD pfet_06v0 ad=35.511p pd=48.245u as=35.511p ps=48.245u w=46.725u l=1u
X14995 BAT GATE DVDD DVDD pfet_06v0 ad=35.511p pd=48.245u as=35.511p ps=48.245u w=46.725u l=1u
X14996 BAT GATE DVDD DVDD pfet_06v0 ad=35.511p pd=48.245u as=35.511p ps=48.245u w=46.725u l=1u
X14997 DVDD GATE BAT DVDD pfet_06v0 ad=58.1134p pd=77.985u as=58.1134p ps=77.985u w=76.465u l=1u
X14998 DVDD GATE BAT DVDD pfet_06v0 ad=71.92879p pd=0.15492m as=58.1552p ps=78.04u w=76.52u l=1u
X14999 DVDD GATE BAT DVDD pfet_06v0 ad=35.511p pd=48.245u as=35.511p ps=48.245u w=46.725u l=1u
X15000 DVDD GATE BAT DVDD pfet_06v0 ad=43.9215p pd=95.32999u as=35.511p ps=48.245u w=46.725u l=1u
X15001 DVDD GATE BAT DVDD pfet_06v0 ad=58.1134p pd=77.985u as=58.1134p ps=77.985u w=76.465u l=1u
X15002 BAT GATE DVDD DVDD pfet_06v0 ad=58.1134p pd=77.985u as=58.1134p ps=77.985u w=76.465u l=1u
X15003 BAT GATE DVDD DVDD pfet_06v0 ad=47.6862p pd=64.265u as=47.6862p ps=64.265u w=62.745u l=1u
X15004 BAT GATE DVDD DVDD pfet_06v0 ad=58.1134p pd=77.985u as=71.8771p ps=0.15481m w=76.465u l=1u
X15005 BAT GATE DVDD DVDD pfet_06v0 ad=35.511p pd=48.245u as=35.511p ps=48.245u w=46.725u l=1u
X15006 BAT GATE DVDD DVDD pfet_06v0 ad=58.1134p pd=77.985u as=71.8771p ps=0.15481m w=76.465u l=1u
X15007 BAT GATE DVDD DVDD pfet_06v0 ad=35.511p pd=48.245u as=35.511p ps=48.245u w=46.725u l=1u
X15008 DVDD GATE BAT DVDD pfet_06v0 ad=71.8771p pd=0.15481m as=58.1134p ps=77.985u w=76.465u l=1u
X15009 BAT GATE DVDD DVDD pfet_06v0 ad=35.511p pd=48.245u as=35.511p ps=48.245u w=46.725u l=1u
X15010 BAT GATE DVDD DVDD pfet_06v0 ad=58.1134p pd=77.985u as=58.1134p ps=77.985u w=76.465u l=1u
X15011 DVDD GATE BAT DVDD pfet_06v0 ad=58.0754p pd=77.935u as=58.0754p ps=77.935u w=76.41499u l=1u
X15012 BAT GATE DVDD DVDD pfet_06v0 ad=58.1134p pd=77.985u as=58.1134p ps=77.985u w=76.465u l=1u
X15013 BAT GATE DVDD DVDD pfet_06v0 ad=35.511p pd=48.245u as=35.511p ps=48.245u w=46.725u l=1u
X15014 DVDD GATE BAT DVDD pfet_06v0 ad=58.1134p pd=77.985u as=58.1134p ps=77.985u w=76.465u l=1u
X15015 DVDD GATE BAT DVDD pfet_06v0 ad=35.511p pd=48.245u as=35.511p ps=48.245u w=46.725u l=1u
X15016 BAT GATE DVDD DVDD pfet_06v0 ad=35.511p pd=48.245u as=35.511p ps=48.245u w=46.725u l=1u
X15017 BAT GATE DVDD DVDD pfet_06v0 ad=58.1096p pd=77.98u as=58.1096p ps=77.98u w=76.46u l=1u
X15018 BAT GATE DVDD DVDD pfet_06v0 ad=35.511p pd=48.245u as=35.511p ps=48.245u w=46.725u l=1u
X15019 DVDD GATE BAT DVDD pfet_06v0 ad=58.1172p pd=77.99u as=58.1172p ps=77.99u w=76.47u l=1u
X15020 DVDD GATE BAT DVDD pfet_06v0 ad=58.1172p pd=77.99u as=58.1172p ps=77.99u w=76.47u l=1u
X15021 BAT GATE DVDD DVDD pfet_06v0 ad=35.511p pd=48.245u as=35.511p ps=48.245u w=46.725u l=1u
X15022 DVDD GATE BAT DVDD pfet_06v0 ad=58.1552p pd=78.04u as=58.1552p ps=78.04u w=76.52u l=1u
X15023 DVDD GATE BAT DVDD pfet_06v0 ad=35.5072p pd=48.24u as=35.5072p ps=48.24u w=46.72u l=1u
X15024 BAT GATE DVDD DVDD pfet_06v0 ad=35.511p pd=48.245u as=35.511p ps=48.245u w=46.725u l=1u
X15025 DVDD GATE BAT DVDD pfet_06v0 ad=35.511p pd=48.245u as=35.511p ps=48.245u w=46.725u l=1u
X15026 DVDD GATE BAT DVDD pfet_06v0 ad=58.1134p pd=77.985u as=58.1134p ps=77.985u w=76.465u l=1u
X15027 BAT GATE DVDD DVDD pfet_06v0 ad=35.511p pd=48.245u as=43.9215p ps=95.32999u w=46.725u l=1u
X15028 BAT GATE DVDD DVDD pfet_06v0 ad=58.1134p pd=77.985u as=58.1134p ps=77.985u w=76.465u l=1u
X15029 BAT GATE DVDD DVDD pfet_06v0 ad=58.1134p pd=77.985u as=71.8771p ps=0.15481m w=76.465u l=1u
X15030 BAT GATE DVDD DVDD pfet_06v0 ad=35.511p pd=48.245u as=35.511p ps=48.245u w=46.725u l=1u
X15031 DVDD GATE BAT DVDD pfet_06v0 ad=58.1134p pd=77.985u as=58.1134p ps=77.985u w=76.465u l=1u
X15032 BAT GATE DVDD DVDD pfet_06v0 ad=58.0754p pd=77.935u as=71.8301p ps=0.15471m w=76.41499u l=1u
X15033 BAT GATE DVDD DVDD pfet_06v0 ad=47.6862p pd=64.265u as=47.6862p ps=64.265u w=62.745u l=1u
X15034 DVDD GATE BAT DVDD pfet_06v0 ad=43.9215p pd=95.32999u as=35.511p ps=48.245u w=46.725u l=1u
X15035 BAT GATE DVDD DVDD pfet_06v0 ad=58.1134p pd=77.985u as=58.1134p ps=77.985u w=76.465u l=1u
X15036 BAT GATE DVDD DVDD pfet_06v0 ad=58.1172p pd=77.99u as=71.8818p ps=0.15482m w=76.47u l=1u
X15037 DVDD GATE BAT DVDD pfet_06v0 ad=58.1134p pd=77.985u as=58.1134p ps=77.985u w=76.465u l=1u
X15038 BAT GATE DVDD DVDD pfet_06v0 ad=35.511p pd=48.245u as=43.9215p ps=95.32999u w=46.725u l=1u
X15039 BAT GATE DVDD DVDD pfet_06v0 ad=58.1134p pd=77.985u as=71.8771p ps=0.15481m w=76.465u l=1u
X15040 DVDD GATE BAT DVDD pfet_06v0 ad=58.1552p pd=78.04u as=58.1552p ps=78.04u w=76.52u l=1u
X15041 BAT GATE DVDD DVDD pfet_06v0 ad=58.1134p pd=77.985u as=71.8771p ps=0.15481m w=76.465u l=1u
X15042 BAT GATE DVDD DVDD pfet_06v0 ad=35.511p pd=48.245u as=35.511p ps=48.245u w=46.725u l=1u
X15043 BAT GATE DVDD DVDD pfet_06v0 ad=58.1134p pd=77.985u as=58.1134p ps=77.985u w=76.465u l=1u
X15044 BAT GATE DVDD DVDD pfet_06v0 ad=35.511p pd=48.245u as=35.511p ps=48.245u w=46.725u l=1u
X15045 DVDD GATE BAT DVDD pfet_06v0 ad=35.511p pd=48.245u as=35.511p ps=48.245u w=46.725u l=1u
X15046 DVDD GATE BAT DVDD pfet_06v0 ad=71.8771p pd=0.15481m as=58.1134p ps=77.985u w=76.465u l=1u
X15047 DVDD GATE BAT DVDD pfet_06v0 ad=35.511p pd=48.245u as=35.511p ps=48.245u w=46.725u l=1u
X15048 DVDD GATE BAT DVDD pfet_06v0 ad=58.1552p pd=78.04u as=58.1552p ps=78.04u w=76.52u l=1u
X15049 DVDD GATE BAT DVDD pfet_06v0 ad=58.1134p pd=77.985u as=58.1134p ps=77.985u w=76.465u l=1u
X15050 BAT GATE DVDD DVDD pfet_06v0 ad=58.1134p pd=77.985u as=58.1134p ps=77.985u w=76.465u l=1u
X15051 DVDD GATE BAT DVDD pfet_06v0 ad=35.511p pd=48.245u as=35.511p ps=48.245u w=46.725u l=1u
X15052 BAT GATE DVDD DVDD pfet_06v0 ad=58.1134p pd=77.985u as=58.1134p ps=77.985u w=76.465u l=1u
X15053 DVDD GATE BAT DVDD pfet_06v0 ad=58.0754p pd=77.935u as=58.0754p ps=77.935u w=76.41499u l=1u
X15054 BAT GATE DVDD DVDD pfet_06v0 ad=58.1096p pd=77.98u as=58.1096p ps=77.98u w=76.46u l=1u
X15055 DVDD GATE BAT DVDD pfet_06v0 ad=58.1134p pd=77.985u as=58.1134p ps=77.985u w=76.465u l=1u
X15056 DVDD GATE BAT DVDD pfet_06v0 ad=58.1134p pd=77.985u as=58.1134p ps=77.985u w=76.465u l=1u
X15057 DVDD GATE BAT DVDD pfet_06v0 ad=35.511p pd=48.245u as=35.511p ps=48.245u w=46.725u l=1u
X15058 BAT GATE DVDD DVDD pfet_06v0 ad=35.511p pd=48.245u as=43.9215p ps=95.32999u w=46.725u l=1u
X15059 BAT GATE DVDD DVDD pfet_06v0 ad=35.511p pd=48.245u as=35.511p ps=48.245u w=46.725u l=1u
X15060 DVDD GATE BAT DVDD pfet_06v0 ad=58.1134p pd=77.985u as=58.1134p ps=77.985u w=76.465u l=1u
X15061 DVDD GATE BAT DVDD pfet_06v0 ad=35.511p pd=48.245u as=35.511p ps=48.245u w=46.725u l=1u
X15062 BAT GATE DVDD DVDD pfet_06v0 ad=58.1134p pd=77.985u as=58.1134p ps=77.985u w=76.465u l=1u
X15063 DVDD GATE BAT DVDD pfet_06v0 ad=71.8818p pd=0.15482m as=58.1172p ps=77.99u w=76.47u l=1u
X15064 DVDD GATE BAT DVDD pfet_06v0 ad=49.3848p pd=66.5u as=49.3848p ps=66.5u w=64.98u l=1u
X15065 DVDD GATE BAT DVDD pfet_06v0 ad=58.1134p pd=77.985u as=58.1134p ps=77.985u w=76.465u l=1u
X15066 BAT GATE DVDD DVDD pfet_06v0 ad=58.0754p pd=77.935u as=71.8301p ps=0.15471m w=76.41499u l=1u
X15067 DVDD GATE BAT DVDD pfet_06v0 ad=58.1134p pd=77.985u as=58.1134p ps=77.985u w=76.465u l=1u
X15068 BAT GATE DVDD DVDD pfet_06v0 ad=49.3848p pd=66.5u as=49.3848p ps=66.5u w=64.98u l=1u
X15069 BAT GATE DVDD DVDD pfet_06v0 ad=35.511p pd=48.245u as=35.511p ps=48.245u w=46.725u l=1u
X15070 BAT GATE DVDD DVDD pfet_06v0 ad=35.511p pd=48.245u as=35.511p ps=48.245u w=46.725u l=1u
X15071 DVDD GATE BAT DVDD pfet_06v0 ad=47.6862p pd=64.265u as=47.6862p ps=64.265u w=62.745u l=1u
X15072 BAT GATE DVDD DVDD pfet_06v0 ad=58.1134p pd=77.985u as=58.1134p ps=77.985u w=76.465u l=1u
X15073 BAT GATE DVDD DVDD pfet_06v0 ad=58.0754p pd=77.935u as=58.0754p ps=77.935u w=76.41499u l=1u
X15074 DVDD GATE BAT DVDD pfet_06v0 ad=35.511p pd=48.245u as=35.511p ps=48.245u w=46.725u l=1u
X15075 DVDD GATE BAT DVDD pfet_06v0 ad=43.9215p pd=95.32999u as=35.511p ps=48.245u w=46.725u l=1u
X15076 BAT GATE DVDD DVDD pfet_06v0 ad=35.511p pd=48.245u as=43.9215p ps=95.32999u w=46.725u l=1u
X15077 DVDD GATE BAT DVDD pfet_06v0 ad=35.511p pd=48.245u as=35.511p ps=48.245u w=46.725u l=1u
X15078 BAT GATE DVDD DVDD pfet_06v0 ad=35.511p pd=48.245u as=35.511p ps=48.245u w=46.725u l=1u
X15079 BAT GATE DVDD DVDD pfet_06v0 ad=35.511p pd=48.245u as=35.511p ps=48.245u w=46.725u l=1u
X15080 DVDD GATE BAT DVDD pfet_06v0 ad=58.1134p pd=77.985u as=58.1134p ps=77.985u w=76.465u l=1u
X15081 DVDD GATE BAT DVDD pfet_06v0 ad=58.1134p pd=77.985u as=58.1134p ps=77.985u w=76.465u l=1u
X15082 DVDD GATE BAT DVDD pfet_06v0 ad=35.511p pd=48.245u as=35.511p ps=48.245u w=46.725u l=1u
X15083 DVDD GATE BAT DVDD pfet_06v0 ad=35.5072p pd=48.24u as=35.5072p ps=48.24u w=46.72u l=1u
X15084 DVDD GATE BAT DVDD pfet_06v0 ad=35.511p pd=48.245u as=35.511p ps=48.245u w=46.725u l=1u
X15085 BAT GATE DVDD DVDD pfet_06v0 ad=58.1172p pd=77.99u as=58.1172p ps=77.99u w=76.47u l=1u
X15086 BAT GATE DVDD DVDD pfet_06v0 ad=58.1134p pd=77.985u as=58.1134p ps=77.985u w=76.465u l=1u
X15087 DVDD GATE BAT DVDD pfet_06v0 ad=35.511p pd=48.245u as=35.511p ps=48.245u w=46.725u l=1u
X15088 DVDD GATE BAT DVDD pfet_06v0 ad=71.8771p pd=0.15481m as=58.1134p ps=77.985u w=76.465u l=1u
X15089 BAT GATE DVDD DVDD pfet_06v0 ad=35.511p pd=48.245u as=35.511p ps=48.245u w=46.725u l=1u
X15090 DVDD GATE BAT DVDD pfet_06v0 ad=47.6862p pd=64.265u as=47.6862p ps=64.265u w=62.745u l=1u
X15091 BAT GATE DVDD DVDD pfet_06v0 ad=49.3848p pd=66.5u as=61.0812p ps=0.13184m w=64.98u l=1u
X15092 BAT GATE DVDD DVDD pfet_06v0 ad=35.511p pd=48.245u as=43.9215p ps=95.32999u w=46.725u l=1u
X15093 BAT GATE DVDD DVDD pfet_06v0 ad=35.511p pd=48.245u as=35.511p ps=48.245u w=46.725u l=1u
X15094 DVDD GATE BAT DVDD pfet_06v0 ad=35.511p pd=48.245u as=35.511p ps=48.245u w=46.725u l=1u
X15095 BAT GATE DVDD DVDD pfet_06v0 ad=58.1096p pd=77.98u as=58.1096p ps=77.98u w=76.46u l=1u
X15096 DVDD GATE BAT DVDD pfet_06v0 ad=35.5072p pd=48.24u as=35.5072p ps=48.24u w=46.72u l=1u
X15097 DVDD GATE BAT DVDD pfet_06v0 ad=35.511p pd=48.245u as=35.511p ps=48.245u w=46.725u l=1u
X15098 DVDD GATE BAT DVDD pfet_06v0 ad=58.1172p pd=77.99u as=58.1172p ps=77.99u w=76.47u l=1u
X15099 DVDD GATE BAT DVDD pfet_06v0 ad=58.1134p pd=77.985u as=58.1134p ps=77.985u w=76.465u l=1u
X15100 DVDD GATE BAT DVDD pfet_06v0 ad=35.511p pd=48.245u as=35.511p ps=48.245u w=46.725u l=1u
X15101 DVDD GATE BAT DVDD pfet_06v0 ad=58.1134p pd=77.985u as=58.1134p ps=77.985u w=76.465u l=1u
X15102 DVDD GATE BAT DVDD pfet_06v0 ad=49.3848p pd=66.5u as=49.3848p ps=66.5u w=64.98u l=1u
X15103 DVDD GATE BAT DVDD pfet_06v0 ad=58.0754p pd=77.935u as=58.0754p ps=77.935u w=76.41499u l=1u
X15104 BAT GATE DVDD DVDD pfet_06v0 ad=35.511p pd=48.245u as=35.511p ps=48.245u w=46.725u l=1u
X15105 BAT GATE DVDD DVDD pfet_06v0 ad=58.1134p pd=77.985u as=58.1134p ps=77.985u w=76.465u l=1u
X15106 BAT GATE DVDD DVDD pfet_06v0 ad=35.511p pd=48.245u as=35.511p ps=48.245u w=46.725u l=1u
X15107 BAT GATE DVDD DVDD pfet_06v0 ad=35.511p pd=48.245u as=35.511p ps=48.245u w=46.725u l=1u
X15108 BAT GATE DVDD DVDD pfet_06v0 ad=58.1172p pd=77.99u as=58.1172p ps=77.99u w=76.47u l=1u
X15109 BAT GATE DVDD DVDD pfet_06v0 ad=35.511p pd=48.245u as=35.511p ps=48.245u w=46.725u l=1u
X15110 DVDD GATE BAT DVDD pfet_06v0 ad=58.1134p pd=77.985u as=58.1134p ps=77.985u w=76.465u l=1u
X15111 BAT GATE DVDD DVDD pfet_06v0 ad=58.1552p pd=78.04u as=58.1552p ps=78.04u w=76.52u l=1u
X15112 DVDD GATE BAT DVDD pfet_06v0 ad=58.1096p pd=77.98u as=58.1096p ps=77.98u w=76.46u l=1u
X15113 DVDD GATE BAT DVDD pfet_06v0 ad=58.1134p pd=77.985u as=58.1134p ps=77.985u w=76.465u l=1u
X15114 DVDD GATE BAT DVDD pfet_06v0 ad=47.6862p pd=64.265u as=47.6862p ps=64.265u w=62.745u l=1u
X15115 BAT GATE DVDD DVDD pfet_06v0 ad=58.1134p pd=77.985u as=58.1134p ps=77.985u w=76.465u l=1u
X15116 DVDD GATE BAT DVDD pfet_06v0 ad=58.1134p pd=77.985u as=58.1134p ps=77.985u w=76.465u l=1u
X15117 BAT GATE DVDD DVDD pfet_06v0 ad=58.1134p pd=77.985u as=58.1134p ps=77.985u w=76.465u l=1u
X15118 DVDD GATE BAT DVDD pfet_06v0 ad=35.511p pd=48.245u as=35.511p ps=48.245u w=46.725u l=1u
X15119 DVDD GATE BAT DVDD pfet_06v0 ad=35.511p pd=48.245u as=35.511p ps=48.245u w=46.725u l=1u
X15120 DVDD GATE BAT DVDD pfet_06v0 ad=35.511p pd=48.245u as=35.511p ps=48.245u w=46.725u l=1u
X15121 BAT GATE DVDD DVDD pfet_06v0 ad=35.511p pd=48.245u as=43.9215p ps=95.32999u w=46.725u l=1u
X15122 BAT GATE DVDD DVDD pfet_06v0 ad=58.1552p pd=78.04u as=58.1552p ps=78.04u w=76.52u l=1u
X15123 DVDD GATE BAT DVDD pfet_06v0 ad=58.1134p pd=77.985u as=58.1134p ps=77.985u w=76.465u l=1u
X15124 DVDD GATE BAT DVDD pfet_06v0 ad=35.511p pd=48.245u as=35.511p ps=48.245u w=46.725u l=1u
X15125 BAT GATE DVDD DVDD pfet_06v0 ad=58.1172p pd=77.99u as=58.1172p ps=77.99u w=76.47u l=1u
X15126 BAT GATE DVDD DVDD pfet_06v0 ad=58.1172p pd=77.99u as=58.1172p ps=77.99u w=76.47u l=1u
X15127 DVDD GATE BAT DVDD pfet_06v0 ad=43.9215p pd=95.32999u as=35.511p ps=48.245u w=46.725u l=1u
X15128 BAT GATE DVDD DVDD pfet_06v0 ad=58.0754p pd=77.935u as=71.8301p ps=0.15471m w=76.41499u l=1u
X15129 BAT GATE DVDD DVDD pfet_06v0 ad=35.511p pd=48.245u as=35.511p ps=48.245u w=46.725u l=1u
X15130 BAT GATE DVDD DVDD pfet_06v0 ad=35.5072p pd=48.24u as=35.5072p ps=48.24u w=46.72u l=1u
X15131 BAT GATE DVDD DVDD pfet_06v0 ad=35.511p pd=48.245u as=35.511p ps=48.245u w=46.725u l=1u
X15132 DVDD GATE BAT DVDD pfet_06v0 ad=58.1134p pd=77.985u as=58.1134p ps=77.985u w=76.465u l=1u
X15133 DVDD GATE BAT DVDD pfet_06v0 ad=49.3848p pd=66.5u as=49.3848p ps=66.5u w=64.98u l=1u
X15134 DVDD GATE BAT DVDD pfet_06v0 ad=35.511p pd=48.245u as=35.511p ps=48.245u w=46.725u l=1u
X15135 BAT GATE DVDD DVDD pfet_06v0 ad=58.1552p pd=78.04u as=58.1552p ps=78.04u w=76.52u l=1u
X15136 DVDD GATE BAT DVDD pfet_06v0 ad=58.0754p pd=77.935u as=58.0754p ps=77.935u w=76.41499u l=1u
X15137 DVDD GATE BAT DVDD pfet_06v0 ad=58.1134p pd=77.985u as=58.1134p ps=77.985u w=76.465u l=1u
X15138 DVDD GATE BAT DVDD pfet_06v0 ad=35.511p pd=48.245u as=35.511p ps=48.245u w=46.725u l=1u
X15139 DVDD GATE BAT DVDD pfet_06v0 ad=71.8771p pd=0.15481m as=58.1134p ps=77.985u w=76.465u l=1u
X15140 BAT GATE DVDD DVDD pfet_06v0 ad=58.1134p pd=77.985u as=58.1134p ps=77.985u w=76.465u l=1u
X15141 BAT GATE DVDD DVDD pfet_06v0 ad=35.511p pd=48.245u as=43.9215p ps=95.32999u w=46.725u l=1u
X15142 BAT GATE DVDD DVDD pfet_06v0 ad=58.1096p pd=77.98u as=58.1096p ps=77.98u w=76.46u l=1u
X15143 BAT GATE DVDD DVDD pfet_06v0 ad=58.1134p pd=77.985u as=58.1134p ps=77.985u w=76.465u l=1u
X15144 BAT GATE DVDD DVDD pfet_06v0 ad=58.1096p pd=77.98u as=71.8724p ps=0.1548m w=76.46u l=1u
X15145 BAT GATE DVDD DVDD pfet_06v0 ad=35.511p pd=48.245u as=35.511p ps=48.245u w=46.725u l=1u
X15146 BAT GATE DVDD DVDD pfet_06v0 ad=58.1134p pd=77.985u as=71.8771p ps=0.15481m w=76.465u l=1u
X15147 DVDD GATE BAT DVDD pfet_06v0 ad=58.1134p pd=77.985u as=58.1134p ps=77.985u w=76.465u l=1u
X15148 DVDD GATE BAT DVDD pfet_06v0 ad=35.511p pd=48.245u as=35.511p ps=48.245u w=46.725u l=1u
X15149 DVDD GATE BAT DVDD pfet_06v0 ad=71.8818p pd=0.15482m as=58.1172p ps=77.99u w=76.47u l=1u
X15150 DVDD GATE BAT DVDD pfet_06v0 ad=58.1172p pd=77.99u as=58.1172p ps=77.99u w=76.47u l=1u
X15151 DVDD GATE BAT DVDD pfet_06v0 ad=58.1134p pd=77.985u as=58.1134p ps=77.985u w=76.465u l=1u
X15152 BAT GATE DVDD DVDD pfet_06v0 ad=35.511p pd=48.245u as=43.9215p ps=95.32999u w=46.725u l=1u
X15153 BAT GATE DVDD DVDD pfet_06v0 ad=35.511p pd=48.245u as=35.511p ps=48.245u w=46.725u l=1u
X15154 BAT GATE DVDD DVDD pfet_06v0 ad=35.5072p pd=48.24u as=35.5072p ps=48.24u w=46.72u l=1u
X15155 BAT GATE DVDD DVDD pfet_06v0 ad=35.511p pd=48.245u as=35.511p ps=48.245u w=46.725u l=1u
X15156 BAT GATE DVDD DVDD pfet_06v0 ad=58.1134p pd=77.985u as=58.1134p ps=77.985u w=76.465u l=1u
X15157 DVDD GATE BAT DVDD pfet_06v0 ad=35.511p pd=48.245u as=35.511p ps=48.245u w=46.725u l=1u
X15158 DVDD GATE BAT DVDD pfet_06v0 ad=49.3848p pd=66.5u as=49.3848p ps=66.5u w=64.98u l=1u
X15159 BAT GATE DVDD DVDD pfet_06v0 ad=58.1134p pd=77.985u as=71.8771p ps=0.15481m w=76.465u l=1u
X15160 BAT GATE DVDD DVDD pfet_06v0 ad=58.1134p pd=77.985u as=58.1134p ps=77.985u w=76.465u l=1u
X15161 DVDD GATE BAT DVDD pfet_06v0 ad=35.511p pd=48.245u as=35.511p ps=48.245u w=46.725u l=1u
X15162 BAT GATE DVDD DVDD pfet_06v0 ad=35.511p pd=48.245u as=35.511p ps=48.245u w=46.725u l=1u
X15163 DVDD GATE BAT DVDD pfet_06v0 ad=49.3848p pd=66.5u as=49.3848p ps=66.5u w=64.98u l=1u
X15164 DVDD GATE BAT DVDD pfet_06v0 ad=35.511p pd=48.245u as=35.511p ps=48.245u w=46.725u l=1u
X15165 DVDD GATE BAT DVDD pfet_06v0 ad=35.5072p pd=48.24u as=35.5072p ps=48.24u w=46.72u l=1u
X15166 DVDD GATE BAT DVDD pfet_06v0 ad=35.511p pd=48.245u as=35.511p ps=48.245u w=46.725u l=1u
X15167 BAT GATE DVDD DVDD pfet_06v0 ad=47.6862p pd=64.265u as=47.6862p ps=64.265u w=62.745u l=1u
X15168 BAT GATE DVDD DVDD pfet_06v0 ad=58.1134p pd=77.985u as=58.1134p ps=77.985u w=76.465u l=1u
X15169 BAT GATE DVDD DVDD pfet_06v0 ad=58.1134p pd=77.985u as=58.1134p ps=77.985u w=76.465u l=1u
X15170 DVDD GATE BAT DVDD pfet_06v0 ad=71.8771p pd=0.15481m as=58.1134p ps=77.985u w=76.465u l=1u
X15171 BAT GATE DVDD DVDD pfet_06v0 ad=35.511p pd=48.245u as=35.511p ps=48.245u w=46.725u l=1u
X15172 BAT GATE DVDD DVDD pfet_06v0 ad=58.1134p pd=77.985u as=58.1134p ps=77.985u w=76.465u l=1u
X15173 BAT GATE DVDD DVDD pfet_06v0 ad=58.1134p pd=77.985u as=58.1134p ps=77.985u w=76.465u l=1u
X15174 BAT GATE DVDD DVDD pfet_06v0 ad=47.6862p pd=64.265u as=47.6862p ps=64.265u w=62.745u l=1u
X15175 BAT GATE DVDD DVDD pfet_06v0 ad=58.1134p pd=77.985u as=58.1134p ps=77.985u w=76.465u l=1u
X15176 BAT GATE DVDD DVDD pfet_06v0 ad=47.6862p pd=64.265u as=47.6862p ps=64.265u w=62.745u l=1u
X15177 BAT GATE DVDD DVDD pfet_06v0 ad=35.5072p pd=48.24u as=35.5072p ps=48.24u w=46.72u l=1u
X15178 DVDD GATE BAT DVDD pfet_06v0 ad=58.1134p pd=77.985u as=58.1134p ps=77.985u w=76.465u l=1u
X15179 BAT GATE DVDD DVDD pfet_06v0 ad=58.1134p pd=77.985u as=58.1134p ps=77.985u w=76.465u l=1u
C0 DVDD DVSS 0.29489n
.ends
