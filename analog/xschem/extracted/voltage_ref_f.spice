* NGSPICE file created from flattened.ext - technology: gf180mcuD

.subckt voltage_ref_f VDD VSS VREF
X0 VDD a_1049_3632# VREF VDD pfet_06v0 ad=4.4p pd=20.88u as=4.4p ps=20.88u w=10u l=5u
X1 VDD a_1049_3632# a_1049_3632# VDD pfet_06v0 ad=4.4p pd=20.88u as=4.4p ps=20.88u w=10u l=5u
X2 a_1097_2487# a_1097_2487# a_3517_2399# VSS.t4 nfet_06v0 ad=4.4p pd=20.88u as=4.4p ps=20.88u w=10u l=2.5u
D0 a_2251_1915# VSS.t5 diode_pd2nw_06v0 pj=12u area=5p
D1 a_5881_2807# VSS diode_pd2nw_06v0 pj=12u area=5p
X3 a_1129_1915# a_2251_1915# VSS ppolyf_u_1k_6p0 r_width=1u r_length=5u
X4 VDD a_1049_3632# a_1097_2487# VDD pfet_06v0 ad=4.4p pd=20.88u as=4.4p ps=20.88u w=10u l=5u
D2 a_3517_2399# VSS diode_pd2nw_06v0 pj=12u area=5p
X5 a_5881_2807# VREF VSS.t11 ppolyf_u_1k_6p0 r_width=1u r_length=5u
X6 a_1049_3632# a_1097_2487# a_1129_1915# VSS nfet_06v0 ad=4.4p pd=20.88u as=4.4p ps=20.88u w=10u l=2.5u
R0 VSS.n10 VSS.n4 26144.2
R1 VSS.n14 VSS.n13 24965.9
R2 VSS.n13 VSS.n10 24965.9
R3 VSS.n15 VSS.n10 5476.85
R4 VSS.n13 VSS.n5 5476.85
R5 VSS.n16 VSS.n15 4152.78
R6 VSS.n16 VSS.n5 4152.78
R7 VSS.n16 VSS.n4 893.427
R8 VSS.n8 VSS 82.9981
R9 VSS VSS.n8 130.406
R10 VSS.n4 VSS.n3 186.279
R11 VSS.n12 VSS.n11 178.112
R12 VSS.n14 VSS 177.993
R13 VSS.n4 VSS.n2 169.587
R14 VSS.n1 VSS.t11 163.546
R15 VSS.n3 VSS.n12 152.445
R16 VSS.n1 VSS.n9 147.879
R17 VSS VSS.n16 134.924
R18 VSS VSS.n8 140.709
R19 VSS.n0 VSS.n18 137.28
R20 VSS.n1 VSS.n0 0.387857
R21 VSS VSS.n7 105.927
R22 VSS.t11 VSS.t4 100.602
R23 VSS VSS.n7 95.2754
R24 VSS.n11 VSS 77.5838
R25 VSS VSS.n9 53.1767
R26 VSS VSS.n2 42.5838
R27 VSS VSS.n19 37.4797
R28 VSS VSS.n3 33.8338
R29 VSS VSS.n2 33.8338
R30 VSS.n12 VSS.n5 33.8338
R31 VSS.n17 VSS.n5 33.8338
R32 VSS.n19 VSS 33.8338
R33 VSS.n14 VSS 31.9561
R34 VSS.t4 VSS.n14 30.7725
R35 VSS.n18 VSS.n17 28.7297
R36 VSS.n19 VSS.n18 28.438
R37 VSS.n9 VSS.n6 22.5691
R38 VSS.n17 VSS 14.5838
R39 VSS.n2 VSS.n6 12.8824
R40 VSS.n6 VSS.n7 2.6005
R41 VSS VSS.n6 2.6005
R42 VSS VSS.n5 2.6005
R43 VSS VSS.n4 2.6005
R44 VSS.n15 VSS 1.73383
R45 VSS.n11 VSS 1.16717
R46 VSS VSS.t5 1.41866
R47 VSS VSS.n0 1.29807
C0 VDD a_5881_2807# 0.01091f
C1 VDD a_1097_2487# 1.4445f
C2 VREF a_5881_2807# 0.00957f
C3 VREF a_1097_2487# 0
C4 a_5881_2807# a_1097_2487# 0.04671f
C5 a_2251_1915# a_1049_3632# 0.00342f
C6 a_1129_1915# a_1049_3632# 0.16355f
C7 a_2251_1915# a_3517_2399# 0.01245f
C8 a_3517_2399# a_1129_1915# 0
C9 a_2251_1915# VDD 0.00387f
C10 VDD a_1129_1915# 0.00175f
C11 a_2251_1915# a_1097_2487# 0.0341f
C12 a_1129_1915# a_1097_2487# 0.33125f
C13 a_3517_2399# a_1049_3632# 0.00182f
C14 a_2251_1915# a_1129_1915# 0.01906f
C15 VDD a_1049_3632# 10.2901f
C16 a_1049_3632# VREF 0.44249f
C17 a_1049_3632# a_5881_2807# 0.00755f
C18 a_1049_3632# a_1097_2487# 0.86805f
C19 a_3517_2399# VDD 0.00129f
C20 a_3517_2399# a_5881_2807# 0.03516f
C21 a_3517_2399# a_1097_2487# 0.49277f
C22 VDD VREF 1.76181f
C23 VREF VSS 0.949f
C24 VDD VSS 43.8004f
C25 a_2251_1915# VSS 2.05067f
C26 a_3517_2399# VSS 2.61081f
C27 a_5881_2807# VSS 2.3646f
C28 a_1129_1915# VSS 1.60049f
C29 a_1097_2487# VSS 3.21677f
C30 a_1049_3632# VSS 1.60688f
.ends
