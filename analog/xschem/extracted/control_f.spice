* NGSPICE file created from control_f.ext - technology: gf180mcuD

.subckt control_f VDD VSS PD PU PWRENb PROG DONEb CHRGb S0 S1 CE LENb BAT GATE
X0 x1.x2.x1.OUT a_8363_282343# VDD.t253 VDD.t252 pfet_06v0 ad=3.52p pd=16.88u as=3.52p ps=16.88u w=8u l=1.1u
X1 a_33989_250071# CE DISABLE VSS.t40 nfet_06v0 ad=1.96p pd=3.96u as=0.88p ps=4.88u w=2u l=0.7u
X2 VSS.t148 a_23654_250994# x2.x3.OUT VSS.t149 nfet_06v0 ad=4.16p pd=16.52u as=4.16p ps=16.52u w=16u l=1.4u
D0 a_16289_284488# VSS.t85 diode_pd2nw_06v0 pj=12u area=5p
X3 a_4935_249949# a_4935_249949# a_7355_249861# VSS.t74 nfet_06v0 ad=4.4p pd=20.88u as=4.4p ps=20.88u w=10u l=2.5u
X4 VDD.t125 x11.schmitt_0.Y PWRENb.t2 VDD.t124 pfet_06v0 ad=3.52p pd=16.88u as=2.08p ps=8.52u w=8u l=0.55u
D1 a_7354_308607# VSS.t52 diode_pd2nw_06v0 pj=12u area=5p
X5 a_26682_270558# a_38304_271110# VSS.t189 ppolyf_u_1k_6p0 r_width=1u r_length=57.5u
X6 x2.x3.OUT a_28942_249702# GATE VSS.t25 nfet_06v0 ad=2.08p pd=8.52u as=3.52p ps=16.88u w=8u l=0.7u
X7 x2.x3.OUT DISABLE GATE VDD.t53 pfet_06v0 ad=3.52p pd=16.88u as=2.08p ps=8.52u w=8u l=0.7u
X8 a_10653_275509# x1.x4.x2.VREF a_10429_273931# VDD.t262 pfet_06v0 ad=1.76p pd=8.88u as=1.76p ps=8.88u w=4u l=1.1u
X9 x1.OUT2 x1.x2.x1.OUT VSS.t110 VSS.t198 nfet_06v0 ad=1.04p pd=4.52u as=1.76p ps=8.88u w=4u l=0.7u
D2 a_14835_276456# VSS.t47 diode_pd2nw_06v0 pj=12u area=5p
X10 a_13867_273711# a_13867_273711# VDD.t88 VDD.t87 pfet_06v0 ad=4.4p pd=20.88u as=4.4p ps=20.88u w=10u l=5u
X11 VDD.t7 a_4886_309840# x4.VREF VDD.t6 pfet_06v0 ad=4.4p pd=20.88u as=4.4p ps=20.88u w=10u l=5u
X12 x1.x2.x2.VREF a_14837_285088# VSS.t17 ppolyf_u_1k_6p0 r_width=1u r_length=5u
X13 a_10655_284141# x1.x2.x2.VREF a_10431_282563# VDD.t244 pfet_06v0 ad=1.76p pd=8.88u as=1.76p ps=8.88u w=4u l=1.1u
X14 x8.schmitt_0.A a_40856_278332# VSS.t19 VSS.t218 nfet_06v0 ad=1.32p pd=6.88u as=1.32p ps=6.88u w=3u l=1.4u
X15 x2.x3.OUT a_23654_250994# VSS.t148 VSS.t147 nfet_06v0 ad=4.16p pd=16.52u as=4.16p ps=16.52u w=16u l=1.4u
X16 VDD.t97 x6.B LATCH VDD.t96 pfet_06v0 ad=0.88p pd=4.88u as=0.88p ps=4.88u w=2u l=0.55u
X17 VDD.t62 a_4887_251094# a_4935_249949# VDD.t61 pfet_06v0 ad=4.4p pd=20.88u as=4.4p ps=20.88u w=10u l=5u
X18 VDD.t103 a_5090_282373# VSS.t130 ppolyf_u_1k r_width=1u r_length=2u
X19 PWRENb.t1 x11.schmitt_0.Y VSS.t129 VSS.t163 nfet_06v0 ad=2.08p pd=8.52u as=3.52p ps=16.88u w=8u l=0.7u
X20 x10.MINUS REFAMP VSS.t121 ppolyf_u_1k_6p0 r_width=1u r_length=20u
X21 VSS.t207 a_10653_275509# a_10653_275509# VSS.t205 nfet_06v0 ad=1.32p pd=6.88u as=1.32p ps=6.88u w=3u l=1.4u
X22 a_12418_278990# x1.x3.x2.VREF VSS.t105 ppolyf_u_1k_6p0 r_width=1u r_length=5u
X23 a_39788_278052# a_39788_278052# VSS.t19 VSS.t190 nfet_06v0 ad=1.32p pd=6.88u as=1.32p ps=6.88u w=3u l=1.4u
X24 VDD.t228 x2.x1.OUT PROG.t7 VDD.t227 pfet_06v0 ad=0.52p pd=2.52u as=0.52p ps=2.52u w=2u l=1u
X25 a_32580_277758# OPOUT cap_mim_2f0_m4m5_noshield c_width=5u c_length=5u
X26 VSS.t166 a_10655_284141# a_10655_284141# VSS.t165 nfet_06v0 ad=1.32p pd=6.88u as=1.32p ps=6.88u w=3u l=1.4u
D3 a_6088_308123# VSS.t83 diode_pd2nw_06v0 pj=12u area=5p
X27 VSS.t100 S1.t5 x1.S1N VSS.t99 nfet_06v0 ad=0.44p pd=2.88u as=0.44p ps=2.88u w=1u l=0.7u
X28 a_6194_285737# x1.OUT2 VSS.t114 ppolyf_u_1k r_width=1u r_length=16u
X29 VSS.t34 a_32580_277758# OPOUT VSS.t33 nfet_06v0 ad=7.04p pd=32.88u as=4.16p ps=16.52u w=16u l=1.4u
X30 VDD.t171 a_12151_252030# x2.x1.OUT VDD.t168 pfet_06v0 ad=7.04p pd=32.88u as=4.16p ps=16.52u w=16u l=1.1u
X31 VDD.t23 a_32580_277758# OPOUT VDD.t22 pfet_06v0 ad=7.04p pd=32.88u as=4.16p ps=16.52u w=16u l=1.1u
X32 x2.x3.OUT a_21793_252030# VDD.t117 VDD.t116 pfet_06v0 ad=4.16p pd=16.52u as=7.04p ps=32.88u w=16u l=1.1u
X33 VDD.t25 a_32580_277758# OPOUT VDD.t22 pfet_06v0 ad=4.16p pd=16.52u as=4.16p ps=16.52u w=16u l=1.1u
X34 PD.t0 a_5831_36764# VSS.t68 VSS.t66 nfet_06v0 ad=2.08p pd=8.52u as=3.52p ps=16.88u w=8u l=0.7u
X35 a_4887_251094# a_4935_249949# a_4967_249377# VSS.t73 nfet_06v0 ad=4.4p pd=20.88u as=4.4p ps=20.88u w=10u l=2.5u
X36 RESET x8.schmitt_0.Y VSS.t186 VSS.t185 nfet_06v0 ad=3.52p pd=16.88u as=2.08p ps=8.52u w=8u l=0.7u
X37 VDD.t216 x2.x1.OUT PROG.t1 VDD.t215 pfet_06v0 ad=0.52p pd=2.52u as=0.52p ps=2.52u w=2u l=1u
X38 GATE DISABLE x2.x3.OUT VDD.t53 pfet_06v0 ad=2.08p pd=8.52u as=3.52p ps=16.88u w=8u l=0.7u
X39 a_12836_251302# PROG.t12 a_14012_250994# VDD.t29 pfet_06v0 ad=1.76p pd=8.88u as=1.76p ps=8.88u w=4u l=1.1u
X40 a_27936_308366# x11.schmitt_0.A VSS.t129 VSS.t213 nfet_06v0 ad=1.76p pd=8.88u as=1.76p ps=8.88u w=4u l=0.7u
X41 a_16905_279559# a_15729_279559# VSS.t237 VSS.t236 nfet_06v0 ad=1.32p pd=6.88u as=1.32p ps=6.88u w=3u l=1.4u
X42 LEN LENb VSS.t39 VSS.t38 nfet_06v0 ad=0.44p pd=2.88u as=0.44p ps=2.88u w=1u l=0.7u
X43 a_5831_36764# a_5831_36764# VDD.t43 VDD.t41 pfet_06v0 ad=2.08p pd=8.52u as=3.52p ps=16.88u w=8u l=0.55u
X44 VDD.t58 HALFBAT a_32580_277758# VDD.t57 pfet_06v0 ad=1.76p pd=8.88u as=1.76p ps=8.88u w=4u l=1.1u
X45 VSS.t179 a_14012_250994# x2.x1.OUT VSS.t149 nfet_06v0 ad=4.16p pd=16.52u as=4.16p ps=16.52u w=16u l=1.4u
X46 a_27906_309737# x11.schmitt_0.A VDD.t166 VDD.t165 pfet_06v0 ad=1.76p pd=8.88u as=1.76p ps=8.88u w=4u l=0.55u
X47 VDD.t179 a_15046_289227# a_15731_288499# VDD.t178 pfet_06v0 ad=3.52p pd=16.88u as=3.52p ps=16.88u w=8u l=1.1u
X48 PROG.t4 x2.x1.OUT VDD.t202 VDD.t201 pfet_06v0 ad=0.52p pd=2.52u as=0.52p ps=2.52u w=2u l=1u
X49 a_28942_249702# DISABLE VDD.t52 VDD.t51 pfet_06v0 ad=1.76p pd=8.88u as=1.76p ps=8.88u w=4u l=0.7u
X50 a_19144_309740# a_19144_309740# VSS.t42 VSS.t41 nfet_06v0 ad=1.32p pd=6.88u as=1.32p ps=6.88u w=3u l=1.4u
X51 VDD.t64 a_4887_251094# a_4887_251094# VDD.t63 pfet_06v0 ad=4.4p pd=20.88u as=4.4p ps=20.88u w=10u l=5u
X52 x1.EN4 S0.t0 VDD.t9 VDD.t8 pfet_06v0 ad=0.88p pd=4.88u as=0.88p ps=4.88u w=2u l=0.55u
X53 x2.x3.MINUS x2.x3.OUT VSS.t154 ppolyf_u_1k_6p0 r_width=1u r_length=10u
X54 VDD.t113 a_21793_252030# a_22478_251302# VDD.t108 pfet_06v0 ad=3.52p pd=16.88u as=3.52p ps=16.88u w=8u l=1.1u
X55 x1.OUT4 a_5044_273700# VSS.t54 ppolyf_u_1k r_width=1u r_length=2u
X56 VDD.t28 LATCH x6.B VDD.t246 pfet_06v0 ad=0.88p pd=4.88u as=0.88p ps=4.88u w=2u l=0.55u
X57 x2.x1.OUT a_14012_250994# VSS.t179 VSS.t147 nfet_06v0 ad=4.16p pd=16.52u as=4.16p ps=16.52u w=16u l=1.4u
X58 x1.EN1 x1.S1N a_25612_286326# VSS.t133 nfet_06v0 ad=0.88p pd=4.88u as=1.96p ps=3.96u w=2u l=0.7u
X59 VDD.t28 LATCH DONEb.t1 VDD.t245 pfet_06v0 ad=3.52p pd=16.88u as=3.52p ps=16.88u w=8u l=0.55u
X60 a_16287_275856# a_16243_275356# a_16243_275356# VSS.t113 nfet_06v0 ad=4.4p pd=20.88u as=4.4p ps=20.88u w=10u l=2.5u
X61 PWRENb.t0 x11.schmitt_0.Y VSS.t129 VSS.t161 nfet_06v0 ad=3.52p pd=16.88u as=2.08p ps=8.52u w=8u l=0.7u
X62 a_25612_286326# x1.S0N VSS.t258 VSS.t257 nfet_06v0 ad=1.96p pd=3.96u as=0.88p ps=4.88u w=2u l=0.7u
X63 x1.EN2 x1.S1N VDD.t107 VDD.t106 pfet_06v0 ad=0.88p pd=4.88u as=0.88p ps=4.88u w=2u l=0.55u
X64 VDD.t36 a_15044_280595# a_15729_279867# VDD.t150 pfet_06v0 ad=3.52p pd=16.88u as=3.52p ps=16.88u w=8u l=1.1u
D4 a_8788_278098# VSS.t201 diode_pd2nw_06v0 pj=12u area=5p
X65 VDD.t220 x2.x1.OUT PROG.t9 VDD.t219 pfet_06v0 ad=0.52p pd=2.52u as=0.52p ps=2.52u w=2u l=1u
X66 GATE a_28942_249702# x2.x3.OUT VSS.t2 nfet_06v0 ad=3.52p pd=16.88u as=2.08p ps=8.52u w=8u l=0.7u
X67 a_14011_309740# a_12835_309740# VSS.t120 VSS.t119 nfet_06v0 ad=1.32p pd=6.88u as=1.32p ps=6.88u w=3u l=1.4u
X68 a_22508_281381# x1.OUT3 VSS.t200 ppolyf_u_1k r_width=1u r_length=2u
X69 VSS.t144 x1.x3.x1.OUT x1.OUT3 VSS.t176 nfet_06v0 ad=1.76p pd=8.88u as=1.04p ps=4.52u w=4u l=0.7u
X70 GATE DISABLE x2.x3.OUT VDD.t53 pfet_06v0 ad=2.08p pd=8.52u as=2.08p ps=8.52u w=8u l=0.7u
X71 RESET x8.schmitt_0.Y VDD.t139 VDD.t140 pfet_06v0 ad=2.08p pd=8.52u as=2.08p ps=8.52u w=8u l=0.55u
X72 a_54864_264981# a_54864_254859# VSS.t51 ppolyf_u_1k_6p0 r_width=1u r_length=50u
X73 VDD.t44 a_5044_273700# VSS.t69 ppolyf_u_1k r_width=1u r_length=2u
X74 LATCH PWRENb.t5 VDD.t250 VDD.t249 pfet_06v0 ad=0.88p pd=4.88u as=0.88p ps=4.88u w=2u l=0.55u
X75 VDD.t115 a_21793_252030# x2.x3.OUT VDD.t114 pfet_06v0 ad=4.16p pd=16.52u as=4.16p ps=16.52u w=16u l=1.1u
X76 VDD.t36 a_7586_279815# a_7634_278670# VDD.t36 pfet_06v0 ad=4.4p pd=20.88u as=4.4p ps=20.88u w=10u l=5u
D5 a_17971_276456# VSS.t234 diode_pd2nw_06v0 pj=12u area=5p
X77 x2.x1.OUT a_12151_252030# VDD.t177 VDD.t176 pfet_06v0 ad=4.16p pd=16.52u as=7.04p ps=32.88u w=16u l=1.1u
X78 x8.schmitt_0.Y x8.schmitt_0.A a_42971_278925# VDD.t16 pfet_06v0 ad=1.76p pd=8.88u as=1.76p ps=8.88u w=4u l=0.55u
X79 VDD.t162 a_18459_310776# a_19144_310048# VDD.t161 pfet_06v0 ad=3.52p pd=16.88u as=3.52p ps=16.88u w=8u l=1.1u
X80 a_19144_310048# OPOUT a_20320_309740# VDD.t122 pfet_06v0 ad=1.76p pd=8.88u as=1.76p ps=8.88u w=4u l=1.1u
X81 a_24723_308864# a_24723_308864# VSS.t129 VSS.t210 nfet_06v0 ad=1.32p pd=6.88u as=1.32p ps=6.88u w=3u l=1.4u
X82 VSS.t22 a_22462_286211# VSS.t21 ppolyf_u_1k r_width=1u r_length=10u
X83 a_22478_251302# x2.x3.MINUS a_22478_250994# VDD.t32 pfet_06v0 ad=1.76p pd=8.88u as=1.76p ps=8.88u w=4u l=1.1u
X84 VDD.t15 WEH a_40856_278332# VDD.t135 pfet_06v0 ad=1.32p pd=6.88u as=1.32p ps=6.88u w=3u l=1.1u
X85 a_6194_285737# x1.x2.R VSS.t114 ppolyf_u_1k r_width=1u r_length=16.21u
X86 x2.x3.OUT a_23654_250994# VSS.t45 VSS.t150 nfet_06v0 ad=4.16p pd=16.52u as=7.04p ps=32.88u w=16u l=1.4u
X87 PROG.t10 x2.x1.OUT VDD.t238 VDD.t237 pfet_06v0 ad=0.52p pd=2.52u as=0.52p ps=2.52u w=2u l=1u
X88 VDD.t160 a_18459_310776# a_18459_310776# VDD.t159 pfet_06v0 ad=1.76p pd=8.88u as=1.76p ps=8.88u w=4u l=1.1u
X89 a_15046_289227# VSS.t231 VSS.t230 ppolyf_u_1k_6p0 r_width=1u r_length=11u
X90 x1.x4.x1.OUT a_8361_273711# VDD.t77 VDD.t76 pfet_06v0 ad=3.52p pd=16.88u as=3.52p ps=16.88u w=8u l=1.1u
D6 a_12420_287622# VSS.t169 diode_pd2nw_06v0 pj=12u area=5p
D7 x1.x1.R x1.x1.x1.OUT diode_pd2nw_06v0 pj=1.8u area=0.2025p
X91 a_16245_283988# a_13869_282343# VDD.t36 VDD.t156 pfet_06v0 ad=4.4p pd=20.88u as=4.4p ps=20.88u w=10u l=5u
X92 OPOUT a_32580_277758# VDD.t24 VDD.t22 pfet_06v0 ad=4.16p pd=16.52u as=4.16p ps=16.52u w=16u l=1.1u
D8 a_16287_275856# VSS.t57 diode_pd2nw_06v0 pj=12u area=5p
X93 VDD.t224 x2.x1.OUT PROG.t6 VDD.t223 pfet_06v0 ad=0.52p pd=2.52u as=0.52p ps=2.52u w=2u l=1u
X94 a_28942_249702# DISABLE VSS.t81 VSS.t80 nfet_06v0 ad=1.76p pd=8.88u as=1.76p ps=8.88u w=4u l=0.7u
X95 x2.x3.PLUS OPOUT VSS.t240 ppolyf_u_1k_6p0 r_width=1u r_length=10u
X96 x1.EN3 S1.t2 VDD.t75 VDD.t74 pfet_06v0 ad=0.88p pd=4.88u as=0.88p ps=4.88u w=2u l=0.55u
X97 VDD.t71 S1.t0 x1.EN4 VDD.t70 pfet_06v0 ad=0.88p pd=4.88u as=0.88p ps=4.88u w=2u l=0.55u
X98 OPOUT a_32580_277758# VDD.t26 VDD.t22 pfet_06v0 ad=4.16p pd=16.52u as=7.04p ps=32.88u w=16u l=1.1u
X99 OPOUT a_32580_277758# VSS.t35 VSS.t33 nfet_06v0 ad=4.16p pd=16.52u as=7.04p ps=32.88u w=16u l=1.4u
X100 a_12151_252030# VSS.t209 VSS.t77 ppolyf_u_1k_6p0 r_width=1u r_length=11u
X101 a_25612_284054# x1.S1N VSS.t135 VSS.t134 nfet_06v0 ad=1.96p pd=3.96u as=0.88p ps=4.88u w=2u l=0.7u
X102 x1.OUT4 x1.x4.x1.OUT VSS.t8 VSS.t7 nfet_06v0 ad=1.04p pd=4.52u as=1.76p ps=8.88u w=4u l=0.7u
X103 a_26682_270558# a_38304_270558# VSS.t189 ppolyf_u_1k_6p0 r_width=1u r_length=57.5u
X104 VSS.t186 x8.schmitt_0.Y RESET VSS.t187 nfet_06v0 ad=2.08p pd=8.52u as=2.08p ps=8.52u w=8u l=0.7u
X105 a_18665_284488# a_16245_283988# a_13869_282343# VSS.t0 nfet_06v0 ad=4.4p pd=20.88u as=4.4p ps=20.88u w=10u l=2.5u
X106 a_7634_278670# a_7634_278670# a_10054_278582# VSS.t252 nfet_06v0 ad=4.4p pd=20.88u as=4.4p ps=20.88u w=10u l=2.5u
D9 a_54864_254859# GATE diode_pd2nw_06v0 pj=1.8u area=0.2025p
X107 VDD.t28 LENb LEN VDD.t27 pfet_06v0 ad=0.44p pd=2.88u as=0.44p ps=2.88u w=1u l=0.55u
X108 a_19144_310048# x5.MINUS a_19144_309740# VDD.t241 pfet_06v0 ad=1.76p pd=8.88u as=1.76p ps=8.88u w=4u l=1.1u
X109 VSS.t110 a_8363_283268# x1.x2.x1.OUT VSS.t242 nfet_06v0 ad=3.52p pd=16.88u as=3.52p ps=16.88u w=8u l=1.4u
X110 VSS.t35 a_32580_277758# OPOUT VSS.t33 nfet_06v0 ad=4.16p pd=16.52u as=4.16p ps=16.52u w=16u l=1.4u
X111 DONEb.t0 LATCH VSS.t245 VSS.t244 nfet_06v0 ad=3.52p pd=16.88u as=3.52p ps=16.88u w=8u l=0.7u
X112 a_12835_310048# x4.VREF a_14011_309740# VDD.t131 pfet_06v0 ad=1.76p pd=8.88u as=1.76p ps=8.88u w=4u l=1.1u
X113 VDD.t121 REFAMP a_25791_309144# VDD.t120 pfet_06v0 ad=1.32p pd=6.88u as=1.32p ps=6.88u w=3u l=1.1u
X114 VSS.t129 x11.schmitt_0.Y PWRENb.t1 VSS.t162 nfet_06v0 ad=2.08p pd=8.52u as=2.08p ps=8.52u w=8u l=0.7u
X115 a_7666_278098# a_8788_278098# VSS.t136 ppolyf_u_1k_6p0 r_width=1u r_length=5u
X116 x6.B RESET VDD.t28 VDD.t243 pfet_06v0 ad=0.88p pd=4.88u as=0.88p ps=4.88u w=2u l=0.55u
X117 VDD.t212 x2.x1.OUT PROG.t0 VDD.t211 pfet_06v0 ad=0.52p pd=2.52u as=0.52p ps=2.52u w=2u l=1u
X118 a_34961_250959# DISABLE VSS.t79 VSS.t2 nfet_06v0 ad=0.44p pd=2.88u as=0.44p ps=2.88u w=1u l=0.7u
X119 a_12150_310776# VSS.t193 VSS.t192 ppolyf_u_1k_6p0 r_width=1u r_length=11u
X120 PROG.t7 x2.x1.OUT VDD.t230 VDD.t229 pfet_06v0 ad=0.52p pd=2.52u as=0.52p ps=2.52u w=2u l=1u
X121 VDD.t175 a_12151_252030# x2.x1.OUT VDD.t174 pfet_06v0 ad=4.16p pd=16.52u as=4.16p ps=16.52u w=16u l=1.1u
X122 VDD.t102 a_25791_309144# x11.schmitt_0.A VDD.t101 pfet_06v0 ad=1.32p pd=6.88u as=1.32p ps=6.88u w=3u l=1.1u
X123 a_4934_308695# a_4934_308695# a_7354_308607# VSS.t123 nfet_06v0 ad=4.4p pd=20.88u as=4.4p ps=20.88u w=10u l=2.5u
X124 PROG.t5 x2.x1.OUT VDD.t198 VDD.t197 pfet_06v0 ad=0.52p pd=2.52u as=0.52p ps=2.52u w=2u l=1u
D10 a_10056_287214# VSS.t167 diode_pd2nw_06v0 pj=12u area=5p
X125 VSS.t14 S0.t5 x1.S0N VSS.t13 nfet_06v0 ad=0.44p pd=2.88u as=0.44p ps=2.88u w=1u l=0.7u
X126 OPOUT a_32580_277758# VSS.t35 VSS.t33 nfet_06v0 ad=4.16p pd=16.52u as=4.16p ps=16.52u w=16u l=1.4u
X127 a_10429_273931# a_8361_273711# VDD.t81 VDD.t80 pfet_06v0 ad=3.52p pd=16.88u as=3.52p ps=16.88u w=8u l=1.1u
X128 x1.x1.x1.OUT a_16907_288191# cap_mim_2f0_m4m5_noshield c_width=5u c_length=5u
X129 CTRLAMP a_20320_309740# cap_mim_2f0_m4m5_noshield c_width=5u c_length=5u
X130 VSS.t146 a_23654_250994# x2.x3.OUT VSS.t145 nfet_06v0 ad=7.04p pd=32.88u as=4.16p ps=16.52u w=16u l=1.4u
X131 a_9719_250269# x2.MINUS VSS.t104 ppolyf_u_1k_6p0 r_width=1u r_length=5u
X132 x5.MINUS CTRLAMP VSS.t253 ppolyf_u_1k_6p0 r_width=1u r_length=50u
X133 x1.OUT1 x1.x1.x1.OUT VSS.t204 VSS.t227 nfet_06v0 ad=1.04p pd=4.52u as=1.76p ps=8.88u w=4u l=0.7u
X134 x1.x4.x2.VREF a_14835_276456# VSS.t155 ppolyf_u_1k_6p0 r_width=1u r_length=5u
X135 a_7588_288447# a_7636_287302# a_7668_286730# VSS.t139 nfet_06v0 ad=4.4p pd=20.88u as=4.4p ps=20.88u w=10u l=2.5u
X136 VDD.t11 S0.t2 x1.EN2 VDD.t10 pfet_06v0 ad=0.88p pd=4.88u as=0.88p ps=4.88u w=2u l=0.55u
X137 x1.x3.x1.OUT a_16905_279559# cap_mim_2f0_m4m5_noshield c_width=5u c_length=5u
X138 a_12836_251302# x2.MINUS a_12836_250994# VDD.t29 pfet_06v0 ad=1.76p pd=8.88u as=1.76p ps=8.88u w=4u l=1.1u
X139 BAT WEH VSS.t127 ppolyf_u_1k_6p0 r_width=1u r_length=60u
X140 a_43001_277554# x8.schmitt_0.A VSS.t19 VSS.t18 nfet_06v0 ad=1.76p pd=8.88u as=1.76p ps=8.88u w=4u l=0.7u
X141 VDD.t20 a_28942_249702# GATE VDD.t17 pfet_06v0 ad=2.08p pd=8.52u as=2.08p ps=8.52u w=8u l=0.7u
X142 VSS.t76 a_8361_273711# VSS.t75 ppolyf_u_1k_6p0 r_width=1u r_length=11u
X143 x2.x1.OUT a_14012_250994# VSS.t181 VSS.t150 nfet_06v0 ad=4.16p pd=16.52u as=7.04p ps=32.88u w=16u l=1.4u
X144 VDD.t164 a_18459_310776# CTRLAMP VDD.t163 pfet_06v0 ad=3.52p pd=16.88u as=3.52p ps=16.88u w=8u l=1.1u
X145 a_42971_278925# x8.schmitt_0.A VDD.t15 VDD.t14 pfet_06v0 ad=1.76p pd=8.88u as=1.76p ps=8.88u w=4u l=0.55u
X146 a_7668_286730# a_8790_286730# VSS.t87 ppolyf_u_1k_6p0 r_width=1u r_length=5u
X147 VSS.t110 a_8363_282343# VSS.t109 ppolyf_u_1k_6p0 r_width=1u r_length=11u
X148 VDD.t139 x8.schmitt_0.Y RESET VDD.t138 pfet_06v0 ad=3.52p pd=16.88u as=2.08p ps=8.52u w=8u l=0.55u
X149 VDD.t145 CEN DISABLE VDD.t144 pfet_06v0 ad=0.88p pd=4.88u as=0.88p ps=4.88u w=2u l=0.55u
X150 VDD.t94 a_7588_288447# x1.x1.x2.VREF VDD.t93 pfet_06v0 ad=4.4p pd=20.88u as=4.4p ps=20.88u w=10u l=5u
X151 a_10431_282563# a_8363_282343# VDD.t255 VDD.t254 pfet_06v0 ad=3.52p pd=16.88u as=3.52p ps=16.88u w=8u l=1.1u
X152 x1.OUT2 x1.EN2 REFOUT VDD.t100 pfet_06v0 ad=1.76p pd=8.88u as=1.76p ps=8.88u w=4u l=0.55u
X153 VDD.t109 a_21793_252030# a_21793_252030# VDD.t108 pfet_06v0 ad=1.76p pd=8.88u as=1.76p ps=8.88u w=4u l=1.1u
X154 a_22462_290353# x1.OUT1 VSS.t64 ppolyf_u_1k r_width=1u r_length=2u
X155 a_6148_277502# x1.x4.R VSS.t54 ppolyf_u_1k r_width=1u r_length=18.4u
X156 VDD.t248 LATCH CEN VDD.t247 pfet_06v0 ad=0.88p pd=4.88u as=0.88p ps=4.88u w=2u l=0.55u
X157 a_23654_250994# a_22478_250994# VSS.t62 VSS.t40 nfet_06v0 ad=1.32p pd=6.88u as=1.32p ps=6.88u w=3u l=1.4u
X158 PROG.t8 x2.x1.OUT VDD.t234 VDD.t233 pfet_06v0 ad=0.52p pd=2.52u as=0.52p ps=2.52u w=2u l=1u
X159 VSS.t260 VDD.t45 cap_mim_2f0_m4m5_noshield c_width=5u c_length=5u
X160 VSS.t67 a_5831_36764# PD.t0 VSS.t66 nfet_06v0 ad=3.52p pd=16.88u as=2.08p ps=8.52u w=8u l=0.7u
X161 a_5090_285737# VSS.t108 VSS.t107 ppolyf_u_1k r_width=1u r_length=10u
X162 x1.OUT1 a_21358_286211# VSS.t1 ppolyf_u_1k r_width=1u r_length=20.1u
X163 a_53474_278076# LEN CEN VSS.t106 nfet_06v0 ad=1.96p pd=3.96u as=0.88p ps=4.88u w=2u l=0.7u
X164 a_4886_309840# a_4934_308695# a_4966_308123# VSS.t122 nfet_06v0 ad=4.4p pd=20.88u as=4.4p ps=20.88u w=10u l=2.5u
X165 x1.x3.x1.OUT a_16905_279559# VSS.t144 VSS.t143 nfet_06v0 ad=3.52p pd=16.88u as=3.52p ps=16.88u w=8u l=1.4u
X166 REFOUT WM VSS.t214 ppolyf_u_1k_6p0 r_width=1u r_length=10u
X167 a_31404_278437# a_31404_278437# VSS.t33 VSS.t49 nfet_06v0 ad=1.32p pd=6.88u as=1.32p ps=6.88u w=3u l=1.4u
X168 a_14012_250994# x2.x1.OUT cap_mim_2f0_m4m5_noshield c_width=5u c_length=5u
X169 VDD.t36 a_7586_279815# a_7586_279815# VDD.t35 pfet_06v0 ad=4.4p pd=20.88u as=4.4p ps=20.88u w=10u l=5u
X170 a_3855_36764# a_3855_36764# VSS.t224 VSS.t222 nfet_06v0 ad=2.08p pd=8.52u as=3.52p ps=16.88u w=8u l=0.7u
X171 VDD.t139 x8.schmitt_0.Y RESET VDD.t141 pfet_06v0 ad=2.08p pd=8.52u as=3.52p ps=16.88u w=8u l=0.55u
X172 PU.t0 a_3855_36764# VDD.t186 VDD.t185 pfet_06v0 ad=2.08p pd=8.52u as=3.52p ps=16.88u w=8u l=0.55u
X173 VSS.t178 a_14012_250994# x2.x1.OUT VSS.t145 nfet_06v0 ad=7.04p pd=32.88u as=4.16p ps=16.52u w=16u l=1.4u
X174 VSS.t262 VDD.t47 cap_mim_2f0_m4m5_noshield c_width=35u c_length=35u
X175 VDD.t208 x2.x1.OUT PROG.t2 VDD.t207 pfet_06v0 ad=0.52p pd=2.52u as=0.52p ps=2.52u w=2u l=1u
X176 a_21793_252030# VSS.t78 VSS.t77 ppolyf_u_1k_6p0 r_width=1u r_length=11u
X177 x10.MINUS VSS.t60 VSS.t59 ppolyf_u_1k_6p0 r_width=1u r_length=10u
X178 x1.x1.x1.OUT a_16907_288191# VSS.t204 VSS.t203 nfet_06v0 ad=3.52p pd=16.88u as=3.52p ps=16.88u w=8u l=1.4u
X179 x1.OUT1 a_25120_285050# REFOUT VSS.t30 nfet_06v0 ad=1.76p pd=8.88u as=1.76p ps=8.88u w=4u l=0.7u
X180 a_15729_279867# x1.x3.x2.VREF a_15729_279559# VDD.t146 pfet_06v0 ad=1.76p pd=8.88u as=1.76p ps=8.88u w=4u l=1.1u
X181 a_23654_250994# x2.x3.OUT cap_mim_2f0_m4m5_noshield c_width=5u c_length=5u
X182 VDD.t66 a_4887_251094# x2.MINUS VDD.t65 pfet_06v0 ad=4.4p pd=20.88u as=4.4p ps=20.88u w=10u l=5u
X183 VDD.t90 a_7588_288447# a_7588_288447# VDD.t89 pfet_06v0 ad=4.4p pd=20.88u as=4.4p ps=20.88u w=10u l=5u
X184 GATE a_28942_249702# x2.x3.OUT VSS.t24 nfet_06v0 ad=2.08p pd=8.52u as=2.08p ps=8.52u w=8u l=0.7u
X185 VDD.t152 a_15044_280595# x1.x3.x1.OUT VDD.t151 pfet_06v0 ad=3.52p pd=16.88u as=3.52p ps=16.88u w=8u l=1.1u
X186 VDD.t240 x2.x1.OUT PROG.t11 VDD.t239 pfet_06v0 ad=0.52p pd=2.52u as=0.88p ps=4.88u w=2u l=1u
X187 x1.EN4 S1.t1 a_25612_279510# VSS.t103 nfet_06v0 ad=0.88p pd=4.88u as=1.96p ps=3.96u w=2u l=0.7u
X188 VSS.t116 x6.B a_47649_278076# VSS.t115 nfet_06v0 ad=0.88p pd=4.88u as=1.96p ps=3.96u w=2u l=0.7u
D11 a_10054_278582# VSS.t111 diode_pd2nw_06v0 pj=12u area=5p
D12 x1.x4.R x1.x4.x1.OUT diode_pd2nw_06v0 pj=1.8u area=0.2025p
D13 a_9719_250269# VSS.t152 diode_pd2nw_06v0 pj=12u area=5p
X189 a_15731_288499# x1.x1.R a_16907_288191# VDD.t34 pfet_06v0 ad=1.76p pd=8.88u as=1.76p ps=8.88u w=4u l=1.1u
X190 a_12420_287622# x1.x1.x2.VREF VSS.t254 ppolyf_u_1k_6p0 r_width=1u r_length=5u
X191 a_7586_279815# a_7634_278670# a_7666_278098# VSS.t251 nfet_06v0 ad=4.4p pd=20.88u as=4.4p ps=20.88u w=10u l=2.5u
X192 PROG.t6 x2.x1.OUT VDD.t226 VDD.t225 pfet_06v0 ad=0.52p pd=2.52u as=0.52p ps=2.52u w=2u l=1u
X193 CHRGb a_34961_250959# VSS.t3 VSS.t2 nfet_06v0 ad=3.52p pd=16.88u as=3.52p ps=16.88u w=8u l=0.7u
X194 x2.x1.OUT x2.x3.PLUS VSS.t2 ppolyf_u_1k_6p0 r_width=1u r_length=10u
X195 VDD.t5 a_4886_309840# a_4934_308695# VDD.t4 pfet_06v0 ad=4.4p pd=20.88u as=4.4p ps=20.88u w=10u l=5u
X196 CTRLAMP a_20320_309740# VSS.t129 VSS.t194 nfet_06v0 ad=3.52p pd=16.88u as=3.52p ps=16.88u w=8u l=1.4u
X197 x1.OUT2 a_25120_282778# REFOUT VSS.t88 nfet_06v0 ad=1.76p pd=8.88u as=1.76p ps=8.88u w=4u l=0.7u
X198 a_25612_279510# S0.t1 VSS.t12 VSS.t11 nfet_06v0 ad=1.96p pd=3.96u as=0.88p ps=4.88u w=2u l=0.7u
D14 x1.x3.R x1.x3.x1.OUT diode_pd2nw_06v0 pj=1.8u area=0.2025p
X199 a_16243_275356# a_13867_273711# VDD.t86 VDD.t85 pfet_06v0 ad=4.4p pd=20.88u as=4.4p ps=20.88u w=10u l=5u
X200 a_22478_251302# x2.x3.PLUS a_23654_250994# VDD.t32 pfet_06v0 ad=1.76p pd=8.88u as=1.76p ps=8.88u w=4u l=1.1u
X201 x11.schmitt_0.Y x11.schmitt_0.A a_27936_308366# VSS.t213 nfet_06v0 ad=1.76p pd=8.88u as=1.76p ps=8.88u w=4u l=0.7u
X202 x1.EN2 S0.t3 a_25612_284054# VSS.t15 nfet_06v0 ad=0.88p pd=4.88u as=1.96p ps=3.96u w=2u l=0.7u
X203 DISABLE CE VDD.t31 VDD.t30 pfet_06v0 ad=0.88p pd=4.88u as=0.88p ps=4.88u w=2u l=0.55u
X204 a_15731_288499# x1.x1.x2.VREF a_15731_288191# VDD.t251 pfet_06v0 ad=1.76p pd=8.88u as=1.76p ps=8.88u w=4u l=1.1u
X205 VSS.t249 LATCH a_53474_278076# VSS.t248 nfet_06v0 ad=0.88p pd=4.88u as=1.96p ps=3.96u w=2u l=0.7u
X206 PWRENb.t2 x11.schmitt_0.Y VDD.t127 VDD.t126 pfet_06v0 ad=2.08p pd=8.52u as=2.08p ps=8.52u w=8u l=0.55u
X207 x1.OUT4 a_25120_278234# REFOUT VSS.t158 nfet_06v0 ad=1.76p pd=8.88u as=1.76p ps=8.88u w=4u l=0.7u
X208 x2.x3.PLUS VSS.t45 cap_mim_2f0_m4m5_noshield c_width=5u c_length=5u
X209 a_12835_310048# x10.MINUS a_12835_309740# VDD.t183 pfet_06v0 ad=1.76p pd=8.88u as=1.76p ps=8.88u w=4u l=1.1u
X210 VSS.t159 x11.schmitt_0.Y a_28712_309737# VDD.t123 pfet_06v0 ad=0.88p pd=4.88u as=0.88p ps=4.88u w=2u l=0.55u
X211 x1.OUT1 x1.EN1 REFOUT VDD.t56 pfet_06v0 ad=1.76p pd=8.88u as=1.76p ps=8.88u w=4u l=0.55u
X212 a_6148_277502# x1.OUT4 VSS.t54 ppolyf_u_1k r_width=1u r_length=18.4u
X213 a_15044_280595# VSS.t144 VSS.t221 ppolyf_u_1k_6p0 r_width=1u r_length=11u
X214 VSS.t125 a_8361_274636# x1.x4.x1.OUT VSS.t124 nfet_06v0 ad=3.52p pd=16.88u as=3.52p ps=16.88u w=8u l=1.4u
X215 VDD.t192 a_12150_310776# REFAMP VDD.t191 pfet_06v0 ad=3.52p pd=16.88u as=3.52p ps=16.88u w=8u l=1.1u
X216 a_5090_285737# x1.x2.R VSS.t217 ppolyf_u_1k r_width=1u r_length=10u
D15 x1.x2.R x1.x2.x1.OUT diode_pd2nw_06v0 pj=1.8u area=0.2025p
X217 x1.x2.x2.VREF a_13869_282343# VDD.t155 VDD.t154 pfet_06v0 ad=4.4p pd=20.88u as=4.4p ps=20.88u w=10u l=5u
X218 VDD.t42 a_5831_36764# a_5831_36764# VDD.t41 pfet_06v0 ad=3.52p pd=16.88u as=2.08p ps=8.52u w=8u l=0.55u
X219 x1.x1.R a_21358_286211# VSS.t1 ppolyf_u_1k r_width=1u r_length=20.1u
D16 VSS.t174 x1.x3.x1.OUT diode_nd2ps_06v0 pj=8u area=4p
X220 VDD.t15 a_40856_278332# x8.schmitt_0.A VDD.t184 pfet_06v0 ad=1.32p pd=6.88u as=1.32p ps=6.88u w=3u l=1.1u
D17 VSS.t5 x1.x4.x1.OUT diode_nd2ps_06v0 pj=8u area=4p
X221 WM a_38304_271110# VSS.t189 ppolyf_u_1k_6p0 r_width=1u r_length=57.5u
X222 VDD.t200 x2.x1.OUT PROG.t4 VDD.t199 pfet_06v0 ad=0.52p pd=2.52u as=0.52p ps=2.52u w=2u l=1u
X223 REFOUT VSS.t92 cap_mim_2f0_m4m5_noshield c_width=10u c_length=10u
X224 a_4967_249377# a_6089_249377# VSS.t171 ppolyf_u_1k_6p0 r_width=1u r_length=5u
X225 a_12836_250994# a_12836_250994# VSS.t131 VSS.t40 nfet_06v0 ad=1.32p pd=6.88u as=1.32p ps=6.88u w=3u l=1.4u
D18 VSS.t225 x1.x1.x1.OUT diode_nd2ps_06v0 pj=8u area=4p
X226 a_5044_277502# VSS.t151 VSS.t4 ppolyf_u_1k r_width=1u r_length=10u
X227 VSS.t183 x8.schmitt_0.Y a_43777_278925# VDD.t136 pfet_06v0 ad=0.88p pd=4.88u as=0.88p ps=4.88u w=2u l=0.55u
X228 a_8363_282343# a_8363_282343# VDD.t257 VDD.t256 pfet_06v0 ad=1.76p pd=8.88u as=1.76p ps=8.88u w=4u l=1.1u
X229 VDD.t15 REFOUT a_39788_278052# VDD.t242 pfet_06v0 ad=1.32p pd=6.88u as=1.32p ps=6.88u w=3u l=1.1u
X230 a_18663_275856# a_16243_275356# a_13867_273711# VSS.t113 nfet_06v0 ad=4.4p pd=20.88u as=4.4p ps=20.88u w=10u l=2.5u
X231 a_47649_278076# PWRENb.t4 LATCH VSS.t250 nfet_06v0 ad=1.96p pd=3.96u as=0.88p ps=4.88u w=2u l=0.7u
X232 a_18459_310776# VSS.t72 VSS.t71 ppolyf_u_1k_6p0 r_width=1u r_length=11u
X233 BAT HALFBAT VSS.t212 ppolyf_u_1k_6p0 r_width=1u r_length=40u
X234 VSS.t247 LATCH a_51049_278076# VSS.t246 nfet_06v0 ad=0.88p pd=4.88u as=1.96p ps=3.96u w=2u l=0.7u
X235 VDD.t3 a_4886_309840# a_4886_309840# VDD.t2 pfet_06v0 ad=4.4p pd=20.88u as=4.4p ps=20.88u w=10u l=5u
X236 VSS.t92 a_22508_278263# VSS.t82 ppolyf_u_1k r_width=1u r_length=10u
X237 WEH VSS.t220 VSS.t219 ppolyf_u_1k_6p0 r_width=1u r_length=80u
X238 x1.OUT4 x1.EN4 REFOUT VDD.t69 pfet_06v0 ad=1.76p pd=8.88u as=1.76p ps=8.88u w=4u l=0.55u
D19 a_8790_286730# VSS.t28 diode_pd2nw_06v0 pj=12u area=5p
X239 a_22462_290353# VDD.t40 VSS.t64 ppolyf_u_1k r_width=1u r_length=2u
X240 CEN LEN VDD.t28 VDD.t82 pfet_06v0 ad=0.88p pd=4.88u as=0.88p ps=4.88u w=2u l=0.55u
X241 a_40856_278332# a_39788_278052# VSS.t19 VSS.t191 nfet_06v0 ad=1.32p pd=6.88u as=1.32p ps=6.88u w=3u l=1.4u
X242 x2.x3.OUT a_28942_249702# GATE VSS.t23 nfet_06v0 ad=2.08p pd=8.52u as=2.08p ps=8.52u w=8u l=0.7u
X243 a_5044_277502# x1.x4.R VSS.t4 ppolyf_u_1k r_width=1u r_length=10u
X244 x1.x3.R a_21404_278263# VSS.t65 ppolyf_u_1k r_width=1u r_length=9.98u
X245 PROG.t1 x2.x1.OUT VDD.t218 VDD.t217 pfet_06v0 ad=0.52p pd=2.52u as=0.52p ps=2.52u w=2u l=1u
X246 x2.x3.OUT DISABLE GATE VDD.t53 pfet_06v0 ad=2.08p pd=8.52u as=2.08p ps=8.52u w=8u l=0.7u
X247 VDD.t39 a_7586_279815# x1.x3.x2.VREF VDD.t38 pfet_06v0 ad=4.4p pd=20.88u as=4.4p ps=20.88u w=10u l=5u
X248 x1.OUT3 x1.x3.x1.OUT VSS.t173 VSS.t172 nfet_06v0 ad=1.04p pd=4.52u as=1.76p ps=8.88u w=4u l=0.7u
X249 VDD.t236 x2.x1.OUT PROG.t10 VDD.t235 pfet_06v0 ad=0.52p pd=2.52u as=0.52p ps=2.52u w=2u l=1u
X250 a_25612_281782# S1.t3 VSS.t102 VSS.t101 nfet_06v0 ad=1.96p pd=3.96u as=0.88p ps=4.88u w=2u l=0.7u
X251 VSS.t206 a_10653_275509# a_8361_274636# VSS.t205 nfet_06v0 ad=1.32p pd=6.88u as=1.32p ps=6.88u w=3u l=1.4u
X252 a_25791_309144# a_24723_308864# VSS.t129 VSS.t210 nfet_06v0 ad=1.32p pd=6.88u as=1.32p ps=6.88u w=3u l=1.4u
X253 VDD.t194 WM a_31404_278437# VDD.t193 pfet_06v0 ad=1.76p pd=8.88u as=1.76p ps=8.88u w=4u l=1.1u
X254 a_8361_274636# x1.x4.R a_10429_273931# VDD.t33 pfet_06v0 ad=1.76p pd=8.88u as=1.76p ps=8.88u w=4u l=1.1u
X255 VDD.t204 x2.x1.OUT PROG.t3 VDD.t203 pfet_06v0 ad=0.52p pd=2.52u as=0.52p ps=2.52u w=2u l=1u
X256 VDD.t18 a_28942_249702# GATE VDD.t17 pfet_06v0 ad=3.52p pd=16.88u as=2.08p ps=8.52u w=8u l=0.7u
X257 VSS.t110 a_10655_284141# a_8363_283268# VSS.t164 nfet_06v0 ad=1.32p pd=6.88u as=1.32p ps=6.88u w=3u l=1.4u
X258 x1.OUT3 a_25120_280506# REFOUT VSS.t208 nfet_06v0 ad=1.76p pd=8.88u as=1.76p ps=8.88u w=4u l=0.7u
X259 VDD.t137 x8.schmitt_0.Y a_43001_277554# VSS.t184 nfet_06v0 ad=0.88p pd=4.88u as=0.88p ps=4.88u w=2u l=0.7u
X260 PROG.t9 x2.x1.OUT VDD.t222 VDD.t221 pfet_06v0 ad=0.52p pd=2.52u as=0.52p ps=2.52u w=2u l=1u
D20 a_7355_249861# VSS.t26 diode_pd2nw_06v0 pj=12u area=5p
X261 a_4966_308123# a_6088_308123# VSS.t16 ppolyf_u_1k_6p0 r_width=1u r_length=5u
X262 x11.schmitt_0.A a_25791_309144# VSS.t129 VSS.t128 nfet_06v0 ad=1.32p pd=6.88u as=1.32p ps=6.88u w=3u l=1.4u
X263 VSS.t92 x1.EN1 a_25120_285050# VSS.t91 nfet_06v0 ad=0.44p pd=2.88u as=0.44p ps=2.88u w=1u l=0.7u
X264 a_8363_283268# x1.x2.R a_10431_282563# VDD.t95 pfet_06v0 ad=1.76p pd=8.88u as=1.76p ps=8.88u w=4u l=1.1u
D21 VSS.t196 x1.x2.x1.OUT diode_nd2ps_06v0 pj=8u area=4p
X265 VDD.t55 x1.EN1 a_25120_285050# VDD.t54 pfet_06v0 ad=0.44p pd=2.88u as=0.44p ps=2.88u w=1u l=0.55u
X266 a_17973_285088# a_18665_284488# VSS.t63 ppolyf_u_1k_6p0 r_width=1u r_length=5u
X267 x1.OUT3 a_21404_278263# VSS.t65 ppolyf_u_1k r_width=1u r_length=9.98u
X268 VDD.t73 S1.t4 x1.S1N VDD.t72 pfet_06v0 ad=0.44p pd=2.88u as=0.44p ps=2.88u w=1u l=0.55u
D22 a_14837_285088# VSS.t55 diode_pd2nw_06v0 pj=12u area=5p
X269 x2.x3.MINUS VSS.t157 VSS.t156 ppolyf_u_1k_6p0 r_width=1u r_length=10u
X270 a_13869_282343# a_13869_282343# VDD.t158 VDD.t157 pfet_06v0 ad=4.4p pd=20.88u as=4.4p ps=20.88u w=10u l=5u
X271 a_51049_278076# RESET x6.B VSS.t243 nfet_06v0 ad=1.96p pd=3.96u as=0.88p ps=4.88u w=2u l=0.7u
X272 REFAMP a_14011_309740# cap_mim_2f0_m4m5_noshield c_width=5u c_length=5u
X273 a_20320_309740# a_19144_309740# VSS.t44 VSS.t43 nfet_06v0 ad=1.32p pd=6.88u as=1.32p ps=6.88u w=3u l=1.4u
X274 a_15729_279559# a_15729_279559# VSS.t239 VSS.t238 nfet_06v0 ad=1.32p pd=6.88u as=1.32p ps=6.88u w=3u l=1.4u
X275 PROG.t2 x2.x1.OUT VDD.t210 VDD.t209 pfet_06v0 ad=0.52p pd=2.52u as=0.52p ps=2.52u w=2u l=1u
X276 VDD.t1 a_34961_250959# CHRGb VDD.t0 pfet_06v0 ad=3.52p pd=16.88u as=3.52p ps=16.88u w=8u l=0.55u
X277 REFAMP a_14011_309740# VSS.t142 VSS.t141 nfet_06v0 ad=3.52p pd=16.88u as=3.52p ps=16.88u w=8u l=1.4u
X278 VDD.t261 x1.S0N x1.EN3 VDD.t260 pfet_06v0 ad=0.88p pd=4.88u as=0.88p ps=4.88u w=2u l=0.55u
X279 a_17971_276456# a_18663_275856# VSS.t4 ppolyf_u_1k_6p0 r_width=1u r_length=5u
X280 x1.x2.x1.OUT a_8363_283268# cap_mim_2f0_m4m5_noshield c_width=5u c_length=5u
X281 x1.x4.x1.OUT a_8361_274636# cap_mim_2f0_m4m5_noshield c_width=5u c_length=5u
X282 a_7636_287302# a_7636_287302# a_10056_287214# VSS.t140 nfet_06v0 ad=4.4p pd=20.88u as=4.4p ps=20.88u w=10u l=2.5u
X283 HALFBAT VSS.t233 VSS.t232 ppolyf_u_1k_6p0 r_width=1u r_length=40u
X284 VDD.t196 x2.x1.OUT PROG.t5 VDD.t195 pfet_06v0 ad=0.88p pd=4.88u as=0.52p ps=2.52u w=2u l=1u
X285 VSS.t261 VDD.t142 cap_mim_2f0_m4m5_noshield c_width=100u c_length=100u
D23 a_12418_278990# VSS.t255 diode_pd2nw_06v0 pj=12u area=5p
X286 VSS.t92 x1.EN4 a_25120_278234# VSS.t93 nfet_06v0 ad=0.44p pd=2.88u as=0.44p ps=2.88u w=1u l=0.7u
X287 VSS.t223 a_3855_36764# a_3855_36764# VSS.t222 nfet_06v0 ad=3.52p pd=16.88u as=2.08p ps=8.52u w=8u l=0.7u
X288 x2.x3.OUT a_21793_252030# VDD.t112 VDD.t111 pfet_06v0 ad=4.16p pd=16.52u as=4.16p ps=16.52u w=16u l=1.1u
X289 VDD.t129 x11.schmitt_0.Y PWRENb.t3 VDD.t128 pfet_06v0 ad=2.08p pd=8.52u as=3.52p ps=16.88u w=8u l=0.55u
X290 VDD.t130 x11.schmitt_0.Y a_27936_308366# VSS.t160 nfet_06v0 ad=0.88p pd=4.88u as=0.88p ps=4.88u w=2u l=0.7u
X291 x1.OUT3 x1.EN3 REFOUT VDD.t134 pfet_06v0 ad=1.76p pd=8.88u as=1.76p ps=8.88u w=4u l=0.55u
X292 VDD.t68 x1.EN4 a_25120_278234# VDD.t67 pfet_06v0 ad=0.44p pd=2.88u as=0.44p ps=2.88u w=1u l=0.55u
D24 a_6089_249377# VSS.t215 diode_pd2nw_06v0 pj=12u area=5p
X293 VSS.t10 x1.x4.x1.OUT x1.OUT4 VSS.t9 nfet_06v0 ad=1.76p pd=8.88u as=1.04p ps=4.52u w=4u l=0.7u
X294 GATE a_28942_249702# VDD.t21 VDD.t17 pfet_06v0 ad=2.08p pd=8.52u as=3.52p ps=16.88u w=8u l=0.7u
X295 x5.MINUS VSS.t138 VSS.t137 ppolyf_u_1k_6p0 r_width=1u r_length=10u
X296 VDD.t90 a_15046_289227# x1.x1.x1.OUT VDD.t182 pfet_06v0 ad=3.52p pd=16.88u as=3.52p ps=16.88u w=8u l=1.1u
X297 a_15731_288191# a_15731_288191# VSS.t95 VSS.t94 nfet_06v0 ad=1.32p pd=6.88u as=1.32p ps=6.88u w=3u l=1.4u
X298 VDD.t181 a_15046_289227# a_15046_289227# VDD.t180 pfet_06v0 ad=1.76p pd=8.88u as=1.76p ps=8.88u w=4u l=1.1u
X299 a_15729_279867# x1.x3.R a_16905_279559# VDD.t153 pfet_06v0 ad=1.76p pd=8.88u as=1.76p ps=8.88u w=4u l=1.1u
X300 a_16289_284488# a_16245_283988# a_16245_283988# VSS.t0 nfet_06v0 ad=4.4p pd=20.88u as=4.4p ps=20.88u w=10u l=2.5u
X301 a_12835_309740# a_12835_309740# VSS.t118 VSS.t117 nfet_06v0 ad=1.32p pd=6.88u as=1.32p ps=6.88u w=3u l=1.4u
D25 a_9718_309015# VSS.t89 diode_pd2nw_06v0 pj=12u area=5p
X302 a_16907_288191# a_15731_288191# VSS.t97 VSS.t96 nfet_06v0 ad=1.32p pd=6.88u as=1.32p ps=6.88u w=3u l=1.4u
X303 x1.EN1 x1.S0N VDD.t259 VDD.t258 pfet_06v0 ad=0.88p pd=4.88u as=0.88p ps=4.88u w=2u l=0.55u
X304 VDD.t119 CTRLAMP a_24723_308864# VDD.t118 pfet_06v0 ad=1.32p pd=6.88u as=1.32p ps=6.88u w=3u l=1.1u
X305 VSS.t229 x1.x1.x1.OUT x1.OUT1 VSS.t228 nfet_06v0 ad=1.76p pd=8.88u as=1.04p ps=4.52u w=4u l=0.7u
X306 VSS.t110 x1.x2.x1.OUT x1.OUT2 VSS.t199 nfet_06v0 ad=1.76p pd=8.88u as=1.04p ps=4.52u w=4u l=0.7u
X307 VSS.t92 x1.EN2 a_25120_282778# VSS.t126 nfet_06v0 ad=0.44p pd=2.88u as=0.44p ps=2.88u w=1u l=0.7u
X308 VDD.t149 a_15044_280595# a_15044_280595# VDD.t148 pfet_06v0 ad=1.76p pd=8.88u as=1.76p ps=8.88u w=4u l=1.1u
X309 x1.OUT2 a_5090_282373# VSS.t114 ppolyf_u_1k r_width=1u r_length=2u
X310 x1.x4.x2.VREF a_13867_273711# VDD.t84 VDD.t83 pfet_06v0 ad=4.4p pd=20.88u as=4.4p ps=20.88u w=10u l=5u
X311 VSS.t79 CEN a_33989_250071# VSS.t40 nfet_06v0 ad=0.88p pd=4.88u as=1.96p ps=3.96u w=2u l=0.7u
X312 VDD.t50 DISABLE a_34961_250959# VDD.t49 pfet_06v0 ad=0.44p pd=2.88u as=0.44p ps=2.88u w=1u l=0.55u
X313 VDD.t99 x1.EN2 a_25120_282778# VDD.t98 pfet_06v0 ad=0.44p pd=2.88u as=0.44p ps=2.88u w=1u l=0.55u
X314 PROG.t0 x2.x1.OUT VDD.t214 VDD.t213 pfet_06v0 ad=0.52p pd=2.52u as=0.52p ps=2.52u w=2u l=1u
X315 GATE a_28942_249702# VDD.t19 VDD.t17 pfet_06v0 ad=2.08p pd=8.52u as=2.08p ps=8.52u w=8u l=0.7u
X316 VDD.t232 x2.x1.OUT PROG.t8 VDD.t231 pfet_06v0 ad=0.52p pd=2.52u as=0.52p ps=2.52u w=2u l=1u
X317 a_8361_273711# a_8361_273711# VDD.t79 VDD.t78 pfet_06v0 ad=1.76p pd=8.88u as=1.76p ps=8.88u w=4u l=1.1u
X318 a_22508_281381# VDD.t147 VSS.t200 ppolyf_u_1k r_width=1u r_length=2u
X319 x2.x1.OUT a_12151_252030# VDD.t173 VDD.t172 pfet_06v0 ad=4.16p pd=16.52u as=4.16p ps=16.52u w=16u l=1.1u
X320 a_9718_309015# x4.VREF VSS.t70 ppolyf_u_1k_6p0 r_width=1u r_length=5u
X321 VDD.t190 a_12150_310776# a_12835_310048# VDD.t189 pfet_06v0 ad=3.52p pd=16.88u as=3.52p ps=16.88u w=8u l=1.1u
X322 VDD.t13 S0.t4 x1.S0N VDD.t12 pfet_06v0 ad=0.44p pd=2.88u as=0.44p ps=2.88u w=1u l=0.55u
X323 a_32580_277758# a_31404_278437# VSS.t33 VSS.t49 nfet_06v0 ad=1.32p pd=6.88u as=1.32p ps=6.88u w=3u l=1.4u
X324 x8.schmitt_0.Y x8.schmitt_0.A a_43001_277554# VSS.t20 nfet_06v0 ad=1.76p pd=8.88u as=1.76p ps=8.88u w=4u l=0.7u
X325 a_54864_275577# a_54864_264981# VSS.t51 ppolyf_u_1k_6p0 r_width=1u r_length=50u
X326 VDD.t92 a_7588_288447# a_7636_287302# VDD.t91 pfet_06v0 ad=4.4p pd=20.88u as=4.4p ps=20.88u w=10u l=5u
D26 a_17973_285088# VSS.t31 diode_pd2nw_06v0 pj=12u area=5p
X327 OPOUT a_38304_270558# VSS.t182 ppolyf_u_1k_6p0 r_width=1u r_length=57.5u
X328 VDD.t170 a_12151_252030# a_12836_251302# VDD.t168 pfet_06v0 ad=3.52p pd=16.88u as=3.52p ps=16.88u w=8u l=1.1u
X329 x1.x3.R a_22508_278263# VSS.t82 ppolyf_u_1k r_width=1u r_length=10u
X330 BAT a_54864_275577# VSS.t51 ppolyf_u_1k_6p0 r_width=1u r_length=50u
X331 a_22478_250994# a_22478_250994# VSS.t61 VSS.t40 nfet_06v0 ad=1.32p pd=6.88u as=1.32p ps=6.88u w=3u l=1.4u
X332 VDD.t188 a_12150_310776# a_12150_310776# VDD.t187 pfet_06v0 ad=1.76p pd=8.88u as=1.76p ps=8.88u w=4u l=1.1u
X333 VDD.t110 a_21793_252030# x2.x3.OUT VDD.t108 pfet_06v0 ad=7.04p pd=32.88u as=4.16p ps=16.52u w=16u l=1.1u
X334 x11.schmitt_0.Y x11.schmitt_0.A a_27906_309737# VDD.t167 pfet_06v0 ad=1.76p pd=8.88u as=1.76p ps=8.88u w=4u l=0.55u
X335 x1.EN3 x1.S0N a_25612_281782# VSS.t259 nfet_06v0 ad=0.88p pd=4.88u as=1.96p ps=3.96u w=2u l=0.7u
X336 VDD.t185 a_3855_36764# PU.t0 VDD.t185 pfet_06v0 ad=3.52p pd=16.88u as=2.08p ps=8.52u w=8u l=0.55u
X337 VDD.t169 a_12151_252030# a_12151_252030# VDD.t168 pfet_06v0 ad=1.76p pd=8.88u as=1.76p ps=8.88u w=4u l=1.1u
X338 PROG.t3 x2.x1.OUT VDD.t206 VDD.t205 pfet_06v0 ad=0.52p pd=2.52u as=0.52p ps=2.52u w=2u l=1u
X339 VSS.t263 VDD.t59 cap_mim_2f0_m4m5_noshield c_width=25u c_length=25u
X340 VDD.t105 x1.S1N x1.EN1 VDD.t104 pfet_06v0 ad=0.88p pd=4.88u as=0.88p ps=4.88u w=2u l=0.55u
X341 VSS.t92 x1.EN3 a_25120_280506# VSS.t177 nfet_06v0 ad=0.44p pd=2.88u as=0.44p ps=2.88u w=1u l=0.7u
X342 RESET x8.schmitt_0.Y VSS.t186 VSS.t187 nfet_06v0 ad=2.08p pd=8.52u as=3.52p ps=16.88u w=8u l=0.7u
X343 a_14012_250994# a_12836_250994# VSS.t132 VSS.t40 nfet_06v0 ad=1.32p pd=6.88u as=1.32p ps=6.88u w=3u l=1.4u
X344 x1.x1.R a_22462_286211# VSS.t21 ppolyf_u_1k r_width=1u r_length=10u
X345 VDD.t133 x1.EN3 a_25120_280506# VDD.t132 pfet_06v0 ad=0.44p pd=2.88u as=0.44p ps=2.88u w=1u l=0.55u
R0 PD.n10 PD.n1 54.9632
R1 PD.n5 PD 49.9364
R2 PD.n7 PD.n6 45.3235
R3 PD.n6 PD.n5 45.3219
R4 PD.n10 PD.t0 32.8056
R5 PD.n8 PD.n7 26.5698
R6 PD.n9 PD.n0 24.3294
R7 PD.n3 PD.n9 18.4135
R8 PD.n4 PD.n8 18.4135
R9 PD.n2 PD.n11 18.4119
R10 PD.n11 PD.n10 14.6898
R11 PD.n12 PD 5.45066
R12 PD PD.n12 4.61655
R13 PD.n2 PD 4.61655
R14 PD.n2 PD 4.61655
R15 PD.n11 PD 4.61655
R16 PD.n1 PD 4.61655
R17 PD.n1 PD 4.61655
R18 PD.n3 PD 4.61655
R19 PD.n3 PD 4.61655
R20 PD.n9 PD 4.61655
R21 PD.n0 PD 4.61655
R22 PD.n0 PD 4.61655
R23 PD.n4 PD 4.61655
R24 PD.n4 PD 4.61655
R25 PD.n8 PD 4.61655
R26 PD.n7 PD 4.61655
R27 PD.n6 PD 4.61655
R28 PD.n5 PD 4.61655
R29 PD.n0 PD.n4 2.57996
R30 PD.n1 PD.n3 2.57836
R31 PD.n12 PD.n2 1.74586
R32 PU.n5 PU.n4 76.8348
R33 PU.n0 PU 50.0706
R34 PU.n5 PU.n3 45.3235
R35 PU.n1 PU.n0 45.3235
R36 PU.n2 PU.n1 45.3219
R37 PU.n4 PU.t0 31.1917
R38 PU.n3 PU.n2 24.6959
R39 PU.n4 PU 18.5561
R40 PU PU.n5 4.74918
R41 PU.n3 PU 4.74918
R42 PU.n2 PU 4.74918
R43 PU.n1 PU 4.74918
R44 PU.n0 PU 4.74918
R45 PROG.n0 PROG.t12 40.929
R46 PROG PROG.n1 15.8534
R47 PROG.n0 PROG.t11 3.8699
R48 PROG.n1 PROG.t5 2.8012
R49 PROG.n1 PROG.t4 2.8012
R50 PROG.n1 PROG.t3 2.8012
R51 PROG.n1 PROG.t2 2.8012
R52 PROG.n1 PROG.t0 2.8012
R53 PROG.n1 PROG.t1 2.8012
R54 PROG.n0 PROG.t9 2.8012
R55 PROG.n0 PROG.t6 2.8012
R56 PROG.n0 PROG.t7 2.8012
R57 PROG.n0 PROG.t8 2.8012
R58 PROG.n0 PROG.t10 2.8012
R59 PROG.n1 PROG.n0 1.50794
R60 DONEb DONEb.n0 290.293
R61 DONEb.n0 DONEb.t1 2.97601
R62 DONEb.n0 DONEb.t0 2.83463
R63 S1 S1.n0 130.685
R64 S1.n1 S1.t0 30.5819
R65 S1.n2 S1.t2 30.5671
R66 S1.n0 S1.t4 22.8804
R67 S1.n3 S1.n1 13.3366
R68 S1.n1 S1.t1 12.7383
R69 S1.n2 S1.t3 12.7381
R70 S1.n0 S1.t5 12.7137
R71 S1.n0 S1.n3 12.2933
R72 S1.n3 S1.n2 1.63407
R73 S0 S0.n0 76.3054
R74 S0.n2 S0.t2 30.5819
R75 S0.n1 S0.t0 30.5671
R76 S0.n0 S0.t4 22.8789
R77 S0.n3 S0.n1 19.1069
R78 S0.n2 S0.t3 12.7383
R79 S0.n1 S0.t1 12.7381
R80 S0.n0 S0.t5 12.6999
R81 S0.n3 S0.n2 10.9934
R82 S0.n0 S0.n3 9.04525
R83 PWRENb PWRENb.n2 329.079
R84 PWRENb.n2 PWRENb.n0 72.2501
R85 PWRENb.n1 PWRENb.t5 30.5819
R86 PWRENb.n1 PWRENb.t4 12.7383
R87 PWRENb.n2 PWRENb.n1 4.70505
R88 PWRENb.n0 PWRENb.t0 2.32738
R89 PWRENb.n0 PWRENb.t3 2.28715
R90 PWRENb.n0 PWRENb.t2 2.22981
R91 PWRENb.n0 PWRENb.t1 2.20527
R92 VDD.n264 VDD.t49 2618.32
R93 VDD.t41 VDD.t185 2319.25
R94 VDD.t0 VDD.t49 2112.85
R95 VDD.t57 VDD.t22 1835.47
R96 VDD.t36 VDD.n9 0.0124345
R97 VDD.t156 VDD.t36 0.753637
R98 VDD.t2 VDD.t4 1495.28
R99 VDD.t6 VDD.t4 1495.28
R100 VDD.t83 VDD.t85 1495.28
R101 VDD.t87 VDD.t85 1495.28
R102 VDD.t91 VDD.t89 1495.28
R103 VDD.t91 VDD.t93 1495.28
R104 VDD.t63 VDD.t61 1495.28
R105 VDD.t65 VDD.t61 1495.28
R106 VDD.n47 VDD.t245 1464.91
R107 VDD.t148 VDD.t38 1288.45
R108 VDD.t256 VDD.t154 1288.45
R109 VDD.t83 VDD.t78 1288.45
R110 VDD.t93 VDD.t180 1288.45
R111 VDD.t53 VDD.t17 1190.7
R112 VDD.t6 VDD.t187 1166.37
R113 VDD.t245 VDD.n200 1162.28
R114 VDD.n482 VDD.n298 1006.4
R115 VDD.n480 VDD.t65 790.434
R116 VDD.t242 VDD.t135 750.769
R117 VDD.t184 VDD.t135 750.769
R118 VDD.t118 VDD.t120 750.769
R119 VDD.t101 VDD.t120 750.769
R120 VDD.n483 VDD.n169 698.601
R121 VDD.t193 VDD.t57 683.721
R122 VDD.n271 VDD.t53 616.279
R123 VDD.t150 VDD.t146 563.324
R124 VDD.t254 VDD.t244 563.324
R125 VDD.t161 VDD.t241 563.324
R126 VDD.t183 VDD.t189 563.324
R127 VDD.t80 VDD.t262 563.324
R128 VDD.t251 VDD.t178 563.324
R129 VDD.n192 VDD.t27 532.242
R130 VDD.n318 VDD.n169 527.14
R131 VDD.n507 VDD.n506 447.075
R132 VDD.n15 VDD.t184 409.522
R133 VDD.t101 VDD.n124 409.522
R134 VDD.t14 VDD.t16 382.623
R135 VDD.t167 VDD.t165 382.623
R136 VDD.t153 VDD.n366 375.932
R137 VDD.n396 VDD.t95 375.932
R138 VDD.t122 VDD.n119 375.932
R139 VDD.n649 VDD.t131 375.932
R140 VDD.n450 VDD.t33 375.932
R141 VDD.n621 VDD.t34 375.932
R142 VDD.t148 VDD.t146 339.829
R143 VDD.t256 VDD.t244 339.829
R144 VDD.t159 VDD.t241 339.829
R145 VDD.t183 VDD.t187 339.829
R146 VDD.t78 VDD.t262 339.829
R147 VDD.t251 VDD.t180 339.829
R148 VDD.t239 VDD.t237 333.334
R149 VDD.t235 VDD.t233 333.334
R150 VDD.t233 VDD.t231 333.334
R151 VDD.t231 VDD.t229 333.334
R152 VDD.t229 VDD.t227 333.334
R153 VDD.t227 VDD.t225 333.334
R154 VDD.t225 VDD.t223 333.334
R155 VDD.t223 VDD.t221 333.334
R156 VDD.t221 VDD.t219 333.334
R157 VDD.t219 VDD.t217 333.334
R158 VDD.t217 VDD.t215 333.334
R159 VDD.t215 VDD.t213 333.334
R160 VDD.t213 VDD.t211 333.334
R161 VDD.t211 VDD.t209 333.334
R162 VDD.t209 VDD.t207 333.334
R163 VDD.t207 VDD.t205 333.334
R164 VDD.t205 VDD.t203 333.334
R165 VDD.t203 VDD.t201 333.334
R166 VDD.t201 VDD.t199 333.334
R167 VDD.t199 VDD.t197 333.334
R168 VDD.t197 VDD.t195 333.334
R169 VDD.n483 VDD.t239 325.462
R170 VDD.t195 VDD.n169 325.462
R171 VDD.n189 VDD.t247 276.12
R172 VDD.t249 VDD.n238 276.12
R173 VDD.n0 VDD.t246 276.12
R174 VDD.t30 VDD.n265 276.12
R175 VDD.n192 VDD.t82 275.219
R176 VDD.t82 VDD.n191 275.219
R177 VDD.n191 VDD.t247 275.219
R178 VDD.n239 VDD.t249 275.219
R179 VDD.n239 VDD.t96 275.219
R180 VDD.t96 VDD.n200 275.219
R181 VDD.n47 VDD.t243 275.219
R182 VDD.n245 VDD.t243 275.219
R183 VDD.t246 VDD.n245 275.219
R184 VDD.n266 VDD.t30 275.219
R185 VDD.n266 VDD.t144 275.219
R186 VDD.t144 VDD.n264 275.219
R187 VDD.n373 VDD.n369 220.15
R188 VDD.n397 VDD.n395 220.15
R189 VDD.n622 VDD.n593 220.15
R190 VDD.n629 VDD.n35 220.15
R191 VDD.n650 VDD.n107 220.15
R192 VDD.n451 VDD.n449 220.15
R193 VDD.n237 VDD.n236 212.653
R194 VDD.n138 VDD.n135 212.653
R195 VDD.t237 VDD.n482 209.43
R196 VDD.n287 VDD.n275 196.875
R197 VDD.n325 VDD.n319 196.875
R198 VDD.n502 VDD.t12 194.802
R199 VDD.n580 VDD.t69 193.65
R200 VDD.n506 VDD.t72 193.226
R201 VDD.t72 VDD.n505 193.226
R202 VDD.n505 VDD.t12 193.226
R203 VDD.t69 VDD.n579 193.077
R204 VDD.n579 VDD.t67 193.077
R205 VDD.t67 VDD.n578 193.077
R206 VDD.t8 VDD.n493 193.077
R207 VDD.n544 VDD.t8 193.077
R208 VDD.t70 VDD.n544 193.077
R209 VDD.n545 VDD.t70 193.077
R210 VDD.t134 VDD.n546 193.077
R211 VDD.n547 VDD.t134 193.077
R212 VDD.n547 VDD.t132 193.077
R213 VDD.t132 VDD.n535 193.077
R214 VDD.t74 VDD.n554 193.077
R215 VDD.n555 VDD.t74 193.077
R216 VDD.n555 VDD.t260 193.077
R217 VDD.t260 VDD.n534 193.077
R218 VDD.t100 VDD.n521 193.077
R219 VDD.n526 VDD.t100 193.077
R220 VDD.t98 VDD.n526 193.077
R221 VDD.n527 VDD.t98 193.077
R222 VDD.n528 VDD.t106 193.077
R223 VDD.n564 VDD.t106 193.077
R224 VDD.t10 VDD.n564 193.077
R225 VDD.n565 VDD.t10 193.077
R226 VDD.n566 VDD.t56 193.077
R227 VDD.n570 VDD.t56 193.077
R228 VDD.t54 VDD.n570 193.077
R229 VDD.n571 VDD.t54 193.077
R230 VDD.n512 VDD.t258 193.077
R231 VDD.n508 VDD.t258 193.077
R232 VDD.n508 VDD.t104 193.077
R233 VDD.t104 VDD.n507 193.077
R234 VDD.n15 VDD.t14 191.311
R235 VDD.t16 VDD.n222 191.311
R236 VDD.n222 VDD.t136 191.311
R237 VDD.n236 VDD.t136 191.311
R238 VDD.t165 VDD.n124 191.311
R239 VDD.n137 VDD.t167 191.311
R240 VDD.t123 VDD.n137 191.311
R241 VDD.n138 VDD.t123 191.311
R242 VDD.n487 VDD.n163 187.608
R243 VDD.n487 VDD.n164 176.925
R244 VDD.n334 VDD.n327 176.925
R245 VDD.n271 VDD.t51 154.651
R246 VDD.n287 VDD.n274 153.3
R247 VDD.n319 VDD.n170 153.3
R248 VDD.n334 VDD.n318 153.3
R249 VDD.t51 VDD.n171 148.256
R250 VDD.n569 VDD.n567 140.525
R251 VDD.n525 VDD.n523 140.525
R252 VDD.n548 VDD.n539 140.525
R253 VDD.n580 VDD.n491 140.525
R254 VDD.n35 VDD.t163 140.506
R255 VDD.n650 VDD.t191 140.506
R256 VDD.n691 VDD.n690 126.507
R257 VDD.n210 VDD.n211 123.989
R258 VDD.n134 VDD.n132 123.989
R259 VDD.n481 VDD.t235 122.808
R260 VDD.n677 VDD.n96 122.62
R261 VDD.n479 VDD.n301 122.48
R262 VDD.n629 VDD.n119 119.892
R263 VDD.n649 VDD.n107 119.892
R264 VDD.t141 VDD.n211 116.32
R265 VDD.n210 VDD.t138 116.32
R266 VDD.t128 VDD.n134 116.32
R267 VDD.n132 VDD.t124 116.32
R268 VDD.n466 VDD.n302 115.501
R269 VDD.n474 VDD.n465 115.501
R270 VDD.t36 VDD.n48 167.411
R271 VDD.n356 VDD.t36 167.231
R272 VDD.n97 VDD.n95 115.501
R273 VDD.n672 VDD.n666 115.501
R274 VDD.n430 VDD.n421 115.501
R275 VDD.n431 VDD.n414 115.501
R276 VDD.n607 VDD.n605 115.501
R277 VDD.n614 VDD.n604 115.501
R278 VDD.n546 VDD.n545 112.308
R279 VDD.n534 VDD.n521 112.308
R280 VDD.n566 VDD.n565 112.308
R281 VDD.t153 VDD.t150 110.603
R282 VDD.t254 VDD.t95 110.603
R283 VDD.t122 VDD.t161 110.603
R284 VDD.t131 VDD.t189 110.603
R285 VDD.t80 VDD.t33 110.603
R286 VDD.t34 VDD.t178 110.603
R287 VDD.n307 VDD.n300 109.695
R288 VDD.n678 VDD.n94 109.695
R289 VDD.n470 VDD.n465 103.951
R290 VDD.n467 VDD.n465 103.951
R291 VDD.n467 VDD.n466 103.951
R292 VDD.n466 VDD.n300 103.951
R293 VDD.n474 VDD.n473 103.951
R294 VDD.n475 VDD.n474 103.951
R295 VDD.n475 VDD.n302 103.951
R296 VDD.n479 VDD.n302 103.951
R297 VDD.n87 VDD.n356 103.951
R298 VDD.n367 VDD.n356 103.951
R299 VDD.n367 VDD.n48 103.951
R300 VDD.n368 VDD.n48 103.951
R301 VDD.n669 VDD.n666 103.951
R302 VDD.n667 VDD.n666 103.951
R303 VDD.n667 VDD.n95 103.951
R304 VDD.n678 VDD.n95 103.951
R305 VDD.n672 VDD.n671 103.951
R306 VDD.n673 VDD.n672 103.951
R307 VDD.n673 VDD.n97 103.951
R308 VDD.n677 VDD.n97 103.951
R309 VDD.n431 VDD.n89 103.951
R310 VDD.n432 VDD.n431 103.951
R311 VDD.n432 VDD.n430 103.951
R312 VDD.n430 VDD.n429 103.951
R313 VDD.n439 VDD.n414 103.951
R314 VDD.n422 VDD.n414 103.951
R315 VDD.n422 VDD.n421 103.951
R316 VDD.n425 VDD.n421 103.951
R317 VDD.n88 VDD.n607 103.951
R318 VDD.n612 VDD.n607 103.951
R319 VDD.n612 VDD.n604 103.951
R320 VDD.n28 VDD.n604 103.951
R321 VDD.n611 VDD.n605 103.951
R322 VDD.n613 VDD.n605 103.951
R323 VDD.n614 VDD.n613 103.951
R324 VDD.n615 VDD.n614 103.951
R325 VDD.n369 VDD.t151 103.746
R326 VDD.t252 VDD.n395 103.746
R327 VDD.t76 VDD.n449 103.746
R328 VDD.t182 VDD.n593 103.746
R329 VDD.n6 VDD.n359 102.144
R330 VDD.n7 VDD.n354 102.144
R331 VDD.n639 VDD.n638 102.144
R332 VDD.n438 VDD.n410 102.144
R333 VDD.n26 VDD.n602 102.144
R334 VDD.n485 VDD.n167 99.0416
R335 VDD.t138 VDD.t140 98.8914
R336 VDD.t124 VDD.t126 98.8914
R337 VDD.n375 VDD.n365 98.7005
R338 VDD.n387 VDD.n386 98.7005
R339 VDD.n596 VDD.n595 98.7005
R340 VDD.n635 VDD.n117 98.7005
R341 VDD.n109 VDD.n108 98.7005
R342 VDD.n447 VDD.n446 98.7005
R343 VDD.n219 VDD.n218 96.6005
R344 VDD.n130 VDD.n129 96.6005
R345 VDD.n165 VDD.n164 95.8079
R346 VDD.n328 VDD.n327 95.8079
R347 VDD.t15 VDD.n218 92.2255
R348 VDD.n129 VDD.n128 92.2255
R349 VDD.n578 VDD.n493 90.7697
R350 VDD.n554 VDD.n535 90.7697
R351 VDD.n528 VDD.n527 90.7697
R352 VDD.n571 VDD.n512 90.7697
R353 VDD.n389 VDD.n354 89.863
R354 VDD.n444 VDD.n410 89.863
R355 VDD.n377 VDD.n359 89.7755
R356 VDD.n638 VDD.n637 89.7755
R357 VDD.n661 VDD.n102 89.7755
R358 VDD.n617 VDD.n602 89.7755
R359 VDD.n270 VDD.n179 89.4255
R360 VDD.n580 VDD.n492 89.0755
R361 VDD.n373 VDD.n366 88.5376
R362 VDD.n397 VDD.n396 88.5376
R363 VDD.n451 VDD.n450 88.5376
R364 VDD.n622 VDD.n621 88.5376
R365 VDD.n166 VDD.n165 86.4505
R366 VDD.n331 VDD.n328 86.4505
R367 VDD.n370 VDD.n358 86.4505
R368 VDD.n371 VDD.n370 86.4505
R369 VDD.n371 VDD.n369 86.4505
R370 VDD.n373 VDD.n372 86.4505
R371 VDD.n395 VDD.n349 86.4505
R372 VDD.n8 VDD.n349 86.4505
R373 VDD.n8 VDD.n348 86.4505
R374 VDD.n397 VDD.n353 86.4505
R375 VDD.n610 VDD.n609 86.4505
R376 VDD.n609 VDD.n608 86.4505
R377 VDD.n608 VDD.n593 86.4505
R378 VDD.n622 VDD.n594 86.4505
R379 VDD.n626 VDD.n113 86.4505
R380 VDD.n627 VDD.n626 86.4505
R381 VDD.n627 VDD.n35 86.4505
R382 VDD.n629 VDD.n628 86.4505
R383 VDD.n653 VDD.n652 86.4505
R384 VDD.n652 VDD.n651 86.4505
R385 VDD.n651 VDD.n650 86.4505
R386 VDD.n107 VDD.n106 86.4505
R387 VDD.n449 VDD.n404 86.4505
R388 VDD.n457 VDD.n404 86.4505
R389 VDD.n457 VDD.n403 86.4505
R390 VDD.n451 VDD.n448 86.4505
R391 VDD.n42 VDD.n685 86.536
R392 VDD.n687 VDD.n685 86.4505
R393 VDD.t185 VDD.n684 86.4505
R394 VDD.n83 VDD.n684 86.4505
R395 VDD.n243 VDD.n202 83.3005
R396 VDD.n243 VDD.n198 83.3005
R397 VDD.n207 VDD.n201 83.3005
R398 VDD.n201 VDD.n199 83.3005
R399 VDD.n260 VDD.n32 83.3005
R400 VDD.n84 VDD.n184 83.3005
R401 VDD.n31 VDD.n181 83.3005
R402 VDD.n270 VDD.n181 83.3005
R403 VDD.n273 VDD.n178 83.3005
R404 VDD.n184 VDD.n178 83.3005
R405 VDD.n259 VDD.n30 83.3005
R406 VDD.n223 VDD.n220 82.3905
R407 VDD.n44 VDD.n220 18.2408
R408 VDD.n149 VDD.n122 82.3905
R409 VDD.n37 VDD.n122 82.3905
R410 VDD.n237 VDD.t141 81.3314
R411 VDD.n135 VDD.t128 81.3314
R412 VDD.n332 VDD.n307 78.7505
R413 VDD.n654 VDD.n94 78.7505
R414 VDD.n189 VDD.n188 74.7255
R415 VDD.n189 VDD.n187 74.7255
R416 VDD.n235 VDD.n212 74.7255
R417 VDD.n235 VDD.n213 74.7255
R418 VDD.n238 VDD.n208 74.7255
R419 VDD.n238 VDD.n206 74.7255
R420 VDD.n0 VDD.n195 74.7255
R421 VDD.n0 VDD.n196 74.7255
R422 VDD.n263 VDD.n255 74.7255
R423 VDD.n265 VDD.n256 74.7255
R424 VDD.n265 VDD.n255 74.7255
R425 VDD.n36 VDD.n127 74.7255
R426 VDD.n36 VDD.n131 74.7255
R427 VDD.n218 VDD.n212 72.6255
R428 VDD.n550 VDD.n538 72.6255
R429 VDD.n533 VDD.n532 72.6255
R430 VDD.n513 VDD.n499 72.6255
R431 VDD.n129 VDD.n127 72.6255
R432 VDD.n500 VDD.n21 71.5755
R433 VDD.n510 VDD.n21 71.5755
R434 VDD.n220 VDD.n219 68.6005
R435 VDD.n130 VDD.n122 68.6005
R436 VDD.n541 VDD.n540 64.3441
R437 VDD.n553 VDD.n519 64.3441
R438 VDD.n529 VDD.n516 64.3441
R439 VDD.n511 VDD.n510 64.3441
R440 VDD.n187 VDD.n186 63.1755
R441 VDD.n206 VDD.n202 63.1755
R442 VDD.n503 VDD.n152 62.8255
R443 VDD.n501 VDD.n152 62.8255
R444 VDD.n502 VDD.n501 62.8255
R445 VDD.n503 VDD.n502 62.8255
R446 VDD.n577 VDD.n492 62.8255
R447 VDD.n551 VDD.n550 62.8255
R448 VDD.n532 VDD.n524 62.8255
R449 VDD.n572 VDD.n499 62.8255
R450 VDD.n257 VDD.n256 62.6505
R451 VDD.n568 VDD.n498 62.3005
R452 VDD.n531 VDD.n530 62.3005
R453 VDD.n549 VDD.n536 62.3005
R454 VDD.n495 VDD.n494 62.3005
R455 VDD.n198 VDD.n195 62.1405
R456 VDD.n285 VDD.n275 57.0066
R457 VDD.n325 VDD.n324 57.0066
R458 VDD.n685 VDD.n684 56.3505
R459 VDD.n282 VDD.n280 55.69
R460 VDD.n184 VDD.n181 55.3005
R461 VDD.n516 VDD.n513 54.368
R462 VDD.n517 VDD.n513 54.368
R463 VDD.n533 VDD.n519 54.368
R464 VDD.n533 VDD.n520 54.368
R465 VDD.n541 VDD.n538 54.368
R466 VDD.n542 VDD.n538 54.368
R467 VDD.n322 VDD.n301 52.8479
R468 VDD.n500 VDD.n498 52.6814
R469 VDD.n530 VDD.n517 52.6814
R470 VDD.n536 VDD.n520 52.6814
R471 VDD.n542 VDD.n495 52.6814
R472 VDD.n284 VDD.n282 51.4505
R473 VDD.n285 VDD.n284 51.4505
R474 VDD.n485 VDD.n166 51.4505
R475 VDD.n322 VDD.n320 51.4505
R476 VDD.n324 VDD.n320 51.4505
R477 VDD.n332 VDD.n331 51.4505
R478 VDD.n6 VDD.n358 51.4505
R479 VDD.n377 VDD.n376 51.4505
R480 VDD.n376 VDD.n375 51.4505
R481 VDD.n7 VDD.n348 51.4505
R482 VDD.n388 VDD.n387 51.4505
R483 VDD.n389 VDD.n388 51.4505
R484 VDD.n617 VDD.n600 51.4505
R485 VDD.n600 VDD.n595 51.4505
R486 VDD.n26 VDD.n610 51.4505
R487 VDD.n639 VDD.n113 51.4505
R488 VDD.n637 VDD.n636 51.4505
R489 VDD.n636 VDD.n635 51.4505
R490 VDD.n654 VDD.n653 51.4505
R491 VDD.n661 VDD.n101 51.4505
R492 VDD.n108 VDD.n101 51.4505
R493 VDD.n438 VDD.n403 51.4505
R494 VDD.n446 VDD.n445 51.4505
R495 VDD.n445 VDD.n444 51.4505
R496 VDD.n254 VDD.n253 51.4505
R497 VDD.n49 VDD.n254 51.4505
R498 VDD.n70 VDD.n248 51.4505
R499 VDD.n50 VDD.n248 51.4505
R500 VDD.n568 VDD.n499 50.4005
R501 VDD.n532 VDD.n531 50.4005
R502 VDD.n550 VDD.n549 50.4005
R503 VDD.n494 VDD.n492 50.4005
R504 VDD.n221 VDD.n213 48.3005
R505 VDD.n136 VDD.n131 48.3005
R506 VDD.n318 VDD.n170 47.9774
R507 VDD.n227 VDD.n224 47.2505
R508 VDD.n232 VDD.n226 47.2505
R509 VDD.n284 VDD.n283 47.2505
R510 VDD.n279 VDD.n166 47.2505
R511 VDD.n320 VDD.n310 47.2505
R512 VDD.n331 VDD.n330 47.2505
R513 VDD.n372 VDD.n371 47.2505
R514 VDD.n376 VDD.n364 47.2505
R515 VDD.n353 VDD.n349 47.2505
R516 VDD.n380 VDD.n348 47.2505
R517 VDD.n388 VDD.n350 47.2505
R518 VDD.n362 VDD.n358 47.2505
R519 VDD.n600 VDD.n598 47.2505
R520 VDD.n610 VDD.n599 47.2505
R521 VDD.n608 VDD.n594 47.2505
R522 VDD.n628 VDD.n627 47.2505
R523 VDD.n636 VDD.n116 47.2505
R524 VDD.n114 VDD.n113 47.2505
R525 VDD.n651 VDD.n106 47.2505
R526 VDD.n103 VDD.n101 47.2505
R527 VDD.n653 VDD.n104 47.2505
R528 VDD.n125 VDD.n123 47.2505
R529 VDD.n144 VDD.n142 47.2505
R530 VDD.n448 VDD.n404 47.2505
R531 VDD.n416 VDD.n403 47.2505
R532 VDD.n445 VDD.n405 47.2505
R533 VDD.n254 VDD.n248 47.2505
R534 VDD.n258 VDD.n257 44.013
R535 VDD.n261 VDD.n257 44.013
R536 VDD.n219 VDD.n213 43.9255
R537 VDD.n131 VDD.n130 43.9255
R538 VDD.n342 VDD.t168 43.7148
R539 VDD.n333 VDD.t168 43.7148
R540 VDD.n174 VDD.t108 43.7148
R541 VDD.n486 VDD.t108 43.7148
R542 VDD.t29 VDD.t174 42.8576
R543 VDD.n232 VDD.n231 42.7005
R544 VDD.n14 VDD.n232 42.7005
R545 VDD.n14 VDD.n224 42.7005
R546 VDD.n233 VDD.n224 42.7005
R547 VDD.n230 VDD.n226 42.7005
R548 VDD.n228 VDD.n226 42.7005
R549 VDD.n228 VDD.n227 42.7005
R550 VDD.n227 VDD.n223 42.7005
R551 VDD.n60 VDD.n142 42.7005
R552 VDD.n38 VDD.n142 42.7005
R553 VDD.n38 VDD.n123 42.7005
R554 VDD.n37 VDD.n123 42.7005
R555 VDD.n144 VDD.n143 42.7005
R556 VDD.n145 VDD.n144 42.7005
R557 VDD.n145 VDD.n125 42.7005
R558 VDD.n149 VDD.n125 42.7005
R559 VDD.n188 VDD.n185 40.7755
R560 VDD.n208 VDD.n207 40.7755
R561 VDD.n199 VDD.n196 40.7755
R562 VDD.n323 VDD.t176 40.2862
R563 VDD.n286 VDD.t116 40.2862
R564 VDD.n179 VDD.n163 40.2505
R565 VDD.n274 VDD.n273 40.2505
R566 VDD.t32 VDD.n278 36.8576
R567 VDD.n509 VDD.n500 33.9505
R568 VDD.n510 VDD.n509 33.9505
R569 VDD.n563 VDD.n517 33.9505
R570 VDD.n563 VDD.n516 33.9505
R571 VDD.n556 VDD.n520 33.9505
R572 VDD.n556 VDD.n519 33.9505
R573 VDD.n543 VDD.n542 33.9505
R574 VDD.n543 VDD.n541 33.9505
R575 VDD.n307 VDD.n301 33.9093
R576 VDD.n190 VDD.n188 30.8005
R577 VDD.n190 VDD.n187 30.8005
R578 VDD.n240 VDD.n208 30.8005
R579 VDD.n240 VDD.n206 30.8005
R580 VDD.n244 VDD.n196 30.8005
R581 VDD.n244 VDD.n195 30.8005
R582 VDD.n267 VDD.n256 30.8005
R583 VDD.n267 VDD.n255 30.8005
R584 VDD.n483 VDD.n170 30.8005
R585 VDD.n277 VDD.n274 28.7168
R586 VDD.n277 VDD.n163 28.7168
R587 VDD.n360 VDD.n359 26.7755
R588 VDD.n638 VDD.n112 26.7755
R589 VDD.n656 VDD.n102 26.7755
R590 VDD.n602 VDD.n601 26.7755
R591 VDD.n355 VDD.n354 26.688
R592 VDD.n417 VDD.n410 26.688
R593 VDD.n273 VDD.n272 25.7255
R594 VDD.n272 VDD.n179 25.7255
R595 VDD.n504 VDD.n503 25.2005
R596 VDD.n504 VDD.n501 25.2005
R597 VDD.n128 VDD.n122 23.6255
R598 VDD.n481 VDD.t172 23.1434
R599 VDD.t111 VDD.n171 23.1434
R600 VDD.n298 VDD.n297 22.1434
R601 VDD.n193 VDD.n186 22.0505
R602 VDD.n43 VDD.n185 22.0505
R603 VDD.n259 VDD.n258 22.0505
R604 VDD.n261 VDD.n260 22.0505
R605 VDD.n260 VDD.n259 21.963
R606 VDD.t163 VDD.n119 20.6143
R607 VDD.t191 VDD.n649 20.6143
R608 VDD.n343 VDD.n307 20.2916
R609 VDD.t140 VDD.n237 17.5606
R610 VDD.n135 VDD.t126 17.5606
R611 VDD.n1 VDD.n185 16.9755
R612 VDD.n207 VDD.n203 16.9755
R613 VDD.n567 VDD.n513 16.4505
R614 VDD.n533 VDD.n523 16.4505
R615 VDD.n539 VDD.n538 16.4505
R616 VDD.n409 VDD.t44 15.7647
R617 VDD.n372 VDD.n365 15.5189
R618 VDD.n386 VDD.n353 15.5189
R619 VDD.n596 VDD.n594 15.5189
R620 VDD.n628 VDD.n117 15.5189
R621 VDD.n109 VDD.n106 15.5189
R622 VDD.n448 VDD.n447 15.5189
R623 VDD.t151 VDD.n366 15.2083
R624 VDD.n396 VDD.t252 15.2083
R625 VDD.n450 VDD.t76 15.2083
R626 VDD.n621 VDD.t182 15.2083
R627 VDD.n4 VDD.n360 14.7005
R628 VDD.n394 VDD.n355 14.7005
R629 VDD.n640 VDD.n112 14.7005
R630 VDD.n657 VDD.n656 14.7005
R631 VDD.n419 VDD.n417 14.7005
R632 VDD.n601 VDD.n24 14.7005
R633 VDD.t36 VDD.t147 14.3467
R634 VDD.n71 VDD.t55 4.48003
R635 VDD.n173 VDD.n164 13.4789
R636 VDD.n327 VDD.n326 13.4789
R637 VDD.n221 VDD.n212 13.3005
R638 VDD.n136 VDD.n127 13.3005
R639 VDD.n591 VDD.t40 13.0867
R640 VDD.n481 VDD.n480 13.0005
R641 VDD.n96 VDD.n94 12.5096
R642 VDD.n263 VDD.n257 12.0755
R643 VDD.n51 VDD.n247 10.3802
R644 VDD.n139 VDD.t130 10.035
R645 VDD.n296 VDD.n173 9.58547
R646 VDD.n326 VDD.n309 9.58547
R647 VDD.n293 VDD.n13 9.34137
R648 VDD.n316 VDD.n306 9.34137
R649 VDD.n53 VDD.t36 0.515691
R650 VDD.n4 VDD.t36 0.390811
R651 VDD.t162 VDD.n39 9.34137
R652 VDD.n659 VDD.n655 9.34137
R653 VDD.n407 VDD.n402 9.34137
R654 VDD.n480 VDD.n299 9.28621
R655 VDD.n283 VDD.n172 9.07991
R656 VDD.n329 VDD.n310 9.07991
R657 VDD.n364 VDD.n363 9.07991
R658 VDD.n374 VDD.n365 9.07991
R659 VDD.n386 VDD.n351 9.07991
R660 VDD.n381 VDD.n350 9.07991
R661 VDD.n23 VDD.n598 9.07991
R662 VDD.n620 VDD.n596 9.07991
R663 VDD.n116 VDD.n115 9.07991
R664 VDD.n634 VDD.n117 9.07991
R665 VDD.n660 VDD.n103 9.07991
R666 VDD.n648 VDD.n109 9.07991
R667 VDD.n447 VDD.n406 9.07991
R668 VDD.n415 VDD.n405 9.07991
R669 VDD.n280 VDD.n279 8.44682
R670 VDD.n330 VDD.n308 8.44682
R671 VDD.n362 VDD.n360 8.44682
R672 VDD.n380 VDD.n355 8.44682
R673 VDD.n601 VDD.n599 8.44682
R674 VDD.n114 VDD.n112 8.44682
R675 VDD.n656 VDD.n104 8.44682
R676 VDD.n417 VDD.n416 8.44682
R677 VDD.n391 VDD.n390 8.43717
R678 VDD.n686 VDD.t45 6.77319
R679 VDD.n283 VDD.n175 6.09976
R680 VDD.n341 VDD.n310 6.09976
R681 VDD.n22 VDD.n364 6.09976
R682 VDD.n400 VDD.n350 6.09976
R683 VDD.n598 VDD.n597 6.09976
R684 VDD.n120 VDD.n116 6.09976
R685 VDD.n110 VDD.n103 6.09976
R686 VDD.n456 VDD.n405 6.09976
R687 VDD.n278 VDD.t114 6.0005
R688 VDD.n488 VDD.n34 5.95175
R689 VDD.n46 VDD.n199 5.8205
R690 VDD.n511 VDD.n498 5.65982
R691 VDD.n530 VDD.n529 5.65982
R692 VDD.n553 VDD.n536 5.65982
R693 VDD.n540 VDD.n495 5.65982
R694 VDD.n461 VDD.n460 5.14104
R695 VDD.n1 VDD.n186 4.988
R696 VDD.n203 VDD.n202 4.988
R697 VDD.t142 VDD.t28 4.96013
R698 VDD.n588 VDD.n150 4.79862
R699 VDD.n680 VDD.n27 4.72572
R700 VDD.n391 VDD.n382 4.56268
R701 VDD.n13 VDD.n484 4.54335
R702 VDD.n18 VDD.t13 4.47606
R703 VDD.n34 VDD.t50 4.47606
R704 VDD.n74 VDD.t99 4.48003
R705 VDD.n78 VDD.t133 4.48003
R706 VDD.n82 VDD.t68 4.48003
R707 VDD.n19 VDD.t73 4.4205
R708 VDD.n275 VDD.n173 4.22775
R709 VDD.n326 VDD.n325 4.22775
R710 VDD.n624 VDD.n121 3.79062
R711 VDD.n323 VDD.n319 3.60407
R712 VDD.n287 VDD.n286 3.60407
R713 VDD.n102 VDD.n96 3.52677
R714 VDD.t176 VDD.t29 3.42907
R715 VDD.t116 VDD.t32 3.42907
R716 VDD.n460 VDD.n459 3.3755
R717 VDD.n246 VDD.n150 3.18618
R718 VDD.n681 VDD.n680 3.1675
R719 VDD.n625 VDD.n91 3.13983
R720 VDD.t59 VDD.n624 3.0416
R721 VDD.n392 VDD.n391 3.02674
R722 VDD.t162 VDD.t127 3.01851
R723 VDD.n296 VDD.n175 2.98065
R724 VDD.n341 VDD.n309 2.98065
R725 VDD.n2 VDD.n22 0.255387
R726 VDD.n400 VDD.n351 2.98065
R727 VDD.n620 VDD.n597 2.98065
R728 VDD.n634 VDD.n120 2.98065
R729 VDD.n648 VDD.n110 2.98065
R730 VDD.n456 VDD.n406 2.98065
R731 VDD.n385 VDD.n384 2.93679
R732 VDD.n308 VDD.n301 2.84261
R733 VDD.t90 VDD.n45 0.562929
R734 VDD.n379 VDD.t36 2.77395
R735 VDD.n54 VDD.n357 1.14156
R736 VDD.n469 VDD.n464 2.63398
R737 VDD.n477 VDD.n463 2.63398
R738 VDD.n668 VDD.n665 2.63398
R739 VDD.n675 VDD.n93 2.63398
R740 VDD.n424 VDD.n420 2.63398
R741 VDD.n434 VDD.n413 2.63398
R742 VDD.n42 VDD.t185 0.667346
R743 VDD.n342 VDD.t172 2.57193
R744 VDD.n174 VDD.t111 2.57193
R745 VDD.n250 VDD.t24 2.50762
R746 VDD.n336 VDD.t173 2.37275
R747 VDD.n289 VDD.t112 2.37275
R748 VDD.n268 VDD.t19 2.3699
R749 VDD.n472 VDD.n471 2.34772
R750 VDD.n670 VDD.t3 2.34772
R751 VDD.n54 VDD.t36 1.09934
R752 VDD.t42 VDD.n686 2.32238
R753 VDD.n378 VDD.n361 2.30137
R754 VDD.n390 VDD.n385 2.30137
R755 VDD.n616 VDD.n603 2.30137
R756 VDD.n118 VDD.n111 2.30137
R757 VDD.n662 VDD.n100 2.30137
R758 VDD.n443 VDD.n408 2.30137
R759 VDD.n3 VDD.n361 2.25833
R760 VDD.n603 VDD.n592 2.25833
R761 VDD.n631 VDD.n118 2.25833
R762 VDD.n646 VDD.n100 2.25833
R763 VDD.n453 VDD.n408 2.25833
R764 VDD.n314 VDD.t196 2.238
R765 VDD.n34 VDD.t31 2.238
R766 VDD.n262 VDD.t145 2.238
R767 VDD.n56 VDD.t259 2.2105
R768 VDD.n75 VDD.t107 2.2105
R769 VDD.n514 VDD.t11 2.2105
R770 VDD.n552 VDD.t75 2.2105
R771 VDD.n522 VDD.t261 2.2105
R772 VDD.n80 VDD.t9 2.2105
R773 VDD.n537 VDD.t71 2.2105
R774 VDD.t162 VDD.n133 0.33756
R775 VDD.n575 VDD.n490 2.0145
R776 VDD.n313 VDD.t198 2.00485
R777 VDD.n13 VDD.t202 2.00485
R778 VDD.n13 VDD.t206 2.00485
R779 VDD.n13 VDD.t210 2.00485
R780 VDD.n13 VDD.t214 2.00485
R781 VDD.n13 VDD.t218 2.00485
R782 VDD.n13 VDD.t222 2.00485
R783 VDD.n13 VDD.t226 2.00485
R784 VDD.n13 VDD.t230 2.00485
R785 VDD.n13 VDD.t234 2.00485
R786 VDD.n13 VDD.t238 2.00485
R787 VDD.n401 VDD.n27 1.99895
R788 VDD.n688 VDD.n686 1.99354
R789 VDD.t186 VDD.n689 1.96288
R790 VDD.n689 VDD.n688 1.96288
R791 VDD.n484 VDD.t47 1.94636
R792 VDD.n460 VDD.n401 1.83628
R793 VDD.n155 VDD.n154 1.76067
R794 VDD.n58 VDD.n586 1.75978
R795 VDD.n204 VDD.n197 1.7249
R796 VDD.n46 VDD.n198 1.7105
R797 VDD.n624 VDD.n623 1.688
R798 VDD.n442 VDD.n441 1.6224
R799 VDD.t42 VDD.n683 1.618
R800 VDD.n21 VDD.n152 1.61729
R801 VDD.n280 VDD.n167 1.59208
R802 VDD.n343 VDD.n308 1.59208
R803 VDD.t185 VDD.n683 1.583
R804 VDD.n193 VDD.t28 1.5755
R805 VDD.n261 VDD.t49 1.5755
R806 VDD.n34 VDD.n261 1.5755
R807 VDD.n258 VDD.t49 1.5755
R808 VDD.n502 VDD.n18 1.5755
R809 VDD.n506 VDD.n152 1.5755
R810 VDD.n505 VDD.n504 1.5755
R811 VDD.n504 VDD.n19 1.5755
R812 VDD.n578 VDD.n577 1.5755
R813 VDD.n577 VDD.n81 1.5755
R814 VDD.n551 VDD.n535 1.5755
R815 VDD.n79 VDD.n551 1.5755
R816 VDD.n527 VDD.n524 1.5755
R817 VDD.n524 VDD.n76 1.5755
R818 VDD.n572 VDD.n571 1.5755
R819 VDD.n72 VDD.n572 1.5755
R820 VDD.n625 VDD.t59 1.56034
R821 VDD.n378 VDD.t36 1.26757
R822 VDD.n43 VDD.n194 1.52159
R823 VDD.n194 VDD.n193 1.52159
R824 VDD.n443 VDD.n442 1.5168
R825 VDD.t162 VDD.t102 1.49211
R826 VDD.t162 VDD.t121 1.49211
R827 VDD.t162 VDD.t119 1.49211
R828 VDD.n183 VDD.n182 1.47253
R829 VDD.n33 VDD.n183 1.47253
R830 VDD.n689 VDD.n683 1.31137
R831 VDD.n209 VDD.n214 1.30462
R832 VDD.n134 VDD.t162 1.00916
R833 VDD.n281 VDD.n176 1.27568
R834 VDD.n321 VDD.n311 1.27568
R835 VDD.n67 VDD.n77 1.26536
R836 VDD.n64 VDD.n73 1.26536
R837 VDD.n336 VDD.n335 1.26277
R838 VDD.n676 VDD.n664 1.2627
R839 VDD.n478 VDD.n303 1.24391
R840 VDD.n590 VDD.n51 1.2344
R841 VDD.n642 VDD.n111 1.22612
R842 VDD.n488 VDD.n161 1.21527
R843 VDD.n399 VDD.n398 1.12607
R844 VDD.t36 VDD.t257 1.11918
R845 VDD.n51 VDD.t194 1.11918
R846 VDD.n51 VDD.t58 1.11918
R847 VDD.t90 VDD.t181 1.11918
R848 VDD.n616 VDD.t90 1.26757
R849 VDD.n663 VDD.n662 1.10985
R850 VDD.t162 VDD.n625 1.10974
R851 VDD.n41 VDD.t15 0.45414
R852 VDD.t15 VDD.n225 1.10789
R853 VDD.t162 VDD.n52 0.440135
R854 VDD.n147 VDD.t162 1.10789
R855 VDD.n51 VDD.n49 0.8318
R856 VDD.n215 VDD.n216 1.10593
R857 VDD.n140 VDD.n126 1.10593
R858 VDD.n304 VDD.t169 1.1055
R859 VDD.t36 VDD.t149 1.1055
R860 VDD.n437 VDD.t79 1.1055
R861 VDD.n13 VDD.t109 1.1055
R862 VDD.n276 VDD.t52 1.1055
R863 VDD.n482 VDD.n481 1.09699
R864 VDD.n161 VDD.n151 1.09198
R865 VDD.n315 VDD.n314 1.06657
R866 VDD.n41 VDD.n230 0.877195
R867 VDD.n569 VDD.n568 1.0505
R868 VDD.n531 VDD.n525 1.0505
R869 VDD.n549 VDD.n548 1.0505
R870 VDD.n494 VDD.n491 1.0505
R871 VDD.n61 VDD.n55 1.04965
R872 VDD.n64 VDD.n497 1.03746
R873 VDD.n67 VDD.n496 1.03746
R874 VDD.n575 VDD.n159 1.03746
R875 VDD.t28 VDD.n197 1.02351
R876 VDD.n52 VDD.n143 0.871749
R877 VDD.n215 VDD.n234 0.977643
R878 VDD.n141 VDD.n140 0.977643
R879 VDD.n288 VDD.n177 0.963719
R880 VDD.n312 VDD.n168 0.963719
R881 VDD.n214 VDD.n205 0.954896
R882 VDD.n34 VDD.n30 0.875932
R883 VDD.n34 VDD.n33 0.952364
R884 VDD.t97 VDD.n203 0.951615
R885 VDD.n393 VDD.n392 0.93963
R886 VDD.n392 VDD.n352 0.932916
R887 VDD.t198 VDD.t200 0.9105
R888 VDD.t202 VDD.t204 0.9105
R889 VDD.t206 VDD.t208 0.9105
R890 VDD.t210 VDD.t212 0.9105
R891 VDD.t214 VDD.t216 0.9105
R892 VDD.t218 VDD.t220 0.9105
R893 VDD.t222 VDD.t224 0.9105
R894 VDD.t226 VDD.t228 0.9105
R895 VDD.t230 VDD.t232 0.9105
R896 VDD.t234 VDD.t236 0.9105
R897 VDD.t238 VDD.t240 0.9105
R898 VDD.t28 VDD.n0 0.9005
R899 VDD.n1 VDD.n192 0.9005
R900 VDD.t248 VDD.n189 0.9005
R901 VDD.n191 VDD.n190 0.9005
R902 VDD.n245 VDD.n244 0.9005
R903 VDD.n46 VDD.n47 0.9005
R904 VDD.n203 VDD.n200 0.9005
R905 VDD.n240 VDD.n239 0.9005
R906 VDD.n241 VDD.n240 0.9005
R907 VDD.n238 VDD.t250 0.9005
R908 VDD.n236 VDD.n235 0.9005
R909 VDD.n235 VDD.t137 0.9005
R910 VDD.n267 VDD.n266 0.9005
R911 VDD.n264 VDD.n263 0.9005
R912 VDD.n263 VDD.n262 0.9005
R913 VDD.n265 VDD.n34 0.9005
R914 VDD.n314 VDD.n169 0.9005
R915 VDD.n11 VDD.n483 0.9005
R916 VDD.n509 VDD.n508 0.9005
R917 VDD.n509 VDD.n153 0.9005
R918 VDD.n507 VDD.n21 0.9005
R919 VDD.n540 VDD.n493 0.9005
R920 VDD.n540 VDD.n80 0.9005
R921 VDD.n544 VDD.n543 0.9005
R922 VDD.n543 VDD.n158 0.9005
R923 VDD.n545 VDD.n538 0.9005
R924 VDD.n538 VDD.n537 0.9005
R925 VDD.n554 VDD.n553 0.9005
R926 VDD.n553 VDD.n552 0.9005
R927 VDD.n556 VDD.n555 0.9005
R928 VDD.n557 VDD.n556 0.9005
R929 VDD.n534 VDD.n533 0.9005
R930 VDD.n533 VDD.n522 0.9005
R931 VDD.n529 VDD.n528 0.9005
R932 VDD.n529 VDD.n75 0.9005
R933 VDD.n564 VDD.n563 0.9005
R934 VDD.n563 VDD.n562 0.9005
R935 VDD.n565 VDD.n513 0.9005
R936 VDD.n514 VDD.n513 0.9005
R937 VDD.n512 VDD.n511 0.9005
R938 VDD.n511 VDD.n56 0.9005
R939 VDD.n36 VDD.n138 0.9005
R940 VDD.t162 VDD.n36 0.9005
R941 VDD.n611 VDD.n45 0.418821
R942 VDD.n247 VDD.t142 0.871319
R943 VDD.t174 VDD.n299 0.857643
R944 VDD.n297 VDD.t114 0.857643
R945 VDD.n623 VDD.n591 0.856272
R946 VDD.n249 VDD.n51 0.834377
R947 VDD.n384 VDD.n383 0.811654
R948 VDD.n315 VDD.n168 0.804296
R949 VDD.n66 VDD.n65 0.574369
R950 VDD.n63 VDD.n62 0.574369
R951 VDD.n472 VDD.n464 0.775283
R952 VDD.n476 VDD.n464 0.775283
R953 VDD.n477 VDD.n476 0.775283
R954 VDD.n478 VDD.n477 0.775283
R955 VDD.n393 VDD.n379 0.775283
R956 VDD.n379 VDD.n357 0.775283
R957 VDD.n54 VDD.n368 0.570328
R958 VDD.n45 VDD.n606 1.2611
R959 VDD.n606 VDD.n40 1.26562
R960 VDD.n615 VDD.n40 0.413046
R961 VDD.n670 VDD.n665 0.775283
R962 VDD.n674 VDD.n665 0.775283
R963 VDD.n675 VDD.n674 0.775283
R964 VDD.n676 VDD.n675 0.775283
R965 VDD.n440 VDD.n413 0.775283
R966 VDD.n423 VDD.n413 0.775283
R967 VDD.n424 VDD.n423 0.775283
R968 VDD.n426 VDD.n424 0.775283
R969 VDD.n690 VDD.t185 0.762695
R970 VDD.n398 VDD.t36 0.79268
R971 VDD.n441 VDD.n440 0.760283
R972 VDD.n427 VDD.n426 0.760283
R973 VDD.n182 VDD.n177 0.741856
R974 VDD.n180 VDD.n34 0.733137
R975 VDD.n204 VDD.n242 0.727274
R976 VDD.n69 VDD.n68 0.582777
R977 VDD.n190 VDD.t28 1.28779
R978 VDD.n244 VDD.t28 1.30757
R979 VDD.n242 VDD.n241 0.71463
R980 VDD.n241 VDD.t28 0.71463
R981 VDD.n267 VDD.n34 1.12193
R982 VDD.n573 VDD.n153 0.71463
R983 VDD.n17 VDD.n153 0.71463
R984 VDD.n562 VDD.n63 1.15643
R985 VDD.n562 VDD.n561 0.71463
R986 VDD.n557 VDD.n66 1.15643
R987 VDD.n558 VDD.n557 0.71463
R988 VDD.n69 VDD.n158 0.847338
R989 VDD.n583 VDD.n158 0.71463
R990 VDD.n281 VDD.n12 0.703201
R991 VDD.t184 VDD.n223 0.7005
R992 VDD.n223 VDD.n217 0.7005
R993 VDD.n228 VDD.t135 0.7005
R994 VDD.n229 VDD.n228 0.7005
R995 VDD.n231 VDD.t15 0.7005
R996 VDD.n14 VDD.t135 0.7005
R997 VDD.t15 VDD.n14 0.7005
R998 VDD.t184 VDD.n233 0.7005
R999 VDD.n233 VDD.n44 0.54144
R1000 VDD.t101 VDD.n149 0.7005
R1001 VDD.n149 VDD.n148 0.7005
R1002 VDD.n145 VDD.t120 0.7005
R1003 VDD.n146 VDD.n145 0.7005
R1004 VDD.n60 VDD.t162 0.7005
R1005 VDD.n38 VDD.t120 0.7005
R1006 VDD.t162 VDD.n38 0.7005
R1007 VDD.n37 VDD.t101 0.7005
R1008 VDD.t162 VDD.n37 0.7005
R1009 VDD.n68 VDD.n67 0.699824
R1010 VDD.n65 VDD.n64 0.699824
R1011 VDD.n231 VDD.t242 0.693689
R1012 VDD.t118 VDD.n60 0.693689
R1013 VDD.n62 VDD.n61 0.687287
R1014 VDD.n643 VDD.n642 0.680292
R1015 VDD.t90 VDD.n25 0.679399
R1016 VDD.t137 VDD.n215 0.678601
R1017 VDD.n3 VDD.n5 0.673514
R1018 VDD.n25 VDD.n592 0.673514
R1019 VDD.n631 VDD.n630 0.673514
R1020 VDD.n646 VDD.n645 0.673514
R1021 VDD.n453 VDD.n452 0.673514
R1022 VDD.n452 VDD.n409 0.637173
R1023 VDD.n484 VDD.n121 0.63095
R1024 VDD.n269 VDD.n33 0.620942
R1025 VDD.n321 VDD.n305 0.617064
R1026 VDD.n73 VDD.n63 0.099155
R1027 VDD.n77 VDD.n66 0.099155
R1028 VDD.n291 VDD.n176 0.613151
R1029 VDD.n338 VDD.n311 0.613151
R1030 VDD.n276 VDD.n34 0.600306
R1031 VDD.n573 VDD.n21 0.600157
R1032 VDD.n574 VDD.n573 0.587593
R1033 VDD.n242 VDD.n205 0.583648
R1034 VDD.n253 VDD.n51 1.01522
R1035 VDD.n13 VDD.n11 0.578697
R1036 VDD.t15 VDD.n15 0.573227
R1037 VDD.n222 VDD.n221 0.573227
R1038 VDD.n221 VDD.n216 0.573227
R1039 VDD.n272 VDD.n271 0.573227
R1040 VDD.n272 VDD.n180 0.573227
R1041 VDD.n278 VDD.n277 0.573227
R1042 VDD.n277 VDD.n276 0.573227
R1043 VDD.n174 VDD.n167 0.573227
R1044 VDD.n292 VDD.n167 0.573227
R1045 VDD.n297 VDD.n172 0.573227
R1046 VDD.n293 VDD.n172 0.573227
R1047 VDD.n297 VDD.n296 0.573227
R1048 VDD.n296 VDD.n295 0.573227
R1049 VDD.n286 VDD.n282 0.573227
R1050 VDD.n282 VDD.n281 0.573227
R1051 VDD.n286 VDD.n285 0.573227
R1052 VDD.n285 VDD.n176 0.573227
R1053 VDD.n486 VDD.n485 0.573227
R1054 VDD.n485 VDD.n13 0.573227
R1055 VDD.n309 VDD.n299 0.573227
R1056 VDD.n339 VDD.n309 0.573227
R1057 VDD.n329 VDD.n299 0.573227
R1058 VDD.n329 VDD.n306 0.573227
R1059 VDD.n343 VDD.n342 0.573227
R1060 VDD.n344 VDD.n343 0.573227
R1061 VDD.n323 VDD.n322 0.573227
R1062 VDD.n322 VDD.n321 0.573227
R1063 VDD.n324 VDD.n323 0.573227
R1064 VDD.n324 VDD.n311 0.573227
R1065 VDD.n333 VDD.n332 0.573227
R1066 VDD.n332 VDD.n304 0.573227
R1067 VDD.n7 VDD.t256 0.573227
R1068 VDD.t36 VDD.n7 0.573227
R1069 VDD.n6 VDD.t148 0.573227
R1070 VDD.t36 VDD.n6 0.573227
R1071 VDD.t153 VDD.n374 0.573227
R1072 VDD.n374 VDD.n2 0.440396
R1073 VDD.n363 VDD.t146 0.573227
R1074 VDD.n363 VDD.n4 0.573227
R1075 VDD.n375 VDD.t153 0.573227
R1076 VDD.n375 VDD.n361 0.573227
R1077 VDD.n377 VDD.t146 0.573227
R1078 VDD.n378 VDD.n377 0.573227
R1079 VDD.t148 VDD.n4 0.573227
R1080 VDD.n381 VDD.t244 0.573227
R1081 VDD.n382 VDD.n381 0.573227
R1082 VDD.n351 VDD.t95 0.573227
R1083 VDD.n384 VDD.n351 0.573227
R1084 VDD.n389 VDD.t244 0.573227
R1085 VDD.n390 VDD.n389 0.573227
R1086 VDD.n387 VDD.t95 0.573227
R1087 VDD.n387 VDD.n385 0.573227
R1088 VDD.t256 VDD.n394 0.573227
R1089 VDD.t34 VDD.n620 0.573227
R1090 VDD.n620 VDD.n619 0.573227
R1091 VDD.n23 VDD.t251 0.573227
R1092 VDD.t90 VDD.n23 0.573227
R1093 VDD.n24 VDD.t180 0.573227
R1094 VDD.t34 VDD.n595 0.573227
R1095 VDD.n603 VDD.n595 0.573227
R1096 VDD.t251 VDD.n617 0.573227
R1097 VDD.n617 VDD.n616 0.573227
R1098 VDD.n26 VDD.t180 0.573227
R1099 VDD.t90 VDD.n26 0.573227
R1100 VDD.n581 VDD.n580 0.573227
R1101 VDD.n579 VDD.n491 0.573227
R1102 VDD.n491 VDD.n159 0.573227
R1103 VDD.n546 VDD.n539 0.573227
R1104 VDD.n539 VDD.n157 0.573227
R1105 VDD.n548 VDD.n547 0.573227
R1106 VDD.n548 VDD.n496 0.573227
R1107 VDD.n523 VDD.n521 0.573227
R1108 VDD.n523 VDD.n518 0.573227
R1109 VDD.n526 VDD.n525 0.573227
R1110 VDD.n525 VDD.n497 0.573227
R1111 VDD.n567 VDD.n566 0.573227
R1112 VDD.n567 VDD.n515 0.573227
R1113 VDD.n570 VDD.n569 0.573227
R1114 VDD.n569 VDD.n55 0.573227
R1115 VDD.n128 VDD.n124 0.573227
R1116 VDD.n128 VDD.t162 0.573227
R1117 VDD.n137 VDD.n136 0.573227
R1118 VDD.n136 VDD.n126 0.573227
R1119 VDD.t122 VDD.n634 0.573227
R1120 VDD.n634 VDD.n633 0.573227
R1121 VDD.n115 VDD.t241 0.573227
R1122 VDD.n115 VDD.n39 0.573227
R1123 VDD.n640 VDD.t159 0.573227
R1124 VDD.n641 VDD.n640 0.573227
R1125 VDD.n635 VDD.t122 0.573227
R1126 VDD.n635 VDD.n118 0.573227
R1127 VDD.n637 VDD.t241 0.573227
R1128 VDD.n637 VDD.n111 0.573227
R1129 VDD.t159 VDD.n639 0.573227
R1130 VDD.n639 VDD.t160 0.573227
R1131 VDD.t131 VDD.n648 0.573227
R1132 VDD.n648 VDD.n647 0.573227
R1133 VDD.t183 VDD.n660 0.573227
R1134 VDD.n660 VDD.n659 0.573227
R1135 VDD.n657 VDD.t187 0.573227
R1136 VDD.n658 VDD.n657 0.573227
R1137 VDD.t131 VDD.n108 0.573227
R1138 VDD.n108 VDD.n100 0.573227
R1139 VDD.n661 VDD.t183 0.573227
R1140 VDD.n662 VDD.n661 0.573227
R1141 VDD.n654 VDD.t187 0.573227
R1142 VDD.t188 VDD.n654 0.573227
R1143 VDD.n444 VDD.t262 0.573227
R1144 VDD.n444 VDD.n443 0.573227
R1145 VDD.n446 VDD.t33 0.573227
R1146 VDD.n446 VDD.n408 0.573227
R1147 VDD.t78 VDD.n419 0.573227
R1148 VDD.n419 VDD.n418 0.573227
R1149 VDD.n415 VDD.t262 0.573227
R1150 VDD.n415 VDD.n407 0.573227
R1151 VDD.n406 VDD.t33 0.573227
R1152 VDD.n454 VDD.n406 0.573227
R1153 VDD.t78 VDD.n438 0.573227
R1154 VDD.n438 VDD.n437 0.573227
R1155 VDD.n51 VDD.n50 0.573227
R1156 VDD.n70 VDD.n51 0.573227
R1157 VDD.n289 VDD.n162 0.570265
R1158 VDD.t193 VDD.n70 0.569391
R1159 VDD.n49 VDD.t57 0.569391
R1160 VDD.n337 VDD.n336 0.568352
R1161 VDD.n290 VDD.n289 0.568352
R1162 VDD.n394 VDD.n53 0.59234
R1163 VDD.n576 VDD.n575 0.562639
R1164 VDD.n11 VDD.n168 0.55728
R1165 VDD.n61 VDD.n574 0.555971
R1166 VDD.n587 VDD.n151 0.55085
R1167 VDD.n630 VDD.t162 0.550184
R1168 VDD.n645 VDD.n644 0.550184
R1169 VDD.n383 VDD.n382 0.546269
R1170 VDD.t36 VDD.t253 0.544514
R1171 VDD.n317 VDD.t170 0.533882
R1172 VDD.t36 VDD.t255 0.533882
R1173 VDD.n133 VDD.t125 0.533882
R1174 VDD.t162 VDD.t164 0.533882
R1175 VDD.n458 VDD.t81 0.533882
R1176 VDD.t90 VDD.t179 0.533882
R1177 VDD.n269 VDD.t21 0.533882
R1178 VDD.n10 VDD.t113 0.533882
R1179 VDD.n34 VDD.t18 0.533882
R1180 VDD.n34 VDD.t1 0.533882
R1181 VDD.n688 VDD.t43 0.533882
R1182 VDD.n572 VDD.n498 0.5255
R1183 VDD.n530 VDD.n524 0.5255
R1184 VDD.n551 VDD.n536 0.5255
R1185 VDD.n577 VDD.n495 0.5255
R1186 VDD.n268 VDD.n34 0.517198
R1187 VDD.n335 VDD.n317 0.501097
R1188 VDD.n290 VDD.n288 0.491732
R1189 VDD.n337 VDD.n312 0.491732
R1190 VDD.n399 VDD.n352 0.488095
R1191 VDD.n680 VDD.n679 0.482643
R1192 VDD.n587 VDD.n18 0.482643
R1193 VDD.n682 VDD.n681 0.475656
R1194 VDD.n291 VDD.n290 0.475263
R1195 VDD.n338 VDD.n337 0.475263
R1196 VDD.n20 VDD.n18 0.0151407
R1197 VDD.n182 VDD.n180 0.454314
R1198 VDD.n442 VDD.n411 0.447239
R1199 VDD.n643 VDD.t160 0.445542
R1200 VDD.n140 VDD.n139 0.443577
R1201 VDD.n591 VDD.n590 0.437448
R1202 VDD.n690 VDD 0.436211
R1203 VDD.n41 VDD.n229 0.614759
R1204 VDD.n229 VDD.n225 0.431088
R1205 VDD.n225 VDD.n217 0.431088
R1206 VDD.n146 VDD.n52 0.61868
R1207 VDD.n147 VDD.n146 0.431088
R1208 VDD.n148 VDD.n147 0.431088
R1209 VDD.t36 VDD.t158 0.430119
R1210 VDD.t36 VDD.t155 0.430119
R1211 VDD.n435 VDD.t84 0.430119
R1212 VDD.n433 VDD.t86 0.430119
R1213 VDD.n428 VDD.t88 0.430119
R1214 VDD.t90 VDD.t94 0.430119
R1215 VDD.t90 VDD.t92 0.430119
R1216 VDD.n462 VDD.t66 0.430119
R1217 VDD.n468 VDD.t62 0.430119
R1218 VDD.n471 VDD.t64 0.430119
R1219 VDD.n126 VDD.t162 0.424576
R1220 VDD.n234 VDD.n217 0.410794
R1221 VDD.n148 VDD.n141 0.410794
R1222 VDD.n234 VDD.t15 0.406984
R1223 VDD.n681 VDD.n91 0.4005
R1224 VDD.n588 VDD.n587 0.396725
R1225 VDD.n692 VDD.n691 0.3755
R1226 VDD.n150 VDD.t162 0.3755
R1227 VDD.n693 VDD.n692 0.3755
R1228 VDD.n20 VDD.n19 0.2255
R1229 VDD.n21 VDD.n20 0.0769929
R1230 VDD.n347 VDD.n346 0.363916
R1231 VDD.n98 VDD.n92 0.36337
R1232 VDD.n458 VDD.t77 0.36012
R1233 VDD.n86 VDD 0.385625
R1234 VDD.n251 VDD.n250 0.347096
R1235 VDD.n664 VDD.n663 0.343143
R1236 VDD.n53 VDD.n352 0.381375
R1237 VDD.n401 VDD.t36 0.338
R1238 VDD.t17 VDD.n84 0.332683
R1239 VDD.t41 VDD.n83 0.332601
R1240 VDD.n30 VDD.t0 0.332558
R1241 VDD.t245 VDD.n201 0.332079
R1242 VDD.n201 VDD.n197 0.332079
R1243 VDD.t245 VDD.n243 0.332079
R1244 VDD.n243 VDD.t28 0.332079
R1245 VDD.t139 VDD.n210 0.332079
R1246 VDD.n214 VDD.n211 0.332079
R1247 VDD.n34 VDD.n32 0.332079
R1248 VDD.n34 VDD.n31 0.332079
R1249 VDD.t53 VDD.n270 0.332079
R1250 VDD.t53 VDD.n178 0.332079
R1251 VDD.n183 VDD.n178 0.332079
R1252 VDD.n175 VDD.n174 0.332079
R1253 VDD.n294 VDD.n175 0.332079
R1254 VDD.n486 VDD.n165 0.332079
R1255 VDD.n10 VDD.n165 0.332079
R1256 VDD.n342 VDD.n341 0.332079
R1257 VDD.n341 VDD.n340 0.332079
R1258 VDD.n333 VDD.n328 0.332079
R1259 VDD.n328 VDD.n317 0.332079
R1260 VDD.n8 VDD.t254 0.332079
R1261 VDD.t36 VDD.n8 0.332079
R1262 VDD.n369 VDD.t36 0.332079
R1263 VDD.n370 VDD.t150 0.332079
R1264 VDD.n370 VDD.t36 0.332079
R1265 VDD.n5 VDD.n373 0.332079
R1266 VDD.n22 VDD.t150 0.332079
R1267 VDD.n4 VDD.n2 0.0498883
R1268 VDD.n395 VDD.t36 0.332079
R1269 VDD.n398 VDD.n397 0.332079
R1270 VDD.t254 VDD.n400 0.332079
R1271 VDD.n400 VDD.n399 0.332079
R1272 VDD.n597 VDD.t178 0.332079
R1273 VDD.n618 VDD.n597 0.332079
R1274 VDD.n593 VDD.t90 0.332079
R1275 VDD.n609 VDD.t178 0.332079
R1276 VDD.n609 VDD.t90 0.332079
R1277 VDD.n25 VDD.n622 0.332079
R1278 VDD.n133 VDD.n132 0.332079
R1279 VDD.n630 VDD.n629 0.332079
R1280 VDD.n120 VDD.t161 0.332079
R1281 VDD.n632 VDD.n120 0.332079
R1282 VDD.n626 VDD.t161 0.332079
R1283 VDD.n626 VDD.t162 0.332079
R1284 VDD.t162 VDD.n35 0.332079
R1285 VDD.n645 VDD.n107 0.332079
R1286 VDD.n110 VDD.t189 0.332079
R1287 VDD.n110 VDD.n105 0.332079
R1288 VDD.n652 VDD.t189 0.332079
R1289 VDD.n652 VDD.t190 0.332079
R1290 VDD.n650 VDD.t192 0.332079
R1291 VDD.t80 VDD.n456 0.332079
R1292 VDD.n456 VDD.n455 0.332079
R1293 VDD.n452 VDD.n451 0.332079
R1294 VDD.n449 VDD.t77 0.332079
R1295 VDD.n457 VDD.t80 0.332079
R1296 VDD.n458 VDD.n457 0.332079
R1297 VDD.n84 VDD.n269 0.332079
R1298 VDD.n42 VDD.t186 0.219676
R1299 VDD.n83 VDD.t42 0.332079
R1300 VDD.n688 VDD.n687 0.332079
R1301 VDD.n31 VDD.t17 0.331788
R1302 VDD.n687 VDD.t41 0.331623
R1303 VDD.t0 VDD.n32 0.331538
R1304 VDD.t248 VDD.t28 0.213198
R1305 VDD.n16 VDD.n216 0.323326
R1306 VDD.n295 VDD.n291 0.318474
R1307 VDD.n339 VDD.n338 0.318474
R1308 VDD.n276 VDD.n177 0.317656
R1309 VDD.t28 VDD.t97 0.313496
R1310 VDD.n335 VDD.n315 0.312292
R1311 VDD.n489 VDD.n160 0.308612
R1312 VDD.t15 VDD.n16 0.299784
R1313 VDD.t192 VDD.t190 0.296359
R1314 VDD.n252 VDD.n249 0.288087
R1315 VDD.n252 VDD.n251 0.288087
R1316 VDD.n305 VDD.n303 0.279121
R1317 VDD.n10 VDD.n162 0.277634
R1318 VDD.n251 VDD.t23 0.267191
R1319 VDD.n249 VDD.t26 0.267191
R1320 VDD.n335 VDD.t171 0.267191
R1321 VDD.n312 VDD.t177 0.267191
R1322 VDD.n29 VDD.t110 0.267191
R1323 VDD.n288 VDD.t117 0.267191
R1324 VDD.n425 VDD.t87 0.263787
R1325 VDD.t83 VDD.n89 0.263787
R1326 VDD.n669 VDD.t2 0.263787
R1327 VDD.n611 VDD.t89 0.263787
R1328 VDD.n615 VDD.t93 0.263787
R1329 VDD.n368 VDD.t157 0.263787
R1330 VDD.t36 VDD.t154 0.264108
R1331 VDD.n470 VDD.t63 0.263787
R1332 VDD.n473 VDD.t63 0.263075
R1333 VDD.t38 VDD.n9 0.387285
R1334 VDD.t154 VDD.n87 0.263075
R1335 VDD.n671 VDD.t2 0.263075
R1336 VDD.n439 VDD.t83 0.263075
R1337 VDD.n429 VDD.t87 0.263075
R1338 VDD.n28 VDD.t93 0.263075
R1339 VDD.t89 VDD.n88 0.263075
R1340 VDD.n471 VDD.n470 0.263
R1341 VDD.n467 VDD.t61 0.263
R1342 VDD.n468 VDD.n467 0.263
R1343 VDD.t65 VDD.n300 0.263
R1344 VDD.n462 VDD.n300 0.263
R1345 VDD.n473 VDD.n472 0.263
R1346 VDD.n475 VDD.t61 0.263
R1347 VDD.n476 VDD.n475 0.263
R1348 VDD.t65 VDD.n479 0.263
R1349 VDD.n479 VDD.n478 0.263
R1350 VDD.t156 VDD.n367 0.263
R1351 VDD.n367 VDD.n357 0.263
R1352 VDD.n87 VDD.n393 0.263
R1353 VDD.t91 VDD.n612 0.263
R1354 VDD.n612 VDD.t90 0.263
R1355 VDD.n613 VDD.t91 0.263
R1356 VDD.n613 VDD.n606 0.263
R1357 VDD.t3 VDD.n669 0.263
R1358 VDD.n667 VDD.t4 0.263
R1359 VDD.t5 VDD.n667 0.263
R1360 VDD.n678 VDD.t6 0.263
R1361 VDD.t7 VDD.n678 0.263
R1362 VDD.t6 VDD.n677 0.263
R1363 VDD.n677 VDD.n676 0.263
R1364 VDD.n673 VDD.t4 0.263
R1365 VDD.n674 VDD.n673 0.263
R1366 VDD.n671 VDD.n670 0.263
R1367 VDD.n426 VDD.n425 0.263
R1368 VDD.n422 VDD.t85 0.263
R1369 VDD.n423 VDD.n422 0.263
R1370 VDD.n440 VDD.n439 0.263
R1371 VDD.n429 VDD.n428 0.263
R1372 VDD.n432 VDD.t85 0.263
R1373 VDD.n433 VDD.n432 0.263
R1374 VDD.n435 VDD.n89 0.263
R1375 VDD.t90 VDD.n28 0.263
R1376 VDD.n88 VDD.t90 0.263
R1377 VDD.t28 VDD.n43 1.73373
R1378 VDD.n258 VDD.n34 1.81381
R1379 VDD.n246 VDD.n91 0.2565
R1380 VDD.t103 VDD.t36 16.1727
R1381 VDD.n436 VDD.n435 0.252744
R1382 VDD.t139 VDD.n209 0.246298
R1383 VDD.n314 VDD.n313 0.245938
R1384 VDD.n623 VDD.t90 0.245535
R1385 VDD.n247 VDD.n246 0.24126
R1386 VDD.n139 VDD.t162 0.235524
R1387 VDD.n294 VDD.n293 0.232097
R1388 VDD.n340 VDD.n306 0.232097
R1389 VDD.n618 VDD.t90 0.232097
R1390 VDD.n632 VDD.n39 0.232097
R1391 VDD.n659 VDD.n105 0.232097
R1392 VDD.n455 VDD.n407 0.232097
R1393 VDD.t28 VDD.t139 0.231955
R1394 VDD.t127 VDD.t129 0.228
R1395 VDD.t19 VDD.t20 0.228
R1396 VDD.n428 VDD.n420 0.214272
R1397 VDD.n433 VDD.n420 0.214272
R1398 VDD.n434 VDD.n433 0.214272
R1399 VDD.n435 VDD.n434 0.214272
R1400 VDD.n383 VDD.n352 0.213788
R1401 VDD.n34 VDD.n51 6.7999
R1402 VDD.n428 VDD.n427 0.20891
R1403 VDD.n345 VDD.n305 0.194848
R1404 VDD.n160 VDD.n121 0.1907
R1405 VDD.n663 VDD.n99 0.188652
R1406 VDD.n269 VDD.n268 0.184047
R1407 VDD.n691 VDD.n682 0.179795
R1408 VDD.n692 VDD.n85 0.179795
R1409 VDD.n262 VDD.n34 0.274501
R1410 VDD.n288 VDD.n287 0.1755
R1411 VDD.n487 VDD.n486 0.1755
R1412 VDD.n29 VDD.n487 0.1755
R1413 VDD.n334 VDD.n333 0.1755
R1414 VDD.n335 VDD.n334 0.1755
R1415 VDD.n319 VDD.n312 0.1755
R1416 VDD.n409 VDD.t77 0.174947
R1417 VDD.n576 VDD.n69 0.582883
R1418 VDD.n347 VDD.n304 0.164663
R1419 VDD.t188 VDD.n92 0.164663
R1420 VDD.t39 VDD.t36 0.541955
R1421 VDD.n489 VDD.n488 0.160911
R1422 VDD.n436 VDD.n412 0.160897
R1423 VDD.n29 VDD.n162 0.157539
R1424 VDD.n59 VDD.n56 0.151764
R1425 VDD.n560 VDD.n75 0.151764
R1426 VDD.n552 VDD.n156 0.151764
R1427 VDD.n582 VDD.n80 0.151764
R1428 VDD.n437 VDD.n436 0.150857
R1429 VDD.n459 VDD.n402 0.149744
R1430 VDD.n13 VDD.n10 0.148429
R1431 VDD.n317 VDD.n316 0.148429
R1432 VDD.n655 VDD.t190 0.148429
R1433 VDD.n589 VDD.n588 0.147239
R1434 VDD.n644 VDD.t192 0.144213
R1435 VDD.n298 VDD.n171 0.143357
R1436 VDD.n471 VDD.n469 0.140482
R1437 VDD.n469 VDD.n468 0.140482
R1438 VDD.n468 VDD.n463 0.140482
R1439 VDD.n463 VDD.n462 0.140482
R1440 VDD.t3 VDD.n668 0.140482
R1441 VDD.n668 VDD.t5 0.140482
R1442 VDD.t5 VDD.n93 0.140482
R1443 VDD.t7 VDD.n93 0.140482
R1444 VDD.n293 VDD.n292 0.140212
R1445 VDD.n344 VDD.n306 0.140212
R1446 VDD.t90 VDD.n24 0.585484
R1447 VDD.n641 VDD.n39 0.140212
R1448 VDD.n659 VDD.n658 0.140212
R1449 VDD.n418 VDD.n407 0.140212
R1450 VDD.n619 VDD.n592 0.139034
R1451 VDD.n633 VDD.n631 0.139034
R1452 VDD.n647 VDD.n646 0.139034
R1453 VDD.n454 VDD.n453 0.139034
R1454 VDD.n59 VDD.n55 0.132104
R1455 VDD.n560 VDD.n497 0.132104
R1456 VDD.n496 VDD.n156 0.132104
R1457 VDD.n582 VDD.n159 0.132104
R1458 VDD.n560 VDD.n559 0.131639
R1459 VDD.t162 VDD.t166 1.14115
R1460 VDD.n59 VDD.n57 0.126738
R1461 VDD.n582 VDD.n581 0.122917
R1462 VDD.n141 VDD.t162 0.459857
R1463 VDD.t137 VDD.n209 0.119279
R1464 VDD.t152 VDD.t36 0.626161
R1465 VDD.n13 VDD.n12 0.117553
R1466 VDD.n40 VDD.t90 0.542037
R1467 VDD.n441 VDD.n412 0.114762
R1468 VDD.t24 VDD.t25 0.11425
R1469 VDD.t173 VDD.t175 0.11425
R1470 VDD.t112 VDD.t115 0.11425
R1471 VDD.n437 VDD.n402 0.112385
R1472 VDD.t97 VDD.n204 0.110648
R1473 VDD.n346 VDD.n345 0.10508
R1474 VDD.n99 VDD.n98 0.104219
R1475 VDD.n585 VDD.n584 0.0933116
R1476 VDD.n16 VDD.n209 0.0918025
R1477 VDD.n316 VDD.n304 0.0917363
R1478 VDD.n655 VDD.t188 0.0917363
R1479 VDD.n574 VDD.n71 0.118861
R1480 VDD.n292 VDD.n12 0.0895825
R1481 VDD.n581 VDD.n490 0.0852851
R1482 VDD.n583 VDD.n582 0.0851813
R1483 VDD.n558 VDD.n156 0.0851813
R1484 VDD.n561 VDD.n560 0.0851813
R1485 VDD.n17 VDD.n59 0.0851813
R1486 VDD.n644 VDD.n643 0.0846481
R1487 VDD.n346 VDD.n303 0.0820513
R1488 VDD.n515 VDD.n57 0.0814598
R1489 VDD.n559 VDD.n518 0.0814598
R1490 VDD.n584 VDD.n157 0.0814598
R1491 VDD.n589 VDD.n18 0.0809813
R1492 VDD.n679 VDD.t7 0.0777566
R1493 VDD.n279 VDD.n172 0.0777059
R1494 VDD.n330 VDD.n329 0.0777059
R1495 VDD.n363 VDD.n362 0.0777059
R1496 VDD.n381 VDD.n380 0.0777059
R1497 VDD.n23 VDD.n599 0.0777059
R1498 VDD.n115 VDD.n114 0.0777059
R1499 VDD.n660 VDD.n104 0.0777059
R1500 VDD.n416 VDD.n415 0.0777059
R1501 VDD.n462 VDD.n461 0.0776429
R1502 VDD.n664 VDD.n98 0.0775684
R1503 VDD.n412 VDD.n411 0.0756447
R1504 VDD VDD.n693 0.0717322
R1505 VDD.t28 VDD.n1 0.913198
R1506 VDD.n693 VDD.n90 0.0685332
R1507 VDD.n584 VDD.n583 0.0604652
R1508 VDD.n559 VDD.n558 0.0604652
R1509 VDD.n561 VDD.n57 0.0604652
R1510 VDD.n490 VDD.n489 0.0604308
R1511 VDD.t36 VDD.n5 0.634979
R1512 VDD.n642 VDD.n641 0.0533076
R1513 VDD.n515 VDD.n514 0.0508571
R1514 VDD.n522 VDD.n518 0.0508571
R1515 VDD.n537 VDD.n157 0.0508571
R1516 VDD.n295 VDD.n294 0.0459712
R1517 VDD.n340 VDD.n339 0.0459712
R1518 VDD.n619 VDD.n618 0.0459712
R1519 VDD.n633 VDD.n632 0.0459712
R1520 VDD.n647 VDD.n105 0.0459712
R1521 VDD.n455 VDD.n454 0.0459712
R1522 VDD.n682 VDD.n85 0.0427902
R1523 VDD.n86 VDD.n85 0.0420058
R1524 VDD.n90 VDD 0.0419457
R1525 VDD.n586 VDD.n155 0.0408737
R1526 VDD.n586 VDD.n585 0.0399737
R1527 VDD.n161 VDD.n155 0.0399737
R1528 VDD.n585 VDD.n156 0.0388277
R1529 VDD.n590 VDD.n589 0.0377192
R1530 VDD.n461 VDD.n347 0.0369096
R1531 VDD.n679 VDD.n92 0.0367958
R1532 VDD.n72 VDD.n71 0.001068
R1533 VDD.n76 VDD.n74 0.001068
R1534 VDD.n79 VDD.n78 0.001068
R1535 VDD.n82 VDD.n81 0.001068
R1536 VDD.t22 VDD.n252 0.0339565
R1537 VDD.n86 VDD.n90 0.0332728
R1538 VDD.n58 VDD.n154 0.03175
R1539 VDD.n154 VDD.n151 0.03175
R1540 VDD.n72 VDD.n56 0.031474
R1541 VDD.n76 VDD.n75 0.031474
R1542 VDD.n552 VDD.n79 0.031474
R1543 VDD.n81 VDD.n80 0.031474
R1544 VDD.n459 VDD.n458 0.031066
R1545 VDD.t250 VDD.n205 0.03043
R1546 VDD.n427 VDD.n160 0.0284626
R1547 VDD.n194 VDD.t27 0.0282073
R1548 VDD.n82 VDD.n576 0.256139
R1549 VDD.n78 VDD.n77 3.71136
R1550 VDD.n74 VDD.n73 3.71136
R1551 VDD.n143 VDD.t118 0.697845
R1552 VDD.n230 VDD.t242 0.697845
R1553 VDD.n50 VDD.t57 0.572059
R1554 VDD.n253 VDD.t193 0.572059
R1555 VDD.n537 VDD.n68 0.137442
R1556 VDD.n522 VDD.n65 0.137442
R1557 VDD.n514 VDD.n62 0.137442
R1558 VDD.n59 VDD.n58 0.0366515
R1559 VDD.n345 VDD.n344 0.0264162
R1560 VDD.n658 VDD.n99 0.0264162
R1561 VDD.n418 VDD.n411 0.0264162
R1562 VDD.t105 VDD.n21 2.23947
R1563 VDD.t35 VDD.n9 0.847239
R1564 VDD.t90 VDD.n27 1.15081
R1565 VDD.n4 VDD.n3 1.12759
R1566 VDD.t15 VDD.n44 1.11393
R1567 VDD.n270 VDD.n34 1.08116
R1568 VDD.n313 VDD.n13 1.07471
R1569 VDD.n34 VDD.n29 1.06606
R1570 VDD.t250 VDD.t28 1.06378
R1571 VDD.t157 VDD.t36 1.04285
R1572 VDD.n250 VDD.n51 1.04088
R1573 VDD.t28 VDD.n46 1.01649
R1574 VDD.t162 VDD.t160 1.00698
R1575 VDD.n21 VDD.n17 1.00187
R1576 VSS.n764 VSS.n306 1.57617e+07
R1577 VSS.n980 VSS.n979 2.58375e+06
R1578 VSS.n980 VSS.n365 2.5805e+06
R1579 VSS.n808 VSS.n807 1.20592e+06
R1580 VSS.n765 VSS.n764 1.02561e+06
R1581 VSS.n1016 VSS.n461 680875
R1582 VSS.n461 VSS.n365 680875
R1583 VSS.t127 VSS.n887 405320
R1584 VSS.n811 VSS.n810 342428
R1585 VSS.n890 VSS.n702 341984
R1586 VSS.n929 VSS.n667 316377
R1587 VSS.n809 VSS.n777 313267
R1588 VSS.t253 VSS.n928 268568
R1589 VSS.n808 VSS.n794 134878
R1590 VSS.n1245 VSS.n141 79338.4
R1591 VSS.n1050 VSS.n1049 78383.3
R1592 VSS.n919 VSS.n364 78363.6
R1593 VSS.n1200 VSS.n1199 72894.2
R1594 VSS.n847 VSS.n724 62729
R1595 VSS.n807 VSS.n723 58754.9
R1596 VSS.n1050 VSS.n365 55932.5
R1597 VSS.n209 VSS.t4 51670.5
R1598 VSS.n1037 VSS.n366 49500.2
R1599 VSS.n1231 VSS.n1230 49500
R1600 VSS.n1200 VSS.n197 48061.8
R1601 VSS.n847 VSS.n765 45499
R1602 VSS.n1201 VSS.n195 40251
R1603 VSS.n1198 VSS.n200 38069.6
R1604 VSS.n420 VSS.n419 38069.6
R1605 VSS.n928 VSS.n668 33615.8
R1606 VSS.n1200 VSS.n196 29135.3
R1607 VSS.n864 VSS.t185 27290.4
R1608 VSS.n1231 VSS.n168 26229.1
R1609 VSS.n895 VSS.n667 26071
R1610 VSS.n1049 VSS.n366 25791.7
R1611 VSS.n1201 VSS.n1200 25732.2
R1612 VSS.n1199 VSS.n198 25732.2
R1613 VSS.n809 VSS.n808 25721.2
R1614 VSS.n889 VSS.t212 23043.6
R1615 VSS.n1078 VSS.t214 22696.4
R1616 VSS.n1078 VSS.t233 22459.6
R1617 VSS.n847 VSS.n306 21656.8
R1618 VSS.n1199 VSS.n199 21399.3
R1619 VSS.n888 VSS.n705 20533.3
R1620 VSS.n419 VSS.n196 19984.3
R1621 VSS.n889 VSS.n307 18741.6
R1622 VSS.n1146 VSS.n200 18086.3
R1623 VSS.n420 VSS.n386 18086.3
R1624 VSS.t213 VSS.n890 18070.7
R1625 VSS.n807 VSS.n806 16988.7
R1626 VSS.n224 VSS.n198 16668.5
R1627 VSS.t185 VSS.n863 16130.5
R1628 VSS.n1201 VSS.t4 15564.4
R1629 VSS.n382 VSS.n198 15564.4
R1630 VSS.n1023 VSS.n198 12971.6
R1631 VSS.n210 VSS.n209 12635.8
R1632 VSS.n422 VSS.n421 12635.8
R1633 VSS.t244 VSS.n839 12315
R1634 VSS.n876 VSS.n875 11707.8
R1635 VSS.n1171 VSS.t4 11317.6
R1636 VSS.n421 VSS.t221 10711.6
R1637 VSS.t244 VSS.n717 10530.6
R1638 VSS.t136 VSS.n400 10385.9
R1639 VSS.t38 VSS.n771 10060.7
R1640 VSS.t238 VSS.t105 9941.18
R1641 VSS.n921 VSS.n920 9275.87
R1642 VSS.n810 VSS.n765 8595.52
R1643 VSS.n1049 VSS.n197 8492.42
R1644 VSS.n448 VSS.n447 8324.65
R1645 VSS.n1213 VSS.n169 8237.87
R1646 VSS.t221 VSS.n382 7924.66
R1647 VSS.n890 VSS.n889 7846.17
R1648 VSS.n864 VSS.n706 7774.51
R1649 VSS.n1170 VSS.n198 7603.85
R1650 VSS.n887 VSS.n706 6858.46
R1651 VSS.n400 VSS.n399 6500
R1652 VSS.t236 VSS.n384 6264.02
R1653 VSS.n1103 VSS.t66 6024.9
R1654 VSS.t251 VSS.n367 5902.57
R1655 VSS.n1076 VSS.t212 5781.68
R1656 VSS.n1050 VSS.t130 5735.98
R1657 VSS.n1077 VSS.n168 5570.54
R1658 VSS.t69 VSS.n191 5561.46
R1659 VSS.n532 VSS.n244 5414.59
R1660 VSS.n521 VSS.n520 5410.44
R1661 VSS.n191 VSS.n169 5303.2
R1662 VSS.n809 VSS.n793 5217.75
R1663 VSS.n1172 VSS.n223 5116.4
R1664 VSS.t38 VSS.n835 5018.38
R1665 VSS.n1076 VSS.n307 4996.06
R1666 VSS.n399 VSS.n197 4845.56
R1667 VSS.n602 VSS.n601 4703.69
R1668 VSS.n401 VSS.t136 4699.24
R1669 VSS.n596 VSS.n595 4685.11
R1670 VSS.n965 VSS.n964 4683.35
R1671 VSS.n443 VSS.t4 4587.37
R1672 VSS.t253 VSS.n50 4379.16
R1673 VSS.n930 VSS.n929 4335.14
R1674 VSS.n888 VSS.n673 4319.38
R1675 VSS.n1245 VSS.t171 4238.03
R1676 VSS.n863 VSS.n717 4237.75
R1677 VSS.n839 VSS.n771 4237.75
R1678 VSS.n835 VSS.n777 4237.75
R1679 VSS.n364 VSS.t16 4236.22
R1680 VSS.n1244 VSS.n142 4152.78
R1681 VSS.n263 VSS.n142 4152.78
R1682 VSS.n1243 VSS.n143 4152.78
R1683 VSS.n263 VSS.n143 4152.78
R1684 VSS.n1197 VSS.t4 4152.78
R1685 VSS.n1198 VSS.n1197 4152.78
R1686 VSS.n419 VSS.n374 4152.78
R1687 VSS.n1043 VSS.n374 4152.78
R1688 VSS.n520 VSS.n234 4152.78
R1689 VSS.n965 VSS.n234 4152.78
R1690 VSS.n593 VSS.n532 4152.78
R1691 VSS.n596 VSS.n593 4152.78
R1692 VSS.n389 VSS.n196 4152.78
R1693 VSS.n389 VSS.n367 4152.78
R1694 VSS.n364 VSS.n335 4152.78
R1695 VSS.n345 VSS.n335 4152.78
R1696 VSS.n364 VSS.n334 4152.78
R1697 VSS.n345 VSS.n334 4152.78
R1698 VSS.n1079 VSS.n1078 4131.78
R1699 VSS.n1049 VSS.t251 3698.07
R1700 VSS.t124 VSS.n1218 3540.24
R1701 VSS.t252 VSS.n1043 3488.97
R1702 VSS.n1052 VSS.n1051 3360.25
R1703 VSS.n920 VSS.n673 3323.56
R1704 VSS.n199 VSS.t4 3250.3
R1705 VSS.t233 VSS.t232 3044.03
R1706 VSS.t238 VSS.n382 2789.98
R1707 VSS.n1018 VSS.n1017 2780.6
R1708 VSS.n919 VSS.n918 2762.28
R1709 VSS.n920 VSS.n919 2746.33
R1710 VSS.n1052 VSS.n364 2664.63
R1711 VSS.t214 VSS.n1076 2664.63
R1712 VSS.t96 VSS.n527 2515.9
R1713 VSS.n1077 VSS.n141 2434.5
R1714 VSS.n959 VSS.n957 2405.99
R1715 VSS.n565 VSS.t242 2403.25
R1716 VSS.n1042 VSS.t105 2383.73
R1717 VSS.n964 VSS.n521 2366.56
R1718 VSS.n595 VSS.n244 2366.56
R1719 VSS.n959 VSS.n526 2351.84
R1720 VSS.n599 VSS.t242 2351.84
R1721 VSS.n1018 VSS.n384 2275.36
R1722 VSS.n961 VSS.n521 2179.12
R1723 VSS.n1150 VSS.n244 2174.97
R1724 VSS.n888 VSS.n136 2160.12
R1725 VSS.n1230 VSS.n169 2000
R1726 VSS.n455 VSS.n384 1926.7
R1727 VSS.n960 VSS.n525 1901.02
R1728 VSS.n565 VSS.n564 1841.76
R1729 VSS.n1076 VSS.n1075 1839.31
R1730 VSS.n1199 VSS.n1198 1835.29
R1731 VSS.n961 VSS.n960 1755.75
R1732 VSS.n1151 VSS.n1150 1755.75
R1733 VSS.n876 VSS.n306 1735.91
R1734 VSS.n1214 VSS.n177 1597.17
R1735 VSS.n1202 VSS.n1201 1433.78
R1736 VSS.n559 VSS.t164 1395.21
R1737 VSS.n1064 VSS.t232 1293.71
R1738 VSS.t143 VSS.n384 1264.88
R1739 VSS.n1151 VSS.t242 1244.1
R1740 VSS.n960 VSS.n959 1241.36
R1741 VSS.n191 VSS.n141 1233.49
R1742 VSS.t33 VSS.n42 0.11863
R1743 VSS.t252 VSS.n367 1194.85
R1744 VSS.n810 VSS.n809 1179.47
R1745 VSS.n25 VSS.t109 1145.59
R1746 VSS.n929 VSS.t253 1123.12
R1747 VSS.t164 VSS.n241 1116.54
R1748 VSS.n804 VSS.n803 1076.83
R1749 VSS.n898 VSS.n50 0.0367862
R1750 VSS.t114 VSS.t130 1070.41
R1751 VSS.t54 VSS.t69 1070.41
R1752 VSS.n136 VSS.t127 1040.26
R1753 VSS.t222 VSS.n1245 1022.06
R1754 VSS.n879 VSS.n302 1017.43
R1755 VSS.n1155 VSS.n241 988.644
R1756 VSS.n932 VSS.n931 960.953
R1757 VSS.n1213 VSS.t7 953.143
R1758 VSS.n1218 VSS.t9 953.143
R1759 VSS.n1051 VSS.t217 922.864
R1760 VSS.t203 VSS.n956 921.016
R1761 VSS.n957 VSS.t203 920.742
R1762 VSS.n964 VSS.n963 919.317
R1763 VSS.n595 VSS.n594 917.566
R1764 VSS.n887 VSS.n886 916.633
R1765 VSS.n1078 VSS.n306 913.574
R1766 VSS.t128 VSS.n894 905.301
R1767 VSS.n895 VSS.t128 904.722
R1768 VSS.n1069 VSS.n313 882.389
R1769 VSS.t7 VSS.t9 874.312
R1770 VSS.n883 VSS.n713 830.083
R1771 VSS.n1154 VSS.n242 801.995
R1772 VSS.n1103 VSS.n159 793.669
R1773 VSS.t172 VSS.n455 764.707
R1774 VSS.t109 VSS.n1151 755.428
R1775 VSS.n30 VSS.n897 0.577893
R1776 VSS.n963 VSS.n522 740.707
R1777 VSS.n594 VSS.n242 740.707
R1778 VSS.t73 VSS.n277 738.308
R1779 VSS.t122 VSS.n333 738.308
R1780 VSS.t73 VSS.t171 705.736
R1781 VSS.t16 VSS.t122 705.736
R1782 VSS.n601 VSS.n526 635.364
R1783 VSS.n602 VSS.n599 635.364
R1784 VSS.n1080 VSS.n305 634.668
R1785 VSS.t233 VSS.n296 634.668
R1786 VSS.n479 VSS.n475 609.375
R1787 VSS.n878 VSS.n869 608.807
R1788 VSS.n877 VSS.n871 608.807
R1789 VSS.t94 VSS.n608 588.941
R1790 VSS.n1156 VSS.t165 588.941
R1791 VSS.n1080 VSS.n302 588
R1792 VSS.n305 VSS.n304 588
R1793 VSS.n304 VSS.n303 588
R1794 VSS.n1085 VSS.n296 588
R1795 VSS.n1085 VSS.n298 588
R1796 VSS.n877 VSS.t233 584.5
R1797 VSS.n879 VSS.n878 584.5
R1798 VSS.n447 VSS.n170 583.25
R1799 VSS.n899 VSS.n898 561.75
R1800 VSS.t174 VSS.t176 549.633
R1801 VSS.n853 VSS.n715 531.188
R1802 VSS.n804 VSS.n787 511.584
R1803 VSS.n799 VSS.n798 511.584
R1804 VSS.n799 VSS.n795 511.584
R1805 VSS.n803 VSS.n795 511.584
R1806 VSS.n791 VSS.n786 511.584
R1807 VSS.n788 VSS.n786 511.584
R1808 VSS.n818 VSS.n788 511.584
R1809 VSS.n818 VSS.n787 511.584
R1810 VSS.n797 VSS.n792 511.584
R1811 VSS.n798 VSS.n797 511.584
R1812 VSS.n1173 VSS.n1172 494.342
R1813 VSS.n915 VSS.t137 489.043
R1814 VSS.n609 VSS.t230 483.298
R1815 VSS.t96 VSS.t94 472.791
R1816 VSS.t165 VSS.n1155 471.041
R1817 VSS.n1057 VSS.n328 462.288
R1818 VSS.n1079 VSS.n297 456.606
R1819 VSS.n1086 VSS.n297 456.606
R1820 VSS.t233 VSS.n1086 456.606
R1821 VSS.n36 VSS.n199 452.106
R1822 VSS.n1067 VSS.n313 414.361
R1823 VSS.n1069 VSS.n1068 414.361
R1824 VSS.n703 VSS.t161 399.765
R1825 VSS.n705 VSS.t163 399.493
R1826 VSS.n475 VSS.t176 394.301
R1827 VSS.n1173 VSS.n168 375.003
R1828 VSS.n1053 VSS.t59 371.214
R1829 VSS.t160 VSS.t213 369.318
R1830 VSS.t162 VSS.t163 366.452
R1831 VSS.t161 VSS.t162 366.452
R1832 VSS.n915 VSS.t119 366.127
R1833 VSS.n875 VSS.n872 363.974
R1834 VSS.n574 VSS.n116 344.67
R1835 VSS.n116 VSS.n26 344.67
R1836 VSS.t194 VSS.n668 343.074
R1837 VSS.n921 VSS.t194 343.074
R1838 VSS.t189 VSS.n1077 342.714
R1839 VSS.n916 VSS.t141 338.291
R1840 VSS.n918 VSS.t141 338.291
R1841 VSS.n1170 VSS.n1169 333.171
R1842 VSS.t129 VSS.n50 254.208
R1843 VSS.t133 VSS.t21 328.558
R1844 VSS.n874 VSS.n42 176.458
R1845 VSS.t230 VSS.n522 318.697
R1846 VSS.n745 VSS.n744 316.971
R1847 VSS.n1171 VSS.n1170 315.481
R1848 VSS.n762 VSS.n7 308
R1849 VSS.n867 VSS.n866 304.514
R1850 VSS.n987 VSS.t101 299.62
R1851 VSS.n644 VSS.t134 299.62
R1852 VSS.n1204 VSS.n190 299.057
R1853 VSS.n577 VSS.n576 299.057
R1854 VSS.n493 VSS.n492 299.057
R1855 VSS.n936 VSS.n935 299.057
R1856 VSS.n2 VSS.n145 298.084
R1857 VSS.n945 VSS.n506 291.18
R1858 VSS.n1241 VSS.n146 284.084
R1859 VSS.n25 VSS.n241 278.098
R1860 VSS.n1075 VSS.t49 277.933
R1861 VSS.n937 VSS.n662 274.557
R1862 VSS.n664 VSS.n662 274.557
R1863 VSS.t96 VSS.n525 273.947
R1864 VSS.n599 VSS.n522 270.223
R1865 VSS.n526 VSS.n242 270.223
R1866 VSS.n1057 VSS.n329 270.084
R1867 VSS.n1078 VSS.t189 267.757
R1868 VSS.t129 VSS.n694 260.454
R1869 VSS.n221 VSS.n187 258.029
R1870 VSS.n1207 VSS.n187 258.029
R1871 VSS.n590 VSS.t139 254.756
R1872 VSS.n1164 VSS.n232 254.756
R1873 VSS.n1017 VSS.n1016 247.244
R1874 VSS.n874 VSS.n317 244.767
R1875 VSS.t139 VSS.t87 243.517
R1876 VSS.n1164 VSS.t63 243.517
R1877 VSS.n449 VSS.n445 243.05
R1878 VSS.n1172 VSS.n1171 242.952
R1879 VSS.t64 VSS.n930 238.129
R1880 VSS.n1094 VSS.n287 236.833
R1881 VSS.t110 VSS.n47 234.695
R1882 VSS.n728 VSS.n146 233.917
R1883 VSS.n866 VSS.n715 233
R1884 VSS.n757 VSS.n756 231.988
R1885 VSS.n571 VSS.n26 230.404
R1886 VSS.n1145 VSS.n174 226.571
R1887 VSS.n615 VSS.n228 224.779
R1888 VSS.n1067 VSS.n1066 224.389
R1889 VSS.n872 VSS.n310 221.57
R1890 VSS.n939 VSS.n938 220.889
R1891 VSS.t110 VSS.n49 6.7
R1892 VSS.t243 VSS.n766 211.582
R1893 VSS.n664 VSS.n615 210.195
R1894 VSS.n1208 VSS.n186 207.862
R1895 VSS.n1178 VSS.n222 204.362
R1896 VSS.n488 VSS.t103 203.767
R1897 VSS.t259 VSS.n986 203.767
R1898 VSS.t15 VSS.n643 203.767
R1899 VSS.n735 VSS.n725 203.583
R1900 VSS.n897 VSS.t210 202.56
R1901 VSS.n927 VSS.t210 202.56
R1902 VSS.n847 VSS.t250 202.387
R1903 VSS.t104 VSS.n284 200.083
R1904 VSS.t17 VSS.n958 200.083
R1905 VSS.n547 VSS.t254 200.083
R1906 VSS.n358 VSS.t70 200.083
R1907 VSS.n209 VSS.n200 199.001
R1908 VSS.n421 VSS.n420 199.001
R1909 VSS.n285 VSS.n277 195.435
R1910 VSS.n1052 VSS.n333 195.435
R1911 VSS.n1121 VSS.n276 195.222
R1912 VSS.n1035 VSS.n369 195.222
R1913 VSS.n589 VSS.n542 195.222
R1914 VSS.n1165 VSS.n230 195.222
R1915 VSS.n360 VSS.n337 195.222
R1916 VSS.n1208 VSS.n1207 194.056
R1917 VSS.n756 VSS.n734 193.667
R1918 VSS.n1114 VSS.n1105 186.279
R1919 VSS.n443 VSS.n441 186.279
R1920 VSS.n210 VSS.n202 186.279
R1921 VSS.n210 VSS.n201 186.279
R1922 VSS.n422 VSS.n418 186.279
R1923 VSS.n19 VSS.n598 186.279
R1924 VSS.n600 VSS.n519 186.279
R1925 VSS.n78 VSS.n332 186.279
R1926 VSS.n245 VSS.n239 185.012
R1927 VSS.n385 VSS.n381 185.001
R1928 VSS.n604 VSS.n523 185.001
R1929 VSS.n652 VSS.n651 183.268
R1930 VSS.n48 VSS.n575 183.07
R1931 VSS.n1220 VSS.n177 182.244
R1932 VSS.t174 VSS.t172 179.228
R1933 VSS.n1065 VSS.t49 178.672
R1934 VSS.n1116 VSS.n1115 178.112
R1935 VSS.n444 VSS.n439 178.112
R1936 VSS.n397 VSS.n391 178.112
R1937 VSS.n537 VSS.n530 178.112
R1938 VSS.n518 VSS.n517 178.112
R1939 VSS.n349 VSS.n336 178.112
R1940 VSS.t187 VSS.n860 177.964
R1941 VSS.n845 VSS.n766 177.416
R1942 VSS.n160 VSS.n1 176.362
R1943 VSS.n474 VSS.n472 176.167
R1944 VSS.n1015 VSS.n1014 176.035
R1945 VSS.n1241 VSS.n145 173.833
R1946 VSS.n161 VSS.n1 172.862
R1947 VSS.n115 VSS.n47 172.764
R1948 VSS.n104 VSS.t217 172.334
R1949 VSS.t107 VSS.n104 172.334
R1950 VSS.n574 VSS.t107 172.334
R1951 VSS.t222 VSS.t66 170.363
R1952 VSS.n728 VSS.n727 170.333
R1953 VSS.n731 VSS.n725 170.333
R1954 VSS.n19 VSS.n529 169.587
R1955 VSS.n1105 VSS.n260 169.587
R1956 VSS.n422 VSS.n376 169.587
R1957 VSS.n600 VSS.n236 169.587
R1958 VSS.n78 VSS.n331 169.587
R1959 VSS.t65 VSS.n1010 169.404
R1960 VSS.n827 VSS.n826 169.32
R1961 VSS.n1133 VSS.n263 165.107
R1962 VSS.n1159 VSS.n234 165.107
R1963 VSS.n593 VSS.n592 165.107
R1964 VSS.n346 VSS.n345 165.107
R1965 VSS.n478 VSS.t158 160.361
R1966 VSS.n1010 VSS.t93 160.361
R1967 VSS.n488 VSS.t208 160.361
R1968 VSS.n986 VSS.t88 160.361
R1969 VSS.n981 VSS.t126 160.361
R1970 VSS.n651 VSS.t126 160.361
R1971 VSS.n643 VSS.t30 160.361
R1972 VSS.n638 VSS.t30 160.361
R1973 VSS.n638 VSS.t91 160.361
R1974 VSS.t91 VSS.n637 160.361
R1975 VSS.n940 VSS.t99 160.361
R1976 VSS.n940 VSS.t13 160.361
R1977 VSS.t199 VSS.n567 159.846
R1978 VSS.n966 VSS.t227 159.846
R1979 VSS.n1229 VSS.n170 158.638
R1980 VSS.t233 VSS.n876 156.011
R1981 VSS.n1217 VSS.n177 155.507
R1982 VSS.n1021 VSS.n460 154.389
R1983 VSS.n564 VSS.n561 154.389
R1984 VSS.n956 VSS.n614 154.389
R1985 VSS.n51 VSS.n669 153.222
R1986 VSS.t71 VSS.t43 152.95
R1987 VSS.n1115 VSS.n1114 152.445
R1988 VSS.n439 VSS.n201 152.445
R1989 VSS.n418 VSS.n391 152.445
R1990 VSS.n598 VSS.n530 152.445
R1991 VSS.n519 VSS.n518 152.445
R1992 VSS.n349 VSS.n332 152.445
R1993 VSS.n1098 VSS.n282 151.57
R1994 VSS.n958 VSS.n237 147.945
R1995 VSS.n284 VSS.n259 147.879
R1996 VSS.n1037 VSS.n375 147.879
R1997 VSS.n547 VSS.n546 147.879
R1998 VSS.n358 VSS.n76 147.879
R1999 VSS.n1098 VSS.n1097 147.487
R2000 VSS.n981 VSS.n980 145.288
R2001 VSS.n1227 VSS.n1226 144.15
R2002 VSS.n1205 VSS.n1204 143.5
R2003 VSS.n578 VSS.n577 143.5
R2004 VSS.n495 VSS.n493 143.5
R2005 VSS.n935 VSS.n666 143.5
R2006 VSS.n1168 VSS.n114 141.803
R2007 VSS.n440 VSS.n202 141.362
R2008 VSS.n999 VSS.n998 140.466
R2009 VSS.n314 VSS.n309 138.056
R2010 VSS.n1066 VSS.n315 138.056
R2011 VSS.t121 VSS.t192 136.867
R2012 VSS.t191 VSS.t218 133.919
R2013 VSS.n479 VSS.n478 132.629
R2014 VSS.n637 VSS.n635 132.629
R2015 VSS.n14 VSS.n556 131.833
R2016 VSS.n977 VSS.n508 131.833
R2017 VSS.n1020 VSS.n41 131.833
R2018 VSS.n704 VSS.n703 129.994
R2019 VSS.n721 VSS.n723 129.994
R2020 VSS.n1134 VSS.n262 129.624
R2021 VSS.n1158 VSS.n235 129.624
R2022 VSS.n544 VSS.n533 129.624
R2023 VSS.n344 VSS.n75 129.624
R2024 VSS.n865 VSS.n716 128.535
R2025 VSS.n889 VSS.n888 127.657
R2026 VSS.n1202 VSS.n194 126.972
R2027 VSS.n1013 VSS.n465 126.876
R2028 VSS.n620 VSS.n226 126.876
R2029 VSS.n1235 VSS.n161 126.195
R2030 VSS.n474 VSS.n471 126.105
R2031 VSS.n470 VSS.n164 126.097
R2032 VSS.t236 VSS.n382 125.46
R2033 VSS.n882 VSS.t191 125.138
R2034 VSS.n276 VSS.n271 124.251
R2035 VSS.n398 VSS.n369 124.251
R2036 VSS.n542 VSS.n541 124.251
R2037 VSS.n516 VSS.n230 124.251
R2038 VSS.n363 VSS.n337 124.251
R2039 VSS.n947 VSS.n55 124.056
R2040 VSS.n1089 VSS.n1088 123.862
R2041 VSS.n862 VSS.n90 123.862
R2042 VSS.t74 VSS.t104 123.106
R2043 VSS.t0 VSS.t17 123.106
R2044 VSS.t254 VSS.t140 123.106
R2045 VSS.t70 VSS.t123 123.106
R2046 VSS.n2 VSS.n158 122.695
R2047 VSS.n1235 VSS.n160 122.695
R2048 VSS.n727 VSS.n282 122.695
R2049 VSS.n1011 VSS.n469 122.501
R2050 VSS.n1011 VSS.n468 122.501
R2051 VSS.n997 VSS.n497 121.778
R2052 VSS.n1249 VSS.n137 121.373
R2053 VSS.n811 VSS.n724 120.945
R2054 VSS.n1146 VSS.n195 120.945
R2055 VSS.n1023 VSS.n386 120.945
R2056 VSS.t110 VSS.n89 1.02316
R2057 VSS.n962 VSS.t110 1.02316
R2058 VSS.t13 VSS.t1 119.367
R2059 VSS.n449 VSS.n448 118.9
R2060 VSS.n726 VSS.n145 118.213
R2061 VSS.n886 VSS.n707 117.793
R2062 VSS.n1243 VSS.n1242 117.505
R2063 VSS.n1155 VSS.n1154 117.323
R2064 VSS.n1134 VSS.n1133 116.59
R2065 VSS.n1159 VSS.n1158 116.59
R2066 VSS.n592 VSS.n533 116.59
R2067 VSS.n346 VSS.n344 116.59
R2068 VSS.n825 VSS.n772 116.57
R2069 VSS.n830 VSS.n778 116.57
R2070 VSS.n1229 VSS.n167 116.558
R2071 VSS.n1101 VSS.n1100 116.487
R2072 VSS.t200 VSS.n997 116.352
R2073 VSS.n609 VSS.t96 115.572
R2074 VSS.n1121 VSS.n275 115.501
R2075 VSS.n284 VSS.n275 115.501
R2076 VSS.n1120 VSS.n276 115.501
R2077 VSS.n1036 VSS.n1035 115.501
R2078 VSS.n1037 VSS.n1036 115.501
R2079 VSS.n1048 VSS.n369 115.501
R2080 VSS.n542 VSS.n538 115.501
R2081 VSS.n589 VSS.n540 115.501
R2082 VSS.n547 VSS.n540 115.501
R2083 VSS.n958 VSS.n231 115.501
R2084 VSS.n1165 VSS.n231 115.501
R2085 VSS.n1163 VSS.n230 115.501
R2086 VSS.n360 VSS.n359 115.501
R2087 VSS.n359 VSS.n358 115.501
R2088 VSS.n351 VSS.n337 115.501
R2089 VSS.n866 VSS.n865 115.138
R2090 VSS.t196 VSS.t198 114.891
R2091 VSS.t225 VSS.t228 114.891
R2092 VSS.n1232 VSS.n167 112.912
R2093 VSS.n471 VSS.n470 112.195
R2094 VSS.n1013 VSS.n464 112.001
R2095 VSS.n934 VSS.n620 112.001
R2096 VSS.n1203 VSS.n1202 111.903
R2097 VSS.n552 VSS.n103 111.903
R2098 VSS.n223 VSS.t4 111.867
R2099 VSS.n999 VSS.n461 109.721
R2100 VSS.n701 VSS.n700 107.334
R2101 VSS.n850 VSS.n716 107.334
R2102 VSS.n702 VSS.n701 105.389
R2103 VSS.n633 VSS.n624 105.267
R2104 VSS.n647 VSS.n504 105.267
R2105 VSS.n498 VSS.n485 105.267
R2106 VSS.n1221 VSS.n176 103.572
R2107 VSS.t99 VSS.n658 102.487
R2108 VSS.n836 VSS.n776 100.722
R2109 VSS.n733 VSS.n7 99.3616
R2110 VSS.n1065 VSS.n1064 99.2624
R2111 VSS.n829 VSS.n819 98.6558
R2112 VSS.n859 VSS.n848 98.4296
R2113 VSS.n894 VSS.n697 96.2116
R2114 VSS.n29 VSS.n697 96.2116
R2115 VSS.n1246 VSS.n139 96.0561
R2116 VSS.n135 VSS.n139 96.0561
R2117 VSS.n140 VSS.n133 96.0561
R2118 VSS.n134 VSS.n140 96.0561
R2119 VSS.n1219 VSS.n178 96.0561
R2120 VSS.n38 VSS.n459 96.0561
R2121 VSS.n969 VSS.n70 96.0561
R2122 VSS.n1074 VSS.n310 95.0838
R2123 VSS.n1063 VSS.n317 95.0838
R2124 VSS.n851 VSS.n850 94.5977
R2125 VSS.n437 VSS.n174 92.7505
R2126 VSS.n907 VSS.n906 92.7505
R2127 VSS.n820 VSS.n767 92.5561
R2128 VSS.n821 VSS.n820 92.5561
R2129 VSS.n1021 VSS.n1020 92.5561
R2130 VSS.n564 VSS.n556 92.5561
R2131 VSS.n10 VSS.n563 92.5561
R2132 VSS.n956 VSS.n508 92.5561
R2133 VSS.n762 VSS.n730 92.5561
R2134 VSS.n737 VSS.n287 92.5561
R2135 VSS.n1094 VSS.n288 92.5561
R2136 VSS.n840 VSS.n770 92.5561
R2137 VSS.n840 VSS.n769 92.5561
R2138 VSS.n928 VSS.n927 92.2376
R2139 VSS.n1224 VSS.n174 91.3292
R2140 VSS.n1015 VSS.n462 90.429
R2141 VSS.n448 VSS.n428 90.1005
R2142 VSS.n1206 VSS.n188 89.8338
R2143 VSS.n554 VSS.n553 89.8338
R2144 VSS.n665 VSS.n663 89.8338
R2145 VSS.n1025 VSS.n1024 88.5513
R2146 VSS.n246 VSS.n243 88.5513
R2147 VSS.n612 VSS.n524 88.5513
R2148 VSS.n1144 VSS.n176 87.7591
R2149 VSS.n32 VSS.n698 85.9449
R2150 VSS.n32 VSS.n699 85.9449
R2151 VSS.n859 VSS.n849 85.9449
R2152 VSS.t106 VSS.n827 85.8951
R2153 VSS.n1168 VSS.n225 84.2996
R2154 VSS.n571 VSS.n570 83.67
R2155 VSS.n978 VSS.n507 83.67
R2156 VSS.n701 VSS.n699 83.6116
R2157 VSS.n850 VSS.n849 83.6116
R2158 VSS.n1101 VSS.n280 82.8809
R2159 VSS.n570 VSS.t198 82.4213
R2160 VSS.t228 VSS.n507 82.4213
R2161 VSS.n700 VSS.n697 82.2505
R2162 VSS.n491 VSS.n490 81.8616
R2163 VSS.n505 VSS.n501 81.8616
R2164 VSS.n634 VSS.n631 81.8616
R2165 VSS.n923 VSS.n922 81.6239
R2166 VSS.n917 VSS.n691 81.6238
R2167 VSS.n448 VSS.n167 81.4356
R2168 VSS.n1097 VSS.n158 81.3755
R2169 VSS.n916 VSS.n915 80.5457
R2170 VSS.n1220 VSS.n1219 80.2088
R2171 VSS.n1118 VSS.n275 79.7227
R2172 VSS.n1036 VSS.n1033 79.7227
R2173 VSS.n540 VSS.n539 79.7227
R2174 VSS.n1161 VSS.n231 79.7227
R2175 VSS.n359 VSS.n339 79.7227
R2176 VSS.n1116 VSS.n271 77.5838
R2177 VSS.n445 VSS.n444 77.5838
R2178 VSS.n398 VSS.n397 77.5838
R2179 VSS.n541 VSS.n537 77.5838
R2180 VSS.n517 VSS.n516 77.5838
R2181 VSS.n363 VSS.n336 77.5838
R2182 VSS.n476 VSS.n224 76.5633
R2183 VSS.n1222 VSS.n1221 76.3199
R2184 VSS.n1100 VSS.n1099 76.2663
R2185 VSS.n908 VSS.n907 76.1815
R2186 VSS.t187 VSS.n847 74.9182
R2187 VSS.n633 VSS.n629 74.7644
R2188 VSS.n504 VSS.n499 74.7644
R2189 VSS.n486 VSS.n485 74.7644
R2190 VSS.n881 VSS.n880 73.8205
R2191 VSS.n854 VSS.t218 73.1344
R2192 VSS.n751 VSS.n749 73.1116
R2193 VSS.t20 VSS.t18 72.9972
R2194 VSS.n1009 VSS.n225 72.7227
R2195 VSS.n996 VSS.n491 72.7227
R2196 VSS.n650 VSS.n505 72.7227
R2197 VSS.n636 VSS.n634 72.7227
R2198 VSS.n660 VSS.n659 72.7227
R2199 VSS.n942 VSS.n660 72.7227
R2200 VSS.n943 VSS.n942 72.7227
R2201 VSS.n943 VSS.n659 72.7227
R2202 VSS.n1245 VSS.n1244 72.7152
R2203 VSS.n686 VSS.n681 72.2631
R2204 VSS.n608 VSS.n604 72.2631
R2205 VSS.n1029 VSS.n381 72.2631
R2206 VSS.n748 VSS.n745 72.2631
R2207 VSS.n1156 VSS.n239 72.1995
R2208 VSS.n990 VSS.n498 69.9439
R2209 VSS.n657 VSS.n624 69.7537
R2210 VSS.n1004 VSS.n481 69.7537
R2211 VSS.n648 VSS.n647 69.7537
R2212 VSS.n38 VSS.n460 68.8806
R2213 VSS.n10 VSS.n561 68.8806
R2214 VSS.n614 VSS.n70 68.8806
R2215 VSS.n1091 VSS.n291 68.6394
R2216 VSS.n140 VSS.n139 68.4449
R2217 VSS.n846 VSS.t115 68.332
R2218 VSS.n822 VSS.t246 68.332
R2219 VSS.t248 VSS.n828 68.332
R2220 VSS.n1111 VSS.n1110 68.2505
R2221 VSS.n1108 VSS.n1107 68.2505
R2222 VSS.n1127 VSS.n269 68.2505
R2223 VSS.n124 VSS.n1129 68.2505
R2224 VSS.n1140 VSS.n250 68.2505
R2225 VSS.n1139 VSS.n251 68.2505
R2226 VSS.n453 VSS.n82 68.2505
R2227 VSS.n37 VSS.n425 68.2505
R2228 VSS.n396 VSS.n393 68.2505
R2229 VSS.n394 VSS.n388 68.2505
R2230 VSS.n206 VSS.n208 68.2505
R2231 VSS.n1194 VSS.n205 68.2505
R2232 VSS.t57 VSS.n46 1.05376
R2233 VSS.n451 VSS.n204 68.2505
R2234 VSS.n414 VSS.n412 68.2505
R2235 VSS.n415 VSS.n411 68.2505
R2236 VSS.n404 VSS.n403 68.2505
R2237 VSS.n407 VSS.n406 68.2505
R2238 VSS.t167 VSS.t110 0.447689
R2239 VSS.n27 VSS.n535 0.606794
R2240 VSS.n126 VSS.n515 68.2505
R2241 VSS.n514 VSS.n512 68.2505
R2242 VSS.n74 VSS.n68 1.60196
R2243 VSS.n353 VSS.n350 68.2505
R2244 VSS.n356 VSS.n355 68.2505
R2245 VSS.t158 VSS.n477 67.5204
R2246 VSS.n590 VSS.t242 67.4357
R2247 VSS.n959 VSS.n232 67.4357
R2248 VSS.n1214 VSS.n1212 66.6949
R2249 VSS.n14 VSS.n555 66.6949
R2250 VSS.n977 VSS.n509 66.6949
R2251 VSS.n41 VSS.n456 66.6949
R2252 VSS.n907 VSS.n900 66.4455
R2253 VSS.t76 VSS.n213 65.475
R2254 VSS.n1111 VSS.n1106 64.2445
R2255 VSS.t26 VSS.n1108 64.2445
R2256 VSS.n1129 VSS.n1128 64.2445
R2257 VSS.n269 VSS.t215 64.2445
R2258 VSS.n252 VSS.n251 64.2445
R2259 VSS.t152 VSS.n250 64.2445
R2260 VSS.t85 VSS.t110 0.447689
R2261 VSS.t234 VSS.n82 64.2445
R2262 VSS.n454 VSS.n425 64.2445
R2263 VSS.n46 VSS.n204 64.2543
R2264 VSS.n208 VSS.t47 64.2445
R2265 VSS.n1194 VSS.n207 64.2445
R2266 VSS.n415 VSS.n413 64.2445
R2267 VSS.t111 VSS.n414 64.2445
R2268 VSS.t110 VSS.t55 0.496493
R2269 VSS.n406 VSS.n405 64.2445
R2270 VSS.n403 VSS.t201 64.2445
R2271 VSS.n396 VSS.n395 64.2445
R2272 VSS.t255 VSS.n388 64.2445
R2273 VSS.n515 VSS.t31 64.2445
R2274 VSS.n513 VSS.n512 64.2445
R2275 VSS.n355 VSS.n354 64.2445
R2276 VSS.n350 VSS.t52 64.2445
R2277 VSS.n848 VSS.n716 64.2074
R2278 VSS.n316 VSS.n315 64.0699
R2279 VSS.n1236 VSS.t156 64.0043
R2280 VSS.n1145 VSS.n1144 63.9727
R2281 VSS.n1024 VSS.n385 63.9727
R2282 VSS.n246 VSS.n245 63.9727
R2283 VSS.n524 VSS.n523 63.9727
R2284 VSS.n932 VSS.t64 63.9033
R2285 VSS.n679 VSS.n678 63.0977
R2286 VSS.n914 VSS.n693 63.0977
R2287 VSS.n575 VSS.n554 62.3199
R2288 VSS.n903 VSS.n693 61.718
R2289 VSS.n678 VSS.n674 61.718
R2290 VSS.n680 VSS.n679 61.4936
R2291 VSS.n914 VSS.n900 61.4936
R2292 VSS.n1043 VSS.n1042 59.7431
R2293 VSS.n993 VSS.n992 59.6833
R2294 VSS.n806 VSS.n673 59.5555
R2295 VSS.n314 VSS.n308 59.4033
R2296 VSS.n682 VSS.n675 58.3338
R2297 VSS.n431 VSS.n175 58.3338
R2298 VSS.n1152 VSS.n240 58.3338
R2299 VSS.n605 VSS.n528 58.3338
R2300 VSS.n1028 VSS.n380 58.3338
R2301 VSS.n695 VSS.n670 58.3338
R2302 VSS.n696 VSS.n671 58.3338
R2303 VSS.n909 VSS.n902 58.3338
R2304 VSS.n318 VSS.n311 58.3338
R2305 VSS.n736 VSS.n154 58.3338
R2306 VSS.n750 VSS.n149 58.3338
R2307 VSS.n715 VSS.n714 58.3338
R2308 VSS.n569 VSS.t110 1.00496
R2309 VSS.t110 VSS.n13 0.705233
R2310 VSS.n973 VSS.n972 57.9449
R2311 VSS.n972 VSS.n88 57.9449
R2312 VSS.t144 VSS.n52 1.01461
R2313 VSS.t144 VSS.n105 1.00496
R2314 VSS.n433 VSS.n183 57.9449
R2315 VSS.n434 VSS.n433 57.9449
R2316 VSS.n944 VSS.n658 57.8747
R2317 VSS.n1000 VSS.n491 57.1672
R2318 VSS.n982 VSS.n505 57.1672
R2319 VSS.n639 VSS.n634 57.1672
R2320 VSS.n690 VSS.n674 56.8341
R2321 VSS.n1025 VSS.n383 56.8341
R2322 VSS.n560 VSS.n243 56.8341
R2323 VSS.n613 VSS.n612 56.8341
R2324 VSS.n903 VSS.n672 56.8341
R2325 VSS.n480 VSS.n225 54.9236
R2326 VSS.n795 VSS.n787 53.6672
R2327 VSS.n798 VSS.n788 53.6672
R2328 VSS.n792 VSS.n791 53.6672
R2329 VSS.n222 VSS.n190 53.6672
R2330 VSS.n222 VSS.n221 53.6672
R2331 VSS.n1206 VSS.n1205 53.6672
R2332 VSS.n1207 VSS.n1206 53.6672
R2333 VSS.n891 VSS.n698 53.6672
R2334 VSS.n578 VSS.n553 53.6672
R2335 VSS.n47 VSS.n553 53.6672
R2336 VSS.n576 VSS.n48 53.6672
R2337 VSS.n1068 VSS.n1067 53.6672
R2338 VSS.n878 VSS.n877 53.6672
R2339 VSS.n493 VSS.n464 53.6672
R2340 VSS.n472 VSS.n469 53.6672
R2341 VSS.n492 VSS.n469 53.6672
R2342 VSS.n665 VSS.n664 53.6672
R2343 VSS.n666 VSS.n665 53.6672
R2344 VSS.n938 VSS.n937 53.6672
R2345 VSS.n938 VSS.n936 53.6672
R2346 VSS.n856 VSS.n848 53.6672
R2347 VSS.n261 VSS.n259 53.1767
R2348 VSS.n377 VSS.n375 53.1767
R2349 VSS.n546 VSS.n21 53.1767
R2350 VSS.n77 VSS.n76 53.1767
R2351 VSS.n18 VSS.n237 53.1111
R2352 VSS.n838 VSS.n772 51.7227
R2353 VSS.n834 VSS.n778 51.7227
R2354 VSS.n700 VSS.n698 51.7227
R2355 VSS.n947 VSS.n657 51.7227
R2356 VSS.n1004 VSS.n482 51.7227
R2357 VSS.n990 VSS.n989 51.7227
R2358 VSS.n648 VSS.n646 51.7227
R2359 VSS.n862 VSS.n718 51.7227
R2360 VSS.n825 VSS.n823 51.6255
R2361 VSS.n830 VSS.n785 51.6255
R2362 VSS.n653 VSS.t92 1.00072
R2363 VSS.t92 VSS.n95 1.00006
R2364 VSS.n1007 VSS.t92 1.00026
R2365 VSS.t92 VSS.n55 1.00034
R2366 VSS.n844 VSS.n90 51.6255
R2367 VSS.n868 VSS.n867 51.4017
R2368 VSS.n1020 VSS.n1019 50.9449
R2369 VSS.n562 VSS.n556 50.9449
R2370 VSS.n968 VSS.n508 50.9449
R2371 VSS.t208 VSS.n461 50.6405
R2372 VSS.n291 VSS.n286 50.3616
R2373 VSS.n741 VSS.n291 50.3616
R2374 VSS.n494 VSS.n464 50.1672
R2375 VSS.n495 VSS.n494 50.1672
R2376 VSS.n63 VSS.n851 49.5838
R2377 VSS.n753 VSS.n735 49.143
R2378 VSS.n685 VSS.n681 48.8582
R2379 VSS.n610 VSS.n604 48.8582
R2380 VSS.n1030 VSS.n381 48.8582
R2381 VSS.n745 VSS.n151 48.8582
R2382 VSS.n1153 VSS.n239 48.8472
R2383 VSS.n655 VSS.n625 48.8319
R2384 VSS.t156 VSS.n159 48.7756
R2385 VSS.n496 VSS.n466 48.7088
R2386 VSS.n933 VSS.n617 48.7088
R2387 VSS.n680 VSS.n329 48.2713
R2388 VSS.n900 VSS.n899 48.2713
R2389 VSS.n294 VSS.n291 47.9311
R2390 VSS.n785 VSS.n784 47.6394
R2391 VSS.n685 VSS.n682 47.4449
R2392 VSS.n684 VSS.n682 47.4449
R2393 VSS.n686 VSS.n675 47.4449
R2394 VSS.n689 VSS.n675 47.4449
R2395 VSS.n1222 VSS.n175 47.4449
R2396 VSS.n1224 VSS.n175 47.4449
R2397 VSS.n431 VSS.n430 47.4449
R2398 VSS.n437 VSS.n431 47.4449
R2399 VSS.n559 VSS.n240 47.4449
R2400 VSS.n1156 VSS.n240 47.4449
R2401 VSS.n1152 VSS.t110 47.4449
R2402 VSS.n1153 VSS.n1152 47.4449
R2403 VSS.n608 VSS.n605 47.4449
R2404 VSS.n605 VSS.n527 47.4449
R2405 VSS.n610 VSS.n528 47.4449
R2406 VSS.n611 VSS.n528 47.4449
R2407 VSS.n1029 VSS.n1028 47.4449
R2408 VSS.n1028 VSS.n1027 47.4449
R2409 VSS.n1030 VSS.n380 47.4449
R2410 VSS.n1026 VSS.n380 47.4449
R2411 VSS.n671 VSS.n669 47.4449
R2412 VSS.n926 VSS.n671 47.4449
R2413 VSS.n926 VSS.n670 47.4449
R2414 VSS.n894 VSS.n670 47.4449
R2415 VSS.n696 VSS.n51 47.4449
R2416 VSS.n896 VSS.n696 47.4449
R2417 VSS.n896 VSS.n695 47.4449
R2418 VSS.n29 VSS.n695 47.4449
R2419 VSS.n909 VSS.n908 47.4449
R2420 VSS.n910 VSS.n909 47.4449
R2421 VSS.n906 VSS.n902 47.4449
R2422 VSS.n904 VSS.n902 47.4449
R2423 VSS.n311 VSS.n308 47.4449
R2424 VSS.n1074 VSS.n311 47.4449
R2425 VSS.n318 VSS.n316 47.4449
R2426 VSS.n1063 VSS.n318 47.4449
R2427 VSS.n743 VSS.n736 47.4449
R2428 VSS.n753 VSS.n736 47.4449
R2429 VSS.n154 VSS.n150 47.4449
R2430 VSS.n152 VSS.n154 47.4449
R2431 VSS.n151 VSS.n149 47.4449
R2432 VSS.n1237 VSS.n149 47.4449
R2433 VSS.n750 VSS.n748 47.4449
R2434 VSS.n751 VSS.n750 47.4449
R2435 VSS.n868 VSS.n714 47.4449
R2436 VSS.n63 VSS.n714 47.4449
R2437 VSS.n678 VSS.n328 46.6672
R2438 VSS.n694 VSS.n693 46.6672
R2439 VSS.n303 VSS.n302 46.6672
R2440 VSS.n303 VSS.n298 46.6672
R2441 VSS.n305 VSS.n296 46.6672
R2442 VSS.n298 VSS.t233 81.6794
R2443 VSS.n1100 VSS.n161 46.6672
R2444 VSS.n823 VSS.n821 46.5894
R2445 VSS.n430 VSS.n176 46.3755
R2446 VSS.n690 VSS.n689 46.1362
R2447 VSS.n560 VSS.n559 46.1362
R2448 VSS.n613 VSS.n527 46.1362
R2449 VSS.n1027 VSS.n383 46.1362
R2450 VSS.n910 VSS.n672 46.1362
R2451 VSS.n330 VSS.n329 45.4305
R2452 VSS.n899 VSS.n692 45.4305
R2453 VSS.n694 VSS.n692 45.4305
R2454 VSS.n757 VSS.n733 44.7227
R2455 VSS.n731 VSS.n730 44.7227
R2456 VSS.t177 VSS.t200 44.009
R2457 VSS.n743 VSS.n281 43.9449
R2458 VSS.n281 VSS.n150 43.9449
R2459 VSS.n1175 VSS.n170 42.8691
R2460 VSS.n1132 VSS.n264 42.5838
R2461 VSS.n1044 VSS.n372 42.5838
R2462 VSS.n591 VSS.n531 42.5838
R2463 VSS.n24 VSS.n233 42.5838
R2464 VSS.n347 VSS.n343 42.5838
R2465 VSS.n152 VSS.n153 42.2023
R2466 VSS.n979 VSS.n978 41.8353
R2467 VSS.n684 VSS.n674 41.8061
R2468 VSS.t110 VSS.n243 41.8061
R2469 VSS.n612 VSS.n611 41.8061
R2470 VSS.n1026 VSS.n1025 41.8061
R2471 VSS.n904 VSS.n903 41.8061
R2472 VSS.n1237 VSS.n148 41.8061
R2473 VSS.n481 VSS.n480 41.6116
R2474 VSS.n726 VSS.n158 41.3199
R2475 VSS.n844 VSS.n767 41.1255
R2476 VSS.n1188 VSS.n1187 41.0742
R2477 VSS.n1178 VSS.n188 41.0283
R2478 VSS.t1 VSS.n661 40.9948
R2479 VSS.n867 VSS.n64 40.2715
R2480 VSS.n563 VSS.n557 40.2505
R2481 VSS.n285 VSS.n262 39.1048
R2482 VSS.n959 VSS.n235 39.1048
R2483 VSS.n544 VSS.t242 39.1048
R2484 VSS.n1052 VSS.n75 39.1048
R2485 VSS.t233 VSS.t182 37.871
R2486 VSS.n880 VSS.t182 37.871
R2487 VSS.t219 VSS.n881 37.871
R2488 VSS.n819 VSS.t51 37.871
R2489 VSS.n793 VSS.t51 37.871
R2490 VSS.n285 VSS.t74 37.6565
R2491 VSS.n959 VSS.t0 37.6565
R2492 VSS.t140 VSS.t242 37.6565
R2493 VSS.n1052 VSS.t123 37.6565
R2494 VSS.n1120 VSS.n1119 37.4797
R2495 VSS.n1048 VSS.n368 37.4797
R2496 VSS.n538 VSS.n536 37.4797
R2497 VSS.n1163 VSS.n1162 37.4797
R2498 VSS.n352 VSS.n351 37.4797
R2499 VSS.t196 VSS.t199 37.4645
R2500 VSS.t225 VSS.t227 37.4645
R2501 VSS.n923 VSS.n672 37.3691
R2502 VSS.n691 VSS.n690 37.3691
R2503 VSS.n184 VSS.n178 36.7505
R2504 VSS.n970 VSS.n969 36.7505
R2505 VSS.n459 VSS.n457 36.7505
R2506 VSS.t18 VSS.n854 36.4989
R2507 VSS.n855 VSS.t20 36.4989
R2508 VSS.n855 VSS.t184 36.4989
R2509 VSS.n860 VSS.t184 36.4989
R2510 VSS.n31 VSS.n923 36.4168
R2511 VSS.n118 VSS.n691 36.4168
R2512 VSS.n749 VSS.n148 35.348
R2513 VSS.n758 VSS.n757 35.18
R2514 VSS.n758 VSS.n731 35.18
R2515 VSS.n1056 VSS.n330 35.0005
R2516 VSS.n1203 VSS.n193 34.6116
R2517 VSS.n581 VSS.n552 34.6116
R2518 VSS.n466 VSS.n464 34.6116
R2519 VSS.n934 VSS.n933 34.6116
R2520 VSS.n1114 VSS.n1113 33.8338
R2521 VSS.n1113 VSS.n264 33.8338
R2522 VSS.n1119 VSS.n1117 33.8338
R2523 VSS.n1115 VSS.n278 33.8338
R2524 VSS.n278 VSS.n265 33.8338
R2525 VSS.n441 VSS.n36 33.8338
R2526 VSS.n439 VSS.n36 33.8338
R2527 VSS.n1196 VSS.n202 33.8338
R2528 VSS.n1196 VSS.n201 33.8338
R2529 VSS.n418 VSS.n417 33.8338
R2530 VSS.n417 VSS.n372 33.8338
R2531 VSS.n401 VSS.n368 33.8338
R2532 VSS.n391 VSS.n390 33.8338
R2533 VSS.n390 VSS.n373 33.8338
R2534 VSS.n598 VSS.n597 33.8338
R2535 VSS.n597 VSS.n531 33.8338
R2536 VSS.n22 VSS.n530 33.8338
R2537 VSS.n22 VSS.n534 33.8338
R2538 VSS.n12 VSS.n536 33.8338
R2539 VSS.n1162 VSS.n97 33.8338
R2540 VSS.n1160 VSS.n15 33.8338
R2541 VSS.n518 VSS.n15 33.8338
R2542 VSS.n17 VSS.n233 33.8338
R2543 VSS.n17 VSS.n519 33.8338
R2544 VSS.n342 VSS.n332 33.8338
R2545 VSS.n343 VSS.n342 33.8338
R2546 VSS.n65 VSS.n352 33.8338
R2547 VSS.n66 VSS.n349 33.8338
R2548 VSS.n66 VSS.n348 33.8338
R2549 VSS.n811 VSS.n792 33.6394
R2550 VSS.n791 VSS.n724 33.6394
R2551 VSS.n122 VSS.n217 32.6185
R2552 VSS.n1212 VSS.n1211 30.7227
R2553 VSS.n1211 VSS.n184 30.7227
R2554 VSS.n568 VSS.n555 30.7227
R2555 VSS.n568 VSS.n557 30.7227
R2556 VSS.n971 VSS.n970 30.7227
R2557 VSS.n971 VSS.n509 30.7227
R2558 VSS.n1022 VSS.n457 30.7227
R2559 VSS.n1022 VSS.n456 30.7227
R2560 VSS.n681 VSS.n680 29.7584
R2561 VSS.t11 VSS.n463 29.5405
R2562 VSS.t190 VSS.t219 29.0894
R2563 VSS.t154 VSS.n1103 28.7361
R2564 VSS.n1118 VSS.n265 28.7297
R2565 VSS.n1033 VSS.n373 28.7297
R2566 VSS.n539 VSS.n534 28.7297
R2567 VSS.n1161 VSS.n1160 28.7297
R2568 VSS.n348 VSS.n339 28.7297
R2569 VSS.n35 VSS.n428 28.6005
R2570 VSS.n642 VSS.n629 28.5838
R2571 VSS.n985 VSS.n499 28.5838
R2572 VSS.n489 VSS.n486 28.5838
R2573 VSS.n733 VSS.n732 28.5838
R2574 VSS.n732 VSS.n730 28.5838
R2575 VSS.n1144 VSS.n195 28.4866
R2576 VSS.n1146 VSS.n1145 28.4866
R2577 VSS.n1024 VSS.n1023 28.4866
R2578 VSS.n386 VSS.n385 28.4866
R2579 VSS.n1149 VSS.n246 28.4866
R2580 VSS.n245 VSS.n89 28.4866
R2581 VSS.n54 VSS.n524 28.4866
R2582 VSS.n962 VSS.n523 28.4866
R2583 VSS.n1119 VSS.n1118 28.438
R2584 VSS.n1033 VSS.n368 28.438
R2585 VSS.n539 VSS.n536 28.438
R2586 VSS.n1162 VSS.n1161 28.438
R2587 VSS.n352 VSS.n339 28.438
R2588 VSS.n942 VSS.n941 28.0005
R2589 VSS.n941 VSS.n659 28.0005
R2590 VSS.t93 VSS.n479 27.7319
R2591 VSS.n1242 VSS.n144 27.616
R2592 VSS.n434 VSS.n184 27.2227
R2593 VSS.n569 VSS.n555 27.2227
R2594 VSS.n566 VSS.n557 27.2227
R2595 VSS.n973 VSS.n509 27.2227
R2596 VSS.n970 VSS.n88 27.2227
R2597 VSS.n456 VSS.n52 27.2227
R2598 VSS.n457 VSS.n105 27.2227
R2599 VSS.n1212 VSS.n183 27.2227
R2600 VSS.n639 VSS.n633 27.1255
R2601 VSS.n982 VSS.n504 27.1255
R2602 VSS.n1000 VSS.n485 27.1255
R2603 VSS.t253 VSS.t43 26.7501
R2604 VSS.n784 VSS.n775 25.8616
R2605 VSS.n737 VSS.n288 25.8616
R2606 VSS.n770 VSS.n767 25.8616
R2607 VSS.n631 VSS.n627 25.7644
R2608 VSS.n501 VSS.n95 25.7644
R2609 VSS.n490 VSS.n84 25.7644
R2610 VSS.n436 VSS.t76 25.7463
R2611 VSS.n931 VSS.n661 25.3205
R2612 VSS.n805 VSS.n794 25.3012
R2613 VSS.n836 VSS.n775 24.5005
R2614 VSS.n784 VSS.n776 24.5005
R2615 VSS.n939 VSS.n663 24.5005
R2616 VSS.n288 VSS.n286 24.5005
R2617 VSS.n741 VSS.n737 24.5005
R2618 VSS.n1244 VSS.n1243 24.2182
R2619 VSS.n727 VSS.n726 23.706
R2620 VSS.n734 VSS.n160 23.3338
R2621 VSS.n702 VSS.n697 23.1394
R2622 VSS.n486 VSS.n482 22.8477
R2623 VSS.n989 VSS.n499 22.8477
R2624 VSS.n646 VSS.n629 22.8477
R2625 VSS.n838 VSS.n769 22.7505
R2626 VSS.n834 VSS.n775 22.7505
R2627 VSS.n1157 VSS.n237 22.5762
R2628 VSS.n1135 VSS.n259 22.5691
R2629 VSS.n1041 VSS.n375 22.5691
R2630 VSS.n546 VSS.n545 22.5691
R2631 VSS.n340 VSS.n76 22.5691
R2632 VSS.n770 VSS.n718 21.9727
R2633 VSS.n1068 VSS.n309 21.0005
R2634 VSS.n744 VSS.n148 20.5537
R2635 VSS.n1173 VSS.t5 20.5052
R2636 VSS.n450 VSS.n429 20.5052
R2637 VSS.t117 VSS.t59 20.0217
R2638 VSS.t137 VSS.t41 20.0217
R2639 VSS.n998 VSS.t177 19.8948
R2640 VSS.n806 VSS.n805 19.8928
R2641 VSS.n1223 VSS.t155 19.1072
R2642 VSS.n653 VSS.n628 19.0561
R2643 VSS.n995 VSS.n994 19.0561
R2644 VSS.n1008 VSS.n1007 19.0561
R2645 VSS.n654 VSS.n626 19.0561
R2646 VSS.n1223 VSS.n169 18.7965
R2647 VSS.n487 VSS.n462 18.0862
R2648 VSS.n988 VSS.n987 18.0862
R2649 VSS.n645 VSS.n644 18.0862
R2650 VSS.n946 VSS.n945 18.0862
R2651 VSS.n1210 VSS.t155 18.0198
R2652 VSS.n1053 VSS.n1052 17.7242
R2653 VSS.n734 VSS.n280 17.6456
R2654 VSS.n1006 VSS.n1005 17.4833
R2655 VSS.n993 VSS.n991 17.4833
R2656 VSS.n652 VSS.n649 17.4833
R2657 VSS.n656 VSS.n655 17.4833
R2658 VSS.t121 VSS.t119 16.0831
R2659 VSS.n1221 VSS.n1220 15.2971
R2660 VSS.n890 VSS.n667 15.1353
R2661 VSS.n1169 VSS.n224 15.0719
R2662 VSS.n980 VSS.t88 15.0719
R2663 VSS.n460 VSS.n383 14.9197
R2664 VSS.n561 VSS.n560 14.9197
R2665 VSS.n614 VSS.n613 14.9197
R2666 VSS.n891 VSS.n699 14.7783
R2667 VSS.n856 VSS.n849 14.7783
R2668 VSS.n446 VSS.n438 14.6024
R2669 VSS.n1132 VSS.n265 14.5838
R2670 VSS.n1044 VSS.n373 14.5838
R2671 VSS.n591 VSS.n534 14.5838
R2672 VSS.n1160 VSS.n24 14.5838
R2673 VSS.n348 VSS.n347 14.5838
R2674 VSS.n563 VSS.n562 14.3894
R2675 VSS.n558 VSS.t87 14.3617
R2676 VSS.n967 VSS.t63 14.3617
R2677 VSS.n1189 VSS.n1188 13.478
R2678 VSS.n870 VSS.n709 13.003
R2679 VSS.n1006 VSS.t82 12.6605
R2680 VSS.n1135 VSS.n260 12.1533
R2681 VSS.n1041 VSS.n376 12.1533
R2682 VSS.n545 VSS.n529 12.1533
R2683 VSS.n1157 VSS.n236 12.1533
R2684 VSS.n340 VSS.n331 12.1533
R2685 VSS.n577 VSS.n552 12.1514
R2686 VSS.n554 VSS.n552 12.1514
R2687 VSS.n429 VSS.t75 11.9616
R2688 VSS.n300 VSS.n299 11.8335
R2689 VSS.n1084 VSS.n44 11.8335
R2690 VSS.n1082 VSS.n299 11.7885
R2691 VSS.n1084 VSS.n1083 11.7885
R2692 VSS.n441 VSS.n440 11.0838
R2693 VSS.n1217 VSS.n178 10.8894
R2694 VSS.n1019 VSS.n459 10.8894
R2695 VSS.n969 VSS.n968 10.8894
R2696 VSS.n315 VSS.n314 10.5999
R2697 VSS.n1056 VSS.n328 10.4305
R2698 VSS.n450 VSS.n438 10.4082
R2699 VSS.n821 VSS.n769 10.3449
R2700 VSS.n642 VSS.n631 9.13939
R2701 VSS.n985 VSS.n501 9.13939
R2702 VSS.n490 VSS.n489 9.13939
R2703 VSS.n1009 VSS.n1008 9.13939
R2704 VSS.n996 VSS.n995 9.13939
R2705 VSS.n650 VSS.n628 9.13939
R2706 VSS.n636 VSS.n626 9.13939
R2707 VSS.n1099 VSS.n281 8.79754
R2708 VSS.n882 VSS.t190 8.78206
R2709 VSS.n626 VSS.n624 8.55606
R2710 VSS.n647 VSS.n628 8.55606
R2711 VSS.n995 VSS.n498 8.55606
R2712 VSS.n1008 VSS.n481 8.55606
R2713 VSS.t257 VSS.n506 8.44049
R2714 VSS.t21 VSS.n944 8.44049
R2715 VSS.n1184 VSS.n1183 8.26599
R2716 VSS.n1209 VSS.t113 7.76744
R2717 VSS.n1177 VSS.n1176 7.76744
R2718 VSS.t117 VSS.t192 7.22126
R2719 VSS.t41 VSS.t71 7.22126
R2720 VSS.n780 VSS.n779 7.13286
R2721 VSS.n744 VSS.n146 7.08484
R2722 VSS.n116 VSS.n49 5.13869
R2723 VSS.n280 VSS.n153 6.81994
R2724 VSS.n221 VSS.n186 6.80606
R2725 VSS.n937 VSS.n228 6.80606
R2726 VSS.n472 VSS.n164 6.70883
R2727 VSS.t205 VSS.t113 6.68007
R2728 VSS.n749 VSS.n146 6.57881
R2729 VSS.n1082 VSS.n1081 6.52797
R2730 VSS.n194 VSS.n190 6.51439
R2731 VSS.n1205 VSS.n189 6.51439
R2732 VSS.n579 VSS.n578 6.51439
R2733 VSS.n576 VSS.n102 6.51439
R2734 VSS.n496 VSS.n495 6.51439
R2735 VSS.n492 VSS.n465 6.51439
R2736 VSS.n666 VSS.n617 6.51439
R2737 VSS.n936 VSS.n226 6.51439
R2738 VSS.t45 VSS.n1234 6.50804
R2739 VSS.n567 VSS.n558 6.2445
R2740 VSS.n967 VSS.n966 6.2445
R2741 VSS.n870 VSS.n106 6.22929
R2742 VSS.n1185 VSS.n1184 6.2105
R2743 VSS.n1186 VSS.n1185 6.2105
R2744 VSS.n108 VSS.n709 6.13361
R2745 VSS.n1081 VSS.n301 5.95929
R2746 VSS.n735 VSS.n153 5.4649
R2747 VSS.n1060 VSS.n110 5.45693
R2748 VSS.n1187 VSS.n1186 5.38925
R2749 VSS.n1186 VSS.n186 5.36289
R2750 VSS.t92 VSS.n228 5.36289
R2751 VSS.n58 VSS.n164 5.36093
R2752 VSS.n579 VSS.n550 5.35702
R2753 VSS.n1182 VSS.n189 5.35702
R2754 VSS.n1184 VSS.n194 5.35702
R2755 VSS.n465 VSS.n58 5.35702
R2756 VSS.n953 VSS.n617 5.35702
R2757 VSS.n496 VSS.t92 5.35702
R2758 VSS.t92 VSS.n226 5.35702
R2759 VSS.n583 VSS.n102 5.35702
R2760 VSS.n752 VSS.t2 5.29277
R2761 VSS.t129 VSS.n110 5.21753
R2762 VSS.n9 VSS.t233 5.55434
R2763 VSS.n625 VSS.n228 5.2005
R2764 VSS.n635 VSS.n226 5.2005
R2765 VSS.n930 VSS.n617 5.2005
R2766 VSS.n477 VSS.n164 5.2005
R2767 VSS.n476 VSS.n465 5.2005
R2768 VSS.n497 VSS.n496 5.2005
R2769 VSS.n399 VSS.n194 5.2005
R2770 VSS.n400 VSS.n186 5.2005
R2771 VSS.n1204 VSS.n1203 5.11161
R2772 VSS.n1203 VSS.n188 5.11161
R2773 VSS.t262 VSS.n1143 5.09387
R2774 VSS.n1047 VSS.n220 5.01115
R2775 VSS.n104 VSS.n102 4.98824
R2776 VSS.n587 VSS.n586 4.96811
R2777 VSS.t250 VSS.n846 4.6657
R2778 VSS.n822 VSS.t243 4.6657
R2779 VSS.n828 VSS.t106 4.6657
R2780 VSS.n580 VSS.n579 4.63554
R2781 VSS.n192 VSS.n189 4.63554
R2782 VSS.n96 VSS.t261 4.86282
R2783 VSS.n61 VSS.n1062 4.7384
R2784 VSS.t115 VSS.n845 4.52849
R2785 VSS.n826 VSS.t246 4.52849
R2786 VSS.n829 VSS.t248 4.52849
R2787 VSS.t207 VSS.n172 4.5142
R2788 VSS.n1031 VSS.t239 4.5142
R2789 VSS.n117 VSS.n1190 4.50592
R2790 VSS.t92 VSS.n227 4.47115
R2791 VSS.n955 VSS.n615 4.37149
R2792 VSS.n292 VSS.t77 4.3241
R2793 VSS.t240 VSS.n144 4.2633
R2794 VSS.n1236 VSS.t240 4.2633
R2795 VSS.n1189 VSS.n217 4.163
R2796 VSS.n1185 VSS.n1179 4.13854
R2797 VSS.n1208 VSS.n181 4.05496
R2798 VSS.n1104 VSS.n1102 3.99333
R2799 VSS.n317 VSS.n310 3.9891
R2800 VSS.n1031 VSS.n371 3.93574
R2801 VSS.n711 VSS.n301 3.83984
R2802 VSS.t149 VSS.n279 3.7807
R2803 VSS.n1176 VSS.n1173 3.72863
R2804 VSS.n584 VSS.n549 3.71007
R2805 VSS.n853 VSS.n851 3.7099
R2806 VSS.n802 VSS.n779 3.70362
R2807 VSS.n115 VSS.n573 3.64321
R2808 VSS.n1014 VSS.n463 3.61764
R2809 VSS.n471 VSS.n468 3.60498
R2810 VSS.n1016 VSS.n1015 3.58374
R2811 VSS.n446 VSS.t5 3.57329
R2812 VSS.n934 VSS.n663 3.52605
R2813 VSS.n935 VSS.n934 3.52605
R2814 VSS.n432 VSS.n173 3.3645
R2815 VSS.n992 VSS.n365 3.2505
R2816 VSS.t206 VSS.n436 3.17398
R2817 VSS.n319 VSS.n57 3.0983
R2818 VSS.n1005 VSS.t11 3.01478
R2819 VSS.t103 VSS.n487 3.01478
R2820 VSS.n991 VSS.t101 3.01478
R2821 VSS.n988 VSS.t259 3.01478
R2822 VSS.n649 VSS.t134 3.01478
R2823 VSS.n645 VSS.t15 3.01478
R2824 VSS.n656 VSS.t257 3.01478
R2825 VSS.n946 VSS.t133 3.01478
R2826 VSS.t147 VSS.t80 2.9774
R2827 VSS.n1167 VSS.t92 2.97438
R2828 VSS.t75 VSS.t4 2.95194
R2829 VSS.n688 VSS.n676 2.84528
R2830 VSS.t129 VSS.n911 2.84528
R2831 VSS.n1058 VSS.n67 2.83698
R2832 VSS.n1250 VSS 2.80436
R2833 VSS.n435 VSS.n185 2.78854
R2834 VSS.n884 VSS.t220 2.7273
R2835 VSS.n866 VSS.n707 2.65567
R2836 VSS.t223 VSS.n138 2.65387
R2837 VSS.n20 VSS.n112 2.65348
R2838 VSS.n67 VSS.n112 2.6429
R2839 VSS.n49 VSS.n48 54.8907
R2840 VSS.n1135 VSS.n1134 2.6005
R2841 VSS.n1136 VSS.n1135 2.6005
R2842 VSS.n1158 VSS.n1157 2.6005
R2843 VSS.n1157 VSS.t110 2.6005
R2844 VSS.n447 VSS.n446 2.6005
R2845 VSS.n447 VSS.n171 2.6005
R2846 VSS.n1042 VSS.n1041 2.6005
R2847 VSS.n1041 VSS.n1040 2.6005
R2848 VSS.n545 VSS.n533 2.6005
R2849 VSS.n545 VSS.t110 2.6005
R2850 VSS.n344 VSS.n340 2.6005
R2851 VSS.n81 VSS.n340 2.6005
R2852 VSS.n72 VSS.n955 2.58849
R2853 VSS.n1083 VSS.t233 2.53645
R2854 VSS.t129 VSS.n33 0.529502
R2855 VSS.t19 VSS.n884 2.51215
R2856 VSS.t25 VSS.t149 2.50488
R2857 VSS.n470 VSS.t92 2.50043
R2858 VSS.n1013 VSS.n467 2.49651
R2859 VSS.n618 VSS.n620 2.49651
R2860 VSS.n1202 VSS.t151 2.49456
R2861 VSS.t108 VSS.n103 2.49456
R2862 VSS.n1012 VSS.n58 2.49115
R2863 VSS.n1059 VSS.n1058 2.38301
R2864 VSS.t260 VSS.t68 2.38108
R2865 VSS.n1047 VSS.n1046 2.32485
R2866 VSS.n1046 VSS.n1045 2.32485
R2867 VSS.n423 VSS.n388 2.29134
R2868 VSS.n211 VSS.n208 2.29134
R2869 VSS.n1123 VSS.n273 2.27985
R2870 VSS.n94 VSS.n165 2.27985
R2871 VSS.n56 VSS.n229 2.27985
R2872 VSS.n362 VSS.n338 2.27985
R2873 VSS.n1226 VSS.n172 2.23079
R2874 VSS.t40 VSS.t23 2.15049
R2875 VSS.n426 VSS.n165 2.1468
R2876 VSS.n319 VSS.n1061 2.12135
R2877 VSS.n586 VSS.n11 2.1155
R2878 VSS.n251 VSS.n248 2.1005
R2879 VSS.n1112 VSS.n1111 2.1005
R2880 VSS.n1112 VSS.n250 2.1005
R2881 VSS.n1129 VSS.n268 2.1005
R2882 VSS.n269 VSS.n267 2.1005
R2883 VSS.n1108 VSS.n267 2.1005
R2884 VSS.n99 VSS.n512 2.1005
R2885 VSS.t144 VSS.n82 2.1005
R2886 VSS.n442 VSS.n425 2.1005
R2887 VSS.n416 VSS.n396 2.1005
R2888 VSS.n1195 VSS.n1194 2.1005
R2889 VSS.n1195 VSS.n204 2.1005
R2890 VSS.n416 VSS.n415 2.1005
R2891 VSS.n403 VSS.n218 2.1005
R2892 VSS.n414 VSS.n218 2.1005
R2893 VSS.n406 VSS.n402 2.1005
R2894 VSS.n355 VSS.n68 2.1005
R2895 VSS.n74 VSS.t83 0.00176191
R2896 VSS.n350 VSS.n67 2.1005
R2897 VSS.t45 VSS.n155 2.05758
R2898 VSS.n1177 VSS.t205 2.01991
R2899 VSS.t67 VSS.t260 1.99453
R2900 VSS.t144 VSS.n458 1.97647
R2901 VSS.n180 VSS.t125 1.97545
R2902 VSS.n1247 VSS.t223 1.96288
R2903 VSS.n1247 VSS.t67 1.96288
R2904 VSS.t145 VSS.t40 1.96148
R2905 VSS VSS.n1250 1.95625
R2906 VSS.n1225 VSS.n173 1.9525
R2907 VSS.n1045 VSS.n371 1.9492
R2908 VSS.n56 VSS.n1166 1.94851
R2909 VSS.n156 VSS.n155 1.94542
R2910 VSS.n20 VSS.n1148 1.94247
R2911 VSS.n1123 VSS.n1122 1.93906
R2912 VSS.n362 VSS.n361 1.93906
R2913 VSS.n688 VSS.n687 1.91007
R2914 VSS.n1156 VSS.n16 0.978935
R2915 VSS.t207 VSS.t206 1.91007
R2916 VSS.t239 VSS.t237 1.91007
R2917 VSS.n121 VSS.n379 1.91007
R2918 VSS.n607 VSS.n606 1.91007
R2919 VSS.n911 VSS.n901 1.91007
R2920 VSS.n764 VSS.n763 1.86697
R2921 VSS.n572 VSS.n551 1.8592
R2922 VSS.n1181 VSS.n1180 1.8592
R2923 VSS.n954 VSS.n616 1.8592
R2924 VSS.t3 VSS.n289 1.85413
R2925 VSS.n386 VSS.n215 1.81114
R2926 VSS.n992 VSS.n497 1.80907
R2927 VSS.n635 VSS.n625 1.80907
R2928 VSS.t116 VSS.n841 1.7649
R2929 VSS.n913 VSS.n327 1.75716
R2930 VSS.n564 VSS.t110 0.759406
R2931 VSS.n956 VSS.n73 0.611722
R2932 VSS.n1039 VSS.n1032 1.72777
R2933 VSS.n274 VSS.n125 1.65572
R2934 VSS.n128 VSS.n127 1.65572
R2935 VSS.n427 VSS.n166 1.65572
R2936 VSS.n1046 VSS.n370 1.65572
R2937 VSS.n548 VSS.n543 1.65572
R2938 VSS.n132 VSS.n130 1.65572
R2939 VSS.t2 VSS.t145 1.65434
R2940 VSS.n543 VSS.n23 1.64934
R2941 VSS.n1248 VSS.t68 1.618
R2942 VSS.n1234 VSS.n57 1.61082
R2943 VSS.n761 VSS.t45 1.61039
R2944 VSS.n815 VSS.n814 1.59522
R2945 VSS.n816 VSS.n815 1.59522
R2946 VSS.n817 VSS.n816 1.59522
R2947 VSS.n817 VSS.n781 1.59522
R2948 VSS.n796 VSS.n790 1.59522
R2949 VSS.n796 VSS.n789 1.59522
R2950 VSS.n800 VSS.n789 1.59522
R2951 VSS.n801 VSS.n800 1.59522
R2952 VSS.n802 VSS.n801 1.59522
R2953 VSS.t224 VSS.n1248 1.583
R2954 VSS.t44 VSS.t72 1.55444
R2955 VSS.t120 VSS.t193 1.55444
R2956 VSS.n703 VSS.n33 1.03329
R2957 VSS.t183 VSS.n100 1.55294
R2958 VSS.t193 VSS.n683 1.53868
R2959 VSS.n912 VSS.t72 1.53868
R2960 VSS.t144 VSS.n121 1.52463
R2961 VSS.n606 VSS.t204 1.60358
R2962 VSS.n16 VSS.n559 1.24829
R2963 VSS.n111 VSS.n100 1.52003
R2964 VSS.n1061 VSS.n1060 1.48653
R2965 VSS.n761 VSS.n760 1.47253
R2966 VSS.n258 VSS.n257 1.46668
R2967 VSS.n79 VSS.n67 0.0395377
R2968 VSS.t108 VSS.n581 1.46531
R2969 VSS.t151 VSS.n193 1.46531
R2970 VSS.n467 VSS.n466 1.46531
R2971 VSS.n933 VSS.n618 1.46531
R2972 VSS.n583 VSS.n582 1.45629
R2973 VSS.n1189 VSS.n109 1.44446
R2974 VSS.n433 VSS.t76 1.43723
R2975 VSS.n1248 VSS.n1247 1.42876
R2976 VSS.t150 VSS.t154 1.41807
R2977 VSS.n1070 VSS.n312 1.39496
R2978 VSS.t45 VSS.n163 1.38303
R2979 VSS.n1190 VSS.n1189 1.37869
R2980 VSS.t144 VSS.n109 1.4109
R2981 VSS.n1148 VSS.t262 1.36985
R2982 VSS.n1190 VSS.n195 1.35198
R2983 VSS.n827 VSS.n776 1.3005
R2984 VSS.n776 VSS.t39 1.3005
R2985 VSS.n836 VSS.t38 1.3005
R2986 VSS.n93 VSS.n836 1.3005
R2987 VSS.n1095 VSS.n286 1.3005
R2988 VSS.t79 VSS.n286 1.3005
R2989 VSS.n742 VSS.n741 1.3005
R2990 VSS.n741 VSS.n740 1.3005
R2991 VSS.n944 VSS.n943 1.3005
R2992 VSS.n943 VSS.n621 1.3005
R2993 VSS.n941 VSS.n940 1.3005
R2994 VSS.n941 VSS.t100 1.3005
R2995 VSS.n661 VSS.n660 1.3005
R2996 VSS.n660 VSS.t14 1.3005
R2997 VSS.n1010 VSS.n1009 1.3005
R2998 VSS.n1009 VSS.t92 1.3005
R2999 VSS.n997 VSS.n996 1.3005
R3000 VSS.n996 VSS.t92 1.3005
R3001 VSS.n651 VSS.n650 1.3005
R3002 VSS.n650 VSS.t92 1.3005
R3003 VSS.n637 VSS.n636 1.3005
R3004 VSS.n636 VSS.t92 1.3005
R3005 VSS.n435 VSS.n434 1.29841
R3006 VSS.n551 VSS.n549 1.28007
R3007 VSS.n1235 VSS.n6 0.770072
R3008 VSS.n6 VSS.t157 0.123846
R3009 VSS.n292 VSS.t24 1.25269
R3010 VSS.n4 VSS.n157 1.24523
R3011 VSS.n94 VSS.n1233 1.23436
R3012 VSS.n80 VSS.t33 0.267165
R3013 VSS.t129 VSS.n87 1.22528
R3014 VSS.t19 VSS.n852 1.22528
R3015 VSS.t144 VSS.n427 1.21354
R3016 VSS.n477 VSS.n476 1.20621
R3017 VSS.t65 VSS.t82 1.20621
R3018 VSS.t129 VSS.n922 0.927619
R3019 VSS.t92 VSS.n69 0.138156
R3020 VSS.t231 VSS.t204 0.384738
R3021 VSS.n917 VSS.t142 1.17273
R3022 VSS.n1034 VSS.n220 1.17129
R3023 VSS.n588 VSS.n587 1.1692
R3024 VSS.n1117 VSS.n1116 1.16717
R3025 VSS.n444 VSS.n443 1.16717
R3026 VSS.n401 VSS.n397 1.16717
R3027 VSS.n12 VSS.n537 1.16717
R3028 VSS.n517 VSS.n97 1.16717
R3029 VSS.n65 VSS.n336 1.16717
R3030 VSS.n68 VSS.n362 1.16276
R3031 VSS.n1240 VSS.t179 1.15906
R3032 VSS.t45 VSS.t148 1.15906
R3033 VSS.n185 VSS.n182 1.15485
R3034 VSS.n1032 VSS.n379 1.14577
R3035 VSS.n683 VSS.t60 1.12959
R3036 VSS.t138 VSS.n912 1.12959
R3037 VSS.n13 VSS.n568 0.365289
R3038 VSS.n1104 VSS.t150 1.11093
R3039 VSS.n892 VSS.n28 1.10593
R3040 VSS.n857 VSS.n85 1.10593
R3041 VSS.n1147 VSS.n1146 1.10231
R3042 VSS.n1167 VSS.n113 1.08737
R3043 VSS.n252 VSS.t152 1.07971
R3044 VSS.n1128 VSS.t215 1.07971
R3045 VSS.t26 VSS.n1106 1.07971
R3046 VSS.t110 VSS.n27 1.60214
R3047 VSS.t31 VSS.n513 1.07971
R3048 VSS.t234 VSS.n454 1.07971
R3049 VSS.n413 VSS.t111 1.07971
R3050 VSS.n405 VSS.t201 1.07971
R3051 VSS.n395 VSS.t255 1.07971
R3052 VSS.n354 VSS.t52 1.07971
R3053 VSS.n207 VSS.t47 1.07971
R3054 VSS.n83 VSS.t60 1.07852
R3055 VSS.n913 VSS.t138 1.07852
R3056 VSS.n119 VSS.n892 1.06949
R3057 VSS.n62 VSS.n85 1.06949
R3058 VSS.n1226 VSS.n1225 1.0665
R3059 VSS.n1122 VSS.n274 1.05911
R3060 VSS.n283 VSS.n274 1.05911
R3061 VSS.n283 VSS.n258 1.05911
R3062 VSS.t110 VSS.n238 1.57559
R3063 VSS.n238 VSS.n127 1.05911
R3064 VSS.n1166 VSS.n127 1.05911
R3065 VSS.n1228 VSS.n1227 1.05911
R3066 VSS.n1228 VSS.n166 1.05911
R3067 VSS.n1233 VSS.n166 1.05911
R3068 VSS.n1034 VSS.n370 1.05911
R3069 VSS.n1038 VSS.n370 1.05911
R3070 VSS.n1039 VSS.n1038 1.05911
R3071 VSS.n588 VSS.n548 1.05911
R3072 VSS.n548 VSS.n53 1.05911
R3073 VSS.n361 VSS.n130 1.05911
R3074 VSS.n357 VSS.n130 1.05911
R3075 VSS.n1249 VSS.t224 1.0476
R3076 VSS.n841 VSS.n768 1.0449
R3077 VSS.n845 VSS.n844 1.0405
R3078 VSS.n844 VSS.n843 1.0405
R3079 VSS.n846 VSS.n90 1.0405
R3080 VSS.n91 VSS.n90 1.0405
R3081 VSS.n718 VSS.n717 1.0405
R3082 VSS.n719 VSS.n718 1.0405
R3083 VSS.n863 VSS.n862 1.0405
R3084 VSS.n862 VSS.n861 1.0405
R3085 VSS.n826 VSS.n825 1.0405
R3086 VSS.n825 VSS.t247 1.0405
R3087 VSS.n823 VSS.n822 1.0405
R3088 VSS.n92 VSS.n823 1.0405
R3089 VSS.n772 VSS.n771 1.0405
R3090 VSS.n773 VSS.n772 1.0405
R3091 VSS.n839 VSS.n838 1.0405
R3092 VSS.n838 VSS.n837 1.0405
R3093 VSS.n830 VSS.n829 1.0405
R3094 VSS.n831 VSS.n830 1.0405
R3095 VSS.n828 VSS.n785 1.0405
R3096 VSS.n785 VSS.n783 1.0405
R3097 VSS.n778 VSS.n777 1.0405
R3098 VSS.n832 VSS.n778 1.0405
R3099 VSS.n835 VSS.n834 1.0405
R3100 VSS.n834 VSS.n833 1.0405
R3101 VSS.n813 VSS.n724 1.0405
R3102 VSS.n812 VSS.n811 1.0405
R3103 VSS.n1092 VSS.n1091 1.0405
R3104 VSS.n1089 VSS.n8 1.0405
R3105 VSS.n295 VSS.n294 1.0405
R3106 VSS.n1088 VSS.n1087 1.0405
R3107 VSS.n84 VSS.n462 1.0405
R3108 VSS.n1007 VSS.n1006 1.0405
R3109 VSS.n1005 VSS.n1004 1.0405
R3110 VSS.n1004 VSS.n1003 1.0405
R3111 VSS.n487 VSS.n482 1.0405
R3112 VSS.n1002 VSS.n482 1.0405
R3113 VSS.n987 VSS.n95 1.0405
R3114 VSS.n994 VSS.n993 1.0405
R3115 VSS.n991 VSS.n990 1.0405
R3116 VSS.n990 VSS.n483 1.0405
R3117 VSS.n989 VSS.n988 1.0405
R3118 VSS.n989 VSS.n500 1.0405
R3119 VSS.n644 VSS.n627 1.0405
R3120 VSS.n627 VSS.t92 1.00072
R3121 VSS.n653 VSS.n652 1.0405
R3122 VSS.n649 VSS.n648 1.0405
R3123 VSS.n648 VSS.n502 1.0405
R3124 VSS.n646 VSS.n645 1.0405
R3125 VSS.n646 VSS.n630 1.0405
R3126 VSS.n945 VSS.n55 1.0405
R3127 VSS.n655 VSS.n654 1.0405
R3128 VSS.n657 VSS.n656 1.0405
R3129 VSS.n657 VSS.n623 1.0405
R3130 VSS.n947 VSS.n946 1.0405
R3131 VSS.n948 VSS.n947 1.0405
R3132 VSS.n567 VSS.n566 1.0405
R3133 VSS.n570 VSS.n569 1.0405
R3134 VSS.n13 VSS.t196 0.446342
R3135 VSS.n963 VSS.n962 1.0405
R3136 VSS.n54 VSS.n961 1.0405
R3137 VSS.n966 VSS.n88 1.0405
R3138 VSS.t204 VSS.n88 1.0405
R3139 VSS.n475 VSS.n52 1.0405
R3140 VSS.t144 VSS.n45 0.599995
R3141 VSS.n455 VSS.n105 1.0405
R3142 VSS.n434 VSS.t5 1.0405
R3143 VSS.n1211 VSS.n1210 1.0405
R3144 VSS.n1211 VSS.n185 1.0405
R3145 VSS.n433 VSS.n429 1.0405
R3146 VSS.t5 VSS.n183 1.0405
R3147 VSS.n213 VSS.n183 1.0405
R3148 VSS.n1023 VSS.t144 1.0405
R3149 VSS.t174 VSS.n45 0.482235
R3150 VSS.n972 VSS.t225 1.0405
R3151 VSS.n972 VSS.n511 1.0405
R3152 VSS.n973 VSS.n507 1.0405
R3153 VSS.n974 VSS.n973 1.0405
R3154 VSS.t225 VSS.n971 1.0405
R3155 VSS.n971 VSS.n71 1.0405
R3156 VSS.n594 VSS.n89 1.0405
R3157 VSS.n1150 VSS.n1149 1.0405
R3158 VSS.n467 VSS.n60 0.338176
R3159 VSS.t92 VSS.t12 0.0874264
R3160 VSS.n949 VSS.n622 1.03043
R3161 VSS.t62 VSS.t61 1.02629
R3162 VSS.t118 VSS.t120 1.02629
R3163 VSS.t97 VSS.t95 1.02629
R3164 VSS.t42 VSS.t44 1.02629
R3165 VSS.t132 VSS.t131 1.02629
R3166 VSS.n953 VSS.t22 1.0156
R3167 VSS.n301 VSS.n300 1.01325
R3168 VSS.n294 VSS.n293 1.00079
R3169 VSS.n1088 VSS.n293 1.00079
R3170 VSS.n1091 VSS.n1090 1.00072
R3171 VSS.n1090 VSS.n1089 1.00072
R3172 VSS.n163 VSS.n162 0.999175
R3173 VSS.n1136 VSS.n258 0.9905
R3174 VSS.n1227 VSS.n171 0.9905
R3175 VSS.n1040 VSS.n1039 0.9905
R3176 VSS.t110 VSS.n53 1.57553
R3177 VSS.n357 VSS.n79 1.63639
R3178 VSS.n108 VSS.n106 0.9905
R3179 VSS.n300 VSS.n44 0.9905
R3180 VSS.t233 VSS.n44 0.9905
R3181 VSS.n801 VSS.n781 0.9905
R3182 VSS.n816 VSS.n789 0.9905
R3183 VSS.n814 VSS.n790 0.9905
R3184 VSS.n759 VSS.t146 0.963719
R3185 VSS.n156 VSS.t178 0.963719
R3186 VSS.n738 VSS.n289 0.954896
R3187 VSS.t147 VSS.t24 0.945549
R3188 VSS.n67 VSS.n83 1.04615
R3189 VSS.t45 VSS.n4 0.92086
R3190 VSS.n687 VSS.n677 0.910283
R3191 VSS.t110 VSS.n16 0.319977
R3192 VSS.n607 VSS.n603 0.910283
R3193 VSS.n905 VSS.n901 0.910283
R3194 VSS.n404 VSS.n216 0.906844
R3195 VSS.n1072 VSS.n1071 0.883687
R3196 VSS.n1099 VSS.n1098 0.878216
R3197 VSS.n122 VSS.n424 0.87556
R3198 VSS.n1191 VSS.n117 0.87556
R3199 VSS.n754 VSS.n5 0.870203
R3200 VSS.n747 VSS.n147 0.870203
R3201 VSS.n1105 VSS.n1104 0.867167
R3202 VSS.n1105 VSS.n248 0.867167
R3203 VSS.n1117 VSS.n277 0.867167
R3204 VSS.n1117 VSS.n268 0.867167
R3205 VSS.n1113 VSS.n143 0.867167
R3206 VSS.n1113 VSS.n1112 0.867167
R3207 VSS.n278 VSS.n142 0.867167
R3208 VSS.n278 VSS.n267 0.867167
R3209 VSS.n78 VSS.n1053 0.867167
R3210 VSS.n67 VSS.n78 0.867167
R3211 VSS.n65 VSS.n333 0.867167
R3212 VSS.n68 VSS.n65 0.867167
R3213 VSS.n12 VSS.n590 0.867167
R3214 VSS.t110 VSS.n12 0.867167
R3215 VSS.n17 VSS.n965 0.867167
R3216 VSS.t110 VSS.n17 0.867167
R3217 VSS.n520 VSS.n15 0.867167
R3218 VSS.t110 VSS.n15 0.867167
R3219 VSS.n97 VSS.n232 0.867167
R3220 VSS.n99 VSS.n97 0.867167
R3221 VSS.t144 VSS.n36 0.867167
R3222 VSS.n211 VSS.n210 0.867167
R3223 VSS.n1197 VSS.n1196 0.867167
R3224 VSS.n1196 VSS.n1195 0.867167
R3225 VSS.n443 VSS.n442 0.867167
R3226 VSS.n402 VSS.n401 0.867167
R3227 VSS.n423 VSS.n422 0.867167
R3228 VSS.n417 VSS.n374 0.867167
R3229 VSS.n417 VSS.n416 0.867167
R3230 VSS.n390 VSS.n389 0.867167
R3231 VSS.n390 VSS.n218 0.867167
R3232 VSS.n19 VSS.n602 0.867167
R3233 VSS.t110 VSS.n19 0.867167
R3234 VSS.n601 VSS.n600 0.867167
R3235 VSS.n600 VSS.t110 0.867167
R3236 VSS.n22 VSS.n532 0.867167
R3237 VSS.t110 VSS.n22 0.867167
R3238 VSS.n597 VSS.n596 0.867167
R3239 VSS.n597 VSS.t110 0.867167
R3240 VSS.n342 VSS.n335 0.867167
R3241 VSS.n342 VSS.n67 0.867167
R3242 VSS.n66 VSS.n334 0.867167
R3243 VSS.n68 VSS.n66 0.867167
R3244 VSS.n1124 VSS.n1123 0.865091
R3245 VSS.n813 VSS.n812 0.863336
R3246 VSS.n1180 VSS.n1179 0.851587
R3247 VSS.n1192 VSS.n172 0.848345
R3248 VSS.t33 VSS.t34 0.842184
R3249 VSS.n925 VSS.n924 0.837071
R3250 VSS.n885 VSS.n708 0.837071
R3251 VSS.n480 VSS.n114 0.808192
R3252 VSS.n73 VSS.n72 0.925143
R3253 VSS.n1216 VSS.n1215 0.784334
R3254 VSS.n273 VSS.n272 0.782971
R3255 VSS.n98 VSS.n229 0.782971
R3256 VSS.n129 VSS.n338 0.782971
R3257 VSS.t23 VSS.n285 0.780165
R3258 VSS.n40 VSS.n473 0.778287
R3259 VSS.t34 VSS.n873 0.777665
R3260 VSS.n975 VSS.n71 0.772032
R3261 VSS.n1149 VSS.t110 1.05386
R3262 VSS.n860 VSS.n859 0.743357
R3263 VSS.n859 VSS.n858 0.743357
R3264 VSS.n933 VSS.n932 0.743357
R3265 VSS.n998 VSS.n466 0.743357
R3266 VSS.n32 VSS.t160 0.743357
R3267 VSS.t129 VSS.n32 0.743357
R3268 VSS.n760 VSS.n759 0.741856
R3269 VSS.n107 VSS.n710 0.739455
R3270 VSS.n763 VSS.n729 0.732913
R3271 VSS.t204 VSS.n69 0.403418
R3272 VSS.n264 VSS.n260 0.729667
R3273 VSS.n376 VSS.n372 0.729667
R3274 VSS.n531 VSS.n529 0.729667
R3275 VSS.n236 VSS.n233 0.729667
R3276 VSS.n343 VSS.n331 0.729667
R3277 VSS.t45 VSS.n0 0.727
R3278 VSS.n582 VSS.n550 0.725703
R3279 VSS.n1187 VSS.n219 0.723312
R3280 VSS.n128 VSS.t110 0.691544
R3281 VSS.n60 VSS.t92 0.127512
R3282 VSS.n193 VSS.n192 0.663078
R3283 VSS.n581 VSS.n580 0.663078
R3284 VSS.n1054 VSS.n67 0.759155
R3285 VSS.n101 VSS.n327 0.659983
R3286 VSS.n683 VSS.n676 0.655935
R3287 VSS.n912 VSS.t129 0.655935
R3288 VSS.n1183 VSS.n1182 0.646316
R3289 VSS.n573 VSS.t110 0.645768
R3290 VSS.t81 VSS.t45 0.626954
R3291 VSS.n1051 VSS.n1050 0.6249
R3292 VSS.n979 VSS.n506 0.6249
R3293 VSS.n1210 VSS.n1209 0.621856
R3294 VSS.n312 VSS.n43 0.62021
R3295 VSS.n1071 VSS.n1070 0.62021
R3296 VSS.n861 VSS.n111 0.608489
R3297 VSS.n955 VSS.n954 0.599054
R3298 VSS.n954 VSS.n953 0.599054
R3299 VSS.n1143 VSS.n247 0.596851
R3300 VSS.n321 VSS 0.596334
R3301 VSS.n1215 VSS.n181 0.596019
R3302 VSS.n711 VSS.t220 0.593966
R3303 VSS.n1216 VSS.n180 0.587532
R3304 VSS.n473 VSS.n458 0.586952
R3305 VSS.n40 VSS.t92 0.584073
R3306 VSS.t19 VSS.n64 0.580473
R3307 VSS.n865 VSS.n864 0.578278
R3308 VSS.n865 VSS.n86 0.578278
R3309 VSS.n707 VSS.n706 0.578278
R3310 VSS.n708 VSS.n707 0.578278
R3311 VSS.n886 VSS.n885 0.578278
R3312 VSS.t190 VSS.n64 0.578278
R3313 VSS.t191 VSS.n868 0.578278
R3314 VSS.n868 VSS.t19 0.578278
R3315 VSS.n63 VSS.t218 0.578278
R3316 VSS.t19 VSS.n63 0.578278
R3317 VSS.n752 VSS.n748 0.578278
R3318 VSS.n748 VSS.n747 0.578278
R3319 VSS.n752 VSS.n751 0.578278
R3320 VSS.n751 VSS.n147 0.578278
R3321 VSS.t147 VSS.n151 0.578278
R3322 VSS.n151 VSS.t131 0.578278
R3323 VSS.n1237 VSS.t147 0.578278
R3324 VSS.t132 VSS.n1237 0.578278
R3325 VSS.t147 VSS.n150 0.578278
R3326 VSS.t61 VSS.n150 0.578278
R3327 VSS.t147 VSS.n152 0.578278
R3328 VSS.n152 VSS.t62 0.578278
R3329 VSS.n753 VSS.n752 0.578278
R3330 VSS.n754 VSS.n753 0.578278
R3331 VSS.n752 VSS.n743 0.578278
R3332 VSS.n743 VSS.n5 0.578278
R3333 VSS.n30 VSS.n51 0.00144231
R3334 VSS.t129 VSS.n30 0.577893
R3335 VSS.n897 VSS.n896 0.578278
R3336 VSS.n896 VSS.t129 0.578278
R3337 VSS.n927 VSS.n926 0.578278
R3338 VSS.n926 VSS.n925 0.578278
R3339 VSS.n927 VSS.n669 0.578278
R3340 VSS.n924 VSS.n669 0.578278
R3341 VSS.n1064 VSS.n316 0.578278
R3342 VSS.n316 VSS.t33 0.578278
R3343 VSS.n1064 VSS.n1063 0.578278
R3344 VSS.n1063 VSS.t33 0.578278
R3345 VSS.n1075 VSS.n1074 0.578278
R3346 VSS.n1075 VSS.n308 0.578278
R3347 VSS.n1073 VSS.n308 0.578278
R3348 VSS.n684 VSS.t119 0.578278
R3349 VSS.t120 VSS.n684 0.578278
R3350 VSS.t117 VSS.n685 0.578278
R3351 VSS.n685 VSS.t118 0.578278
R3352 VSS.n689 VSS.t119 0.578278
R3353 VSS.n689 VSS.n688 0.578278
R3354 VSS.n686 VSS.t117 0.578278
R3355 VSS.n687 VSS.n686 0.578278
R3356 VSS.n904 VSS.t43 0.578278
R3357 VSS.t44 VSS.n904 0.578278
R3358 VSS.n906 VSS.t41 0.578278
R3359 VSS.n906 VSS.t42 0.578278
R3360 VSS.n910 VSS.t43 0.578278
R3361 VSS.n911 VSS.n910 0.578278
R3362 VSS.n908 VSS.t41 0.578278
R3363 VSS.n908 VSS.n901 0.578278
R3364 VSS.n1224 VSS.n1223 0.578278
R3365 VSS.n1225 VSS.n1224 0.578278
R3366 VSS.n1223 VSS.n1222 0.578278
R3367 VSS.n1222 VSS.n173 0.578278
R3368 VSS.n438 VSS.n437 0.578278
R3369 VSS.n437 VSS.t207 0.578278
R3370 VSS.n438 VSS.n430 0.578278
R3371 VSS.t206 VSS.n430 0.578278
R3372 VSS.t236 VSS.n1026 0.578278
R3373 VSS.n1026 VSS.t237 0.578278
R3374 VSS.n1030 VSS.t238 0.578278
R3375 VSS.t239 VSS.n1030 0.578278
R3376 VSS.n1027 VSS.t236 0.578278
R3377 VSS.n1027 VSS.n121 0.578278
R3378 VSS.t238 VSS.n1029 0.578278
R3379 VSS.n1029 VSS.n379 0.578278
R3380 VSS.n611 VSS.n525 0.578278
R3381 VSS.n611 VSS.t97 0.578278
R3382 VSS.n606 VSS.n527 0.578278
R3383 VSS.n610 VSS.n609 0.578278
R3384 VSS.t95 VSS.n610 0.578278
R3385 VSS.n608 VSS.n607 0.578278
R3386 VSS.n1154 VSS.n1153 0.578278
R3387 VSS.n1153 VSS.t166 0.578278
R3388 VSS.t110 VSS.n25 0.578278
R3389 VSS.n29 VSS.n895 0.578278
R3390 VSS.t129 VSS.n29 0.578278
R3391 VSS.n894 VSS.n893 0.578278
R3392 VSS.n1139 VSS.n1138 0.573227
R3393 VSS.n1127 VSS.n1126 0.573227
R3394 VSS.n1110 VSS.n1109 0.573227
R3395 VSS.n1141 VSS.n1140 0.573227
R3396 VSS.n125 VSS.n124 0.573227
R3397 VSS.n1107 VSS.n266 0.573227
R3398 VSS.n514 VSS.t204 0.573227
R3399 VSS.n128 VSS.n126 0.573227
R3400 VSS.t144 VSS.n37 0.573227
R3401 VSS.n453 VSS.n452 0.573227
R3402 VSS.n214 VSS.n205 0.573227
R3403 VSS.n451 VSS.n39 0.573227
R3404 VSS.n206 VSS.n1193 0.573227
R3405 VSS.n412 VSS.n216 0.573227
R3406 VSS.n394 VSS.n215 0.573227
R3407 VSS.n393 VSS.n387 0.573227
R3408 VSS.n408 VSS.n407 0.573227
R3409 VSS.n411 VSS.n410 0.573227
R3410 VSS.t169 VSS.t110 0.444
R3411 VSS.n353 VSS.n68 0.573227
R3412 VSS.n120 VSS.n356 0.573227
R3413 VSS.n424 VSS.n423 0.568693
R3414 VSS.n1191 VSS.n211 0.568693
R3415 VSS.n1095 VSS.t80 0.567529
R3416 VSS.t35 VSS.t33 0.558926
R3417 VSS.n1083 VSS.n1082 0.546434
R3418 VSS.n515 VSS.t110 2.29199
R3419 VSS.n712 VSS.n710 0.536801
R3420 VSS.n905 VSS.n327 0.534506
R3421 VSS.n861 VSS.n719 0.5325
R3422 VSS.n837 VSS.n773 0.5325
R3423 VSS.n833 VSS.n832 0.5325
R3424 VSS.n1087 VSS.n295 0.5325
R3425 VSS.n1003 VSS.n1002 0.5325
R3426 VSS.n500 VSS.n483 0.5325
R3427 VSS.n630 VSS.n502 0.5325
R3428 VSS.n948 VSS.n623 0.5325
R3429 VSS.t233 VSS.n43 0.530797
R3430 VSS.n951 VSS.n621 0.5305
R3431 VSS.t35 VSS.t233 0.524248
R3432 VSS.n616 VSS.n227 0.518978
R3433 VSS.n325 VSS.n324 0.517767
R3434 VSS.n1055 VSS.n1054 0.517741
R3435 VSS.n1187 VSS.n220 0.515192
R3436 VSS.n949 VSS.n948 0.510588
R3437 VSS.n402 VSS.n219 0.50901
R3438 VSS.t204 VSS.n71 0.505283
R3439 VSS.n1022 VSS.n45 0.310839
R3440 VSS.n892 VSS.t159 0.503907
R3441 VSS.n85 VSS.t183 0.503907
R3442 VSS.t10 VSS.n179 0.502582
R3443 VSS.n622 VSS.t14 0.501763
R3444 VSS.n1071 VSS.n43 0.50094
R3445 VSS.t263 VSS.n326 0.499656
R3446 VSS.n1061 VSS.t129 0.49535
R3447 VSS.t148 VSS.t146 0.491732
R3448 VSS.t179 VSS.t178 0.491732
R3449 VSS.n837 VSS.n768 0.48783
R3450 VSS.n842 VSS.t116 0.48525
R3451 VSS.n1001 VSS.n484 0.484075
R3452 VSS.n983 VSS.n503 0.484075
R3453 VSS.n640 VSS.n632 0.484075
R3454 VSS.n873 VSS.n106 0.483918
R3455 VSS.n80 VSS.n1073 0.75461
R3456 VSS.t116 VSS.n719 0.47983
R3457 VSS.n924 VSS.t129 0.478347
R3458 VSS.n326 VSS.n137 0.477635
R3459 VSS.t148 VSS.n755 0.476687
R3460 VSS.t179 VSS.n1239 0.476687
R3461 VSS.n1074 VSS.n80 0.683663
R3462 VSS.n854 VSS.n853 0.473227
R3463 VSS.n856 VSS.n855 0.473227
R3464 VSS.n857 VSS.n856 0.473227
R3465 VSS.n758 VSS.t80 0.473227
R3466 VSS.t81 VSS.n758 0.473227
R3467 VSS.n732 VSS.t80 0.473227
R3468 VSS.n732 VSS.n0 0.473227
R3469 VSS.n1169 VSS.n1168 0.473227
R3470 VSS.n1168 VSS.n1167 0.473227
R3471 VSS.n478 VSS.n114 0.473227
R3472 VSS.t12 VSS.n114 0.473227
R3473 VSS.n489 VSS.n488 0.473227
R3474 VSS.n489 VSS.n59 0.473227
R3475 VSS.n1000 VSS.n999 0.473227
R3476 VSS.t102 VSS.n1000 0.473227
R3477 VSS.n986 VSS.n985 0.473227
R3478 VSS.n985 VSS.n984 0.473227
R3479 VSS.n982 VSS.n981 0.473227
R3480 VSS.t135 VSS.n982 0.473227
R3481 VSS.n643 VSS.n642 0.473227
R3482 VSS.n642 VSS.n641 0.473227
R3483 VSS.n639 VSS.n638 0.473227
R3484 VSS.t258 VSS.n639 0.473227
R3485 VSS.t213 VSS.n891 0.473227
R3486 VSS.n891 VSS.n28 0.473227
R3487 VSS.n14 VSS.n571 0.473227
R3488 VSS.t110 VSS.n14 0.473227
R3489 VSS.n562 VSS.n558 0.473227
R3490 VSS.n562 VSS.t110 0.473227
R3491 VSS.n968 VSS.n967 0.473227
R3492 VSS.n978 VSS.n977 0.473227
R3493 VSS.n977 VSS.t229 0.473227
R3494 VSS.n1017 VSS.n41 0.473227
R3495 VSS.t144 VSS.n41 0.473227
R3496 VSS.n1218 VSS.n1217 0.473227
R3497 VSS.n1217 VSS.t10 0.473227
R3498 VSS.n1214 VSS.n1213 0.473227
R3499 VSS.t8 VSS.n1214 0.473227
R3500 VSS.n1019 VSS.n1018 0.473227
R3501 VSS.n739 VSS.t79 0.470856
R3502 VSS.t110 VSS.n23 0.470823
R3503 VSS.t61 VSS.t45 0.468397
R3504 VSS.t118 VSS.n677 0.468397
R3505 VSS.t95 VSS.n603 0.468397
R3506 VSS.t42 VSS.n905 0.468397
R3507 VSS.n746 VSS.t131 0.468397
R3508 VSS.n1001 VSS.n59 0.465754
R3509 VSS.n984 VSS.n983 0.465754
R3510 VSS.n641 VSS.n640 0.465754
R3511 VSS.n1073 VSS.n1072 0.46039
R3512 VSS.n1062 VSS.n320 0.45502
R3513 VSS.n760 VSS.n0 0.453551
R3514 VSS.t129 VSS.n28 0.447448
R3515 VSS.n1125 VSS.n268 0.446573
R3516 VSS.n893 VSS.n119 0.437643
R3517 VSS.n62 VSS.n86 0.437643
R3518 VSS.t62 VSS.t78 0.425354
R3519 VSS.t97 VSS.t231 0.425354
R3520 VSS.n1238 VSS.t132 0.425354
R3521 VSS.n925 VSS.n87 0.418786
R3522 VSS.n893 VSS.n87 0.418786
R3523 VSS.n852 VSS.n708 0.418786
R3524 VSS.n852 VSS.n86 0.418786
R3525 VSS.t45 VSS.n5 0.414856
R3526 VSS.n755 VSS.n754 0.414856
R3527 VSS.n747 VSS.n746 0.414856
R3528 VSS.n1239 VSS.n147 0.414856
R3529 VSS.n1062 VSS.t261 0.41346
R3530 VSS.n424 VSS.n387 0.407103
R3531 VSS.n782 VSS.n774 0.4055
R3532 VSS.n738 VSS.n290 0.4055
R3533 VSS.n320 VSS.t263 0.4005
R3534 VSS.n885 VSS.n108 0.399071
R3535 VSS.n712 VSS.n711 0.392709
R3536 VSS.n162 VSS.t157 0.385132
R3537 VSS.t249 VSS.n781 0.381468
R3538 VSS.n622 VSS.t100 0.37366
R3539 VSS.n952 VSS.t100 0.37366
R3540 VSS.n4 VSS.n156 0.367069
R3541 VSS.n1124 VSS.n271 0.365272
R3542 VSS.n473 VSS.t173 0.361489
R3543 VSS.n271 VSS.t171 0.347167
R3544 VSS.n262 VSS.n261 0.347167
R3545 VSS.n261 VSS.n255 0.347167
R3546 VSS.t16 VSS.n363 0.347167
R3547 VSS.n363 VSS.n68 0.347167
R3548 VSS.n541 VSS.t87 0.347167
R3549 VSS.n541 VSS.t110 0.347167
R3550 VSS.n18 VSS.n235 0.347167
R3551 VSS.t110 VSS.n18 0.347167
R3552 VSS.n516 VSS.t63 0.347167
R3553 VSS.n516 VSS.n99 0.347167
R3554 VSS.n445 VSS.n223 0.347167
R3555 VSS.n1176 VSS.n1175 0.347167
R3556 VSS.n1175 VSS.n1174 0.347167
R3557 VSS.t136 VSS.n398 0.347167
R3558 VSS.n398 VSS.n219 0.347167
R3559 VSS.n377 VSS.t105 0.347167
R3560 VSS.n378 VSS.n377 0.347167
R3561 VSS.n21 VSS.n544 0.347167
R3562 VSS.t110 VSS.n21 0.347167
R3563 VSS.n77 VSS.n75 0.347167
R3564 VSS.n759 VSS.t81 0.346772
R3565 VSS.n1174 VSS.n172 0.337093
R3566 VSS.n1031 VSS.n378 0.337093
R3567 VSS.t173 VSS.n123 0.0748742
R3568 VSS.n109 VSS.n117 0.324584
R3569 VSS.n722 VSS.n857 0.323326
R3570 VSS.t247 VSS.n93 0.321872
R3571 VSS.n722 VSS.t19 0.318341
R3572 VSS.t45 VSS.n3 0.316631
R3573 VSS.t144 VSS.n122 2.67931
R3574 VSS.n157 VSS.n3 0.300151
R3575 VSS.t10 VSS.n1216 0.290894
R3576 VSS.n1190 VSS.t76 0.288581
R3577 VSS.n408 VSS.n402 0.287122
R3578 VSS.n1096 VSS.n1095 0.284015
R3579 VSS.n1148 VSS.n1147 0.28175
R3580 VSS.t110 VSS.n20 0.28175
R3581 VSS.n1087 VSS.n9 0.347906
R3582 VSS.t142 VSS.n118 0.278582
R3583 VSS.t66 VSS.n134 0.274897
R3584 VSS.t222 VSS.n133 0.274897
R3585 VSS.n138 VSS.n133 0.274754
R3586 VSS.n840 VSS.t244 0.274184
R3587 VSS.n841 VSS.n840 0.274184
R3588 VSS.n820 VSS.n766 0.274184
R3589 VSS.n820 VSS.t245 0.274184
R3590 VSS.n723 VSS.n100 0.274184
R3591 VSS.n721 VSS.t187 0.274184
R3592 VSS.t186 VSS.n721 0.274184
R3593 VSS.n763 VSS.n762 0.274184
R3594 VSS.n762 VSS.n761 0.274184
R3595 VSS.n7 VSS.n279 0.274184
R3596 VSS.t45 VSS.n7 0.274184
R3597 VSS.n1095 VSS.n1094 0.274184
R3598 VSS.n1094 VSS.t3 0.274184
R3599 VSS.n742 VSS.n287 0.274184
R3600 VSS.n289 VSS.n287 0.274184
R3601 VSS.n134 VSS.t68 0.274184
R3602 VSS.n135 VSS.t67 0.274184
R3603 VSS.t223 VSS.n1246 0.274184
R3604 VSS.n31 VSS.n668 0.274184
R3605 VSS.t129 VSS.n31 0.274184
R3606 VSS.n922 VSS.n921 0.274184
R3607 VSS.n705 VSS.n704 0.274184
R3608 VSS.n704 VSS.t129 0.274184
R3609 VSS.n118 VSS.n916 0.274184
R3610 VSS.n918 VSS.n917 0.274184
R3611 VSS.n10 VSS.n565 0.274184
R3612 VSS.n957 VSS.n70 0.274184
R3613 VSS.t204 VSS.n70 0.274184
R3614 VSS.n1219 VSS.t124 0.274184
R3615 VSS.n1219 VSS.t125 0.274184
R3616 VSS.t124 VSS.n177 0.274184
R3617 VSS.n180 VSS.n177 0.274184
R3618 VSS.t143 VSS.n1021 0.274184
R3619 VSS.n1021 VSS.n458 0.274184
R3620 VSS.n38 VSS.t143 0.274184
R3621 VSS.t144 VSS.n38 0.274184
R3622 VSS.n1246 VSS.t222 0.27411
R3623 VSS.t66 VSS.n135 0.27411
R3624 VSS.n773 VSS.t247 0.274047
R3625 VSS.t45 VSS.n6 0.123846
R3626 VSS.n1174 VSS.n171 0.263577
R3627 VSS.n1040 VSS.n378 0.263577
R3628 VSS.n1032 VSS.n1031 0.263577
R3629 VSS.n93 VSS.n774 0.262588
R3630 VSS.n740 VSS.n739 0.262588
R3631 VSS.n740 VSS.n738 0.262588
R3632 VSS.n442 VSS.n426 0.258236
R3633 VSS.n432 VSS.n179 0.2565
R3634 VSS.n445 VSS.t144 0.434426
R3635 VSS.n1093 VSS.n290 0.254574
R3636 VSS.n442 VSS.t144 0.254198
R3637 VSS.t110 VSS.n11 0.253372
R3638 VSS.n1002 VSS.n1001 0.2485
R3639 VSS.n983 VSS.n500 0.2485
R3640 VSS.n640 VSS.n630 0.2485
R3641 VSS.n833 VSS.n774 0.2475
R3642 VSS.n1142 VSS.t209 0.246643
R3643 VSS.n1189 VSS.n215 0.246032
R3644 VSS.n61 VSS.t233 0.686686
R3645 VSS.n739 VSS.n295 0.240263
R3646 VSS.n832 VSS.n780 0.2395
R3647 VSS.n409 VSS.n408 0.238878
R3648 VSS.n410 VSS.n409 0.238878
R3649 VSS.n392 VSS.n387 0.238878
R3650 VSS.n619 VSS.t14 0.238797
R3651 VSS.n873 VSS.t233 0.238757
R3652 VSS.n1003 VSS.n113 0.2385
R3653 VSS.n484 VSS.n483 0.2385
R3654 VSS.n503 VSS.n502 0.2385
R3655 VSS.n632 VSS.n623 0.2385
R3656 VSS.n752 VSS.n742 0.236762
R3657 VSS.n494 VSS.n468 0.235575
R3658 VSS.t8 VSS.n182 0.223735
R3659 VSS.t73 VSS.n1120 0.217167
R3660 VSS.n1120 VSS.n273 0.217167
R3661 VSS.n1121 VSS.t73 0.217167
R3662 VSS.n1122 VSS.n1121 0.217167
R3663 VSS.n620 VSS.n658 0.217167
R3664 VSS.n470 VSS.n463 0.217167
R3665 VSS.n1014 VSS.n1013 0.217167
R3666 VSS.n284 VSS.n283 0.217167
R3667 VSS.n1133 VSS.n1132 0.217167
R3668 VSS.n1132 VSS.n1131 0.217167
R3669 VSS.n351 VSS.t122 0.217167
R3670 VSS.n351 VSS.n338 0.217167
R3671 VSS.n360 VSS.t122 0.217167
R3672 VSS.n361 VSS.n360 0.217167
R3673 VSS.t139 VSS.n538 0.217167
R3674 VSS.n586 VSS.n538 0.217167
R3675 VSS.t139 VSS.n589 0.217167
R3676 VSS.n589 VSS.n588 0.217167
R3677 VSS.n1165 VSS.n1164 0.217167
R3678 VSS.n1166 VSS.n1165 0.217167
R3679 VSS.n958 VSS.n238 0.217167
R3680 VSS.n450 VSS.n449 0.217167
R3681 VSS.n449 VSS.n165 0.217167
R3682 VSS.n1232 VSS.n1231 0.217167
R3683 VSS.n1233 VSS.n1232 0.217167
R3684 VSS.n1230 VSS.n1229 0.217167
R3685 VSS.n1229 VSS.n1228 0.217167
R3686 VSS.n35 VSS.n450 0.217167
R3687 VSS.t144 VSS.n35 0.217167
R3688 VSS.n1044 VSS.t252 0.217167
R3689 VSS.n1045 VSS.n1044 0.217167
R3690 VSS.t251 VSS.n1048 0.217167
R3691 VSS.n1048 VSS.n1047 0.217167
R3692 VSS.n1038 VSS.n1037 0.217167
R3693 VSS.n1035 VSS.n366 0.217167
R3694 VSS.n1035 VSS.n1034 0.217167
R3695 VSS.n1164 VSS.n1163 0.217167
R3696 VSS.n1163 VSS.n229 0.217167
R3697 VSS.n24 VSS.n1159 0.217167
R3698 VSS.n592 VSS.n591 0.217167
R3699 VSS.n53 VSS.n547 0.217167
R3700 VSS.n347 VSS.n346 0.217167
R3701 VSS.n347 VSS.n341 0.217167
R3702 VSS.n358 VSS.n357 0.217167
R3703 VSS.n1096 VSS.n285 0.213136
R3704 VSS.n543 VSS.n11 0.209848
R3705 VSS.n266 VSS.n254 0.206816
R3706 VSS.n1193 VSS.n34 0.206816
R3707 VSS.t144 VSS.n34 0.206816
R3708 VSS.n1071 VSS.n309 0.203688
R3709 VSS.t92 VSS.n56 0.203247
R3710 VSS.n984 VSS.t92 0.202172
R3711 VSS.n641 VSS.t92 0.202172
R3712 VSS.n974 VSS.n511 0.201797
R3713 VSS.n1097 VSS.n1096 0.2005
R3714 VSS.n1097 VSS.t45 0.2005
R3715 VSS.n1102 VSS.n1101 0.2005
R3716 VSS.n1101 VSS.n163 0.2005
R3717 VSS.n763 VSS.n282 0.2005
R3718 VSS.n282 VSS.n155 0.2005
R3719 VSS.t156 VSS.n1 0.2005
R3720 VSS.t45 VSS.n1 0.2005
R3721 VSS.t156 VSS.n1235 0.2005
R3722 VSS.n145 VSS.n144 0.2005
R3723 VSS.n157 VSS.n145 0.2005
R3724 VSS.n2 VSS.n1236 0.2005
R3725 VSS.t45 VSS.n2 0.2005
R3726 VSS.t65 VSS.n474 0.2005
R3727 VSS.n474 VSS.t144 0.2005
R3728 VSS.n1011 VSS.t65 0.2005
R3729 VSS.n1012 VSS.n1011 0.2005
R3730 VSS.n1066 VSS.n1065 0.2005
R3731 VSS.n1075 VSS.n309 0.2005
R3732 VSS.n679 VSS.t59 0.2005
R3733 VSS.n679 VSS.n83 0.2005
R3734 VSS.t59 VSS.n330 0.2005
R3735 VSS.n1054 VSS.n330 0.2005
R3736 VSS.t137 VSS.n692 0.2005
R3737 VSS.n101 VSS.n692 0.2005
R3738 VSS.t137 VSS.n914 0.2005
R3739 VSS.n914 VSS.n913 0.2005
R3740 VSS.n572 VSS.n550 0.197643
R3741 VSS.n573 VSS.n572 0.197643
R3742 VSS.n1192 VSS.n1191 0.189927
R3743 VSS.t229 VSS.n976 0.189799
R3744 VSS.n582 VSS.t108 0.189747
R3745 VSS.n1102 VSS.n279 0.18951
R3746 VSS.t77 VSS.t25 0.18951
R3747 VSS.n58 VSS.t144 0.187096
R3748 VSS.n410 VSS.n371 0.186581
R3749 VSS.n98 VSS.n128 0.183658
R3750 VSS.n452 VSS.t144 0.183236
R3751 VSS.n272 VSS.n125 0.182605
R3752 VSS.n132 VSS.n129 0.182605
R3753 VSS.n1137 VSS.n254 0.180237
R3754 VSS.n427 VSS.n426 0.178543
R3755 VSS.n535 VSS.n23 0.178372
R3756 VSS.n435 VSS.n432 0.176552
R3757 VSS.n1137 VSS.n1136 0.176
R3758 VSS.n824 VSS.n768 0.175137
R3759 VSS.n324 VSS.n137 0.173577
R3760 VSS.n324 VSS.n323 0.173577
R3761 VSS.n1072 VSS.t33 0.170912
R3762 VSS.n551 VSS.t108 0.170637
R3763 VSS.n214 VSS.n203 0.164212
R3764 VSS.n39 VSS.n203 0.164212
R3765 VSS.n1193 VSS.n1192 0.164184
R3766 VSS.n976 VSS.n975 0.16288
R3767 VSS.n132 VSS.n131 0.1555
R3768 VSS.n1130 VSS.n125 0.1555
R3769 VSS.n1138 VSS.n253 0.154447
R3770 VSS.n81 VSS.n120 0.154447
R3771 VSS.n92 VSS.n824 0.151824
R3772 VSS.t92 VSS.n59 0.149972
R3773 VSS.n256 VSS.n255 0.146353
R3774 VSS.t186 VSS.n720 0.145095
R3775 VSS.n763 VSS.n725 0.144944
R3776 VSS.t146 VSS.n725 0.144944
R3777 VSS.n763 VSS.n728 0.144944
R3778 VSS.n728 VSS.t178 0.144944
R3779 VSS.n756 VSS.n159 0.144944
R3780 VSS.n756 VSS.t45 0.144944
R3781 VSS.n1242 VSS.n1241 0.144944
R3782 VSS.n1241 VSS.t181 0.144944
R3783 VSS.n874 VSS.t35 0.144944
R3784 VSS.t34 VSS.n872 0.144944
R3785 VSS.n843 VSS.n842 0.144407
R3786 VSS.n323 VSS.n322 0.14331
R3787 VSS.n755 VSS.t78 0.140086
R3788 VSS.n1239 VSS.n1238 0.140086
R3789 VSS.n968 VSS.t204 0.500549
R3790 VSS.n123 VSS.n1019 0.504603
R3791 VSS.n575 VSS.n574 0.133833
R3792 VSS.n575 VSS.n549 0.133833
R3793 VSS.n780 VSS.t249 0.131609
R3794 VSS.n1182 VSS.n1181 0.126272
R3795 VSS.n1181 VSS.n181 0.126272
R3796 VSS.t3 VSS.n1093 0.125685
R3797 VSS.t263 VSS.n112 0.1255
R3798 VSS.n320 VSS.n319 0.1255
R3799 VSS.n1209 VSS.n1208 0.12431
R3800 VSS.n662 VSS.n510 0.124233
R3801 VSS.n123 VSS.t144 0.171973
R3802 VSS.n91 VSS.t186 0.121911
R3803 VSS.n1234 VSS.n58 0.121036
R3804 VSS.t79 VSS.n290 0.1205
R3805 VSS.n619 VSS.n952 0.1199
R3806 VSS.n814 VSS.n813 0.119374
R3807 VSS.n812 VSS.n790 0.119374
R3808 VSS.n1177 VSS.n187 0.118682
R3809 VSS.n212 VSS.n187 0.118682
R3810 VSS.n1178 VSS.n1177 0.118682
R3811 VSS.n1179 VSS.n1178 0.118682
R3812 VSS.n109 VSS.n214 0.118064
R3813 VSS.n58 VSS.n94 0.116245
R3814 VSS.n931 VSS.n615 0.116056
R3815 VSS.n511 VSS.t204 0.114842
R3816 VSS.n619 VSS.t92 0.114661
R3817 VSS.n976 VSS.n69 0.19745
R3818 VSS.n1143 VSS.n1142 0.111581
R3819 VSS.t1 VSS.n662 0.111138
R3820 VSS.t1 VSS.n939 0.111138
R3821 VSS.n939 VSS.n227 0.111138
R3822 VSS.n1057 VSS.t121 0.111138
R3823 VSS.n1058 VSS.n1057 0.111138
R3824 VSS.t121 VSS.n1056 0.111138
R3825 VSS.n1056 VSS.n1055 0.111138
R3826 VSS.n162 VSS.t78 0.109377
R3827 VSS.n591 VSS.t110 0.247845
R3828 VSS.t110 VSS.n24 0.247845
R3829 VSS.n677 VSS.n67 0.187547
R3830 VSS.n603 VSS.t110 0.253931
R3831 VSS.n9 VSS.t45 0.0328709
R3832 VSS.n322 VSS 0.104908
R3833 VSS.n323 VSS 0.102401
R3834 VSS.n1131 VSS.n266 0.101553
R3835 VSS.n120 VSS.n341 0.101553
R3836 VSS.n1238 VSS.t209 0.101369
R3837 VSS.n440 VSS.n428 0.0982881
R3838 VSS.n1250 VSS.n1249 0.0977893
R3839 VSS.n257 VSS.n247 0.0975782
R3840 VSS.t135 VSS.t92 0.0961664
R3841 VSS.t258 VSS.t92 0.0959527
R3842 VSS.t102 VSS.t92 0.0947086
R3843 VSS.n746 VSS.n247 0.09376
R3844 VSS.n858 VSS.n720 0.0930352
R3845 VSS.n950 VSS.n949 0.0914084
R3846 VSS.n79 VSS.n81 0.0268809
R3847 VSS.n949 VSS.n621 0.0905
R3848 VSS.n720 VSS.n722 0.0898488
R3849 VSS.t92 VSS.n84 1.02387
R3850 VSS.n1189 VSS.n216 0.0885851
R3851 VSS.n584 VSS.n583 0.0884292
R3852 VSS.n1060 VSS.n1059 0.0874849
R3853 VSS.t33 VSS.n61 0.185959
R3854 VSS.n484 VSS.t102 0.0849615
R3855 VSS.n503 VSS.t135 0.0849615
R3856 VSS.n632 VSS.t258 0.0849615
R3857 VSS.n950 VSS.t92 0.0848047
R3858 VSS.n1130 VSS.n267 0.0810025
R3859 VSS.n131 VSS.n68 0.0810025
R3860 VSS.n952 VSS.n951 0.0803
R3861 VSS.t92 VSS.n57 0.0789884
R3862 VSS.n72 VSS.n510 0.0762412
R3863 VSS.n1183 VSS.t151 0.0761986
R3864 VSS.n272 VSS.n268 0.0755
R3865 VSS.n99 VSS.n98 0.0755
R3866 VSS.n129 VSS.n68 0.0755
R3867 VSS.n702 VSS.t129 0.498224
R3868 VSS.n119 VSS.t129 0.468863
R3869 VSS.n853 VSS.t19 0.498224
R3870 VSS.t181 VSS.n3 0.0738775
R3871 VSS.n654 VSS.t92 1.02007
R3872 VSS.n580 VSS.t114 0.071682
R3873 VSS.n192 VSS.t54 0.071682
R3874 VSS.n1142 VSS.n1141 0.0701769
R3875 VSS.n1180 VSS.t151 0.0685548
R3876 VSS.n566 VSS.t110 1.01912
R3877 VSS.n1126 VSS.n1125 0.0669942
R3878 VSS.n842 VSS.t245 0.0603002
R3879 VSS.n824 VSS.t245 0.0603002
R3880 VSS.n1215 VSS.t8 0.059903
R3881 VSS.n843 VSS.n91 0.0592823
R3882 VSS.n831 VSS.n783 0.0592823
R3883 VSS.t247 VSS.n92 0.0592823
R3884 VSS.n1069 VSS.n307 0.0582778
R3885 VSS.n1070 VSS.n1069 0.0582778
R3886 VSS.n313 VSS.t212 0.0582778
R3887 VSS.n313 VSS.n312 0.0582778
R3888 VSS.n1059 VSS.t142 0.0581855
R3889 VSS.n326 VSS.n325 0.0560556
R3890 VSS.n325 VSS.n321 0.0560556
R3891 VSS.n1142 VSS.n248 0.0543356
R3892 VSS.n1131 VSS.n1130 0.0533947
R3893 VSS.n131 VSS.n341 0.0533947
R3894 VSS.t249 VSS.n831 0.0531937
R3895 VSS.n392 VSS.n371 0.0527973
R3896 VSS.n1093 VSS.n1092 0.0514248
R3897 VSS.t181 VSS.n1240 0.0513776
R3898 VSS.t110 VSS.n54 1.05396
R3899 VSS.n819 VSS.n786 0.0473468
R3900 VSS.n815 VSS.n786 0.0473468
R3901 VSS.n819 VSS.n818 0.0473468
R3902 VSS.n818 VSS.n817 0.0473468
R3903 VSS.n797 VSS.n793 0.0473468
R3904 VSS.n797 VSS.n796 0.0473468
R3905 VSS.n799 VSS.n793 0.0473468
R3906 VSS.n800 VSS.n799 0.0473468
R3907 VSS.n803 VSS.n794 0.0473468
R3908 VSS.n803 VSS.n802 0.0473468
R3909 VSS.n805 VSS.n804 0.0473468
R3910 VSS.n804 VSS.n779 0.0473468
R3911 VSS.n898 VSS.n110 0.0473468
R3912 VSS.n618 VSS.n616 0.0469299
R3913 VSS.t22 VSS.n618 0.0449953
R3914 VSS.n1125 VSS.n1124 0.0433103
R3915 VSS.n1112 VSS.n249 0.0423342
R3916 VSS.n1112 VSS.n254 0.0423342
R3917 VSS.n270 VSS.n267 0.0423342
R3918 VSS.n1195 VSS.n34 0.0423342
R3919 VSS.n1195 VSS.n203 0.0423342
R3920 VSS.n416 VSS.n217 0.0423342
R3921 VSS.n416 VSS.n392 0.0423342
R3922 VSS.n1188 VSS.n218 0.0423342
R3923 VSS.n409 VSS.n218 0.0423342
R3924 VSS.n880 VSS.n879 0.0414449
R3925 VSS.n879 VSS.n710 0.0414449
R3926 VSS.n1086 VSS.n1085 0.0414449
R3927 VSS.n1085 VSS.n1084 0.0414449
R3928 VSS.n304 VSS.n297 0.0414449
R3929 VSS.n304 VSS.n299 0.0414449
R3930 VSS.n1080 VSS.n1079 0.0414449
R3931 VSS.n1081 VSS.n1080 0.0414449
R3932 VSS.n871 VSS.n136 0.0408927
R3933 VSS.n869 VSS.n136 0.0403915
R3934 VSS.n1240 VSS.t209 0.0402234
R3935 VSS.n871 VSS.n870 0.0398939
R3936 VSS.n869 VSS.n709 0.0398939
R3937 VSS.n1059 VSS.n327 0.0396691
R3938 VSS.t144 VSS.n39 0.164179
R3939 VSS.n1137 VSS.n255 0.0362353
R3940 VSS.n783 VSS.n782 0.0361879
R3941 VSS.n1126 VSS.n270 0.0359395
R3942 VSS.n1109 VSS.n270 0.0359395
R3943 VSS.n1109 VSS.n249 0.0359395
R3944 VSS.n1141 VSS.n249 0.0359395
R3945 VSS.n1140 VSS.n252 0.0343415
R3946 VSS.n1110 VSS.t26 0.0343415
R3947 VSS.n1107 VSS.n1106 0.0343415
R3948 VSS.n1128 VSS.n1127 0.0343415
R3949 VSS.n124 VSS.t215 0.0343415
R3950 VSS.t152 VSS.n1139 0.0343415
R3951 VSS.n454 VSS.n453 0.0343415
R3952 VSS.n37 VSS.t234 0.0343415
R3953 VSS.n413 VSS.n412 0.0343415
R3954 VSS.n395 VSS.n394 0.0343415
R3955 VSS.t255 VSS.n393 0.0343415
R3956 VSS.n207 VSS.n206 0.0343415
R3957 VSS.t47 VSS.n205 0.0343415
R3958 VSS.n46 VSS.t144 0.589596
R3959 VSS.t57 VSS.n451 0.0343415
R3960 VSS.t111 VSS.n411 0.0343415
R3961 VSS.n405 VSS.n404 0.0343415
R3962 VSS.n407 VSS.t201 0.0343415
R3963 VSS.t28 VSS.n27 0.00175924
R3964 VSS.n126 VSS.n513 0.0343415
R3965 VSS.t31 VSS.n514 0.0343415
R3966 VSS.n74 VSS.n132 0.606791
R3967 VSS.n354 VSS.n353 0.0343415
R3968 VSS.n356 VSS.t52 0.0343415
R3969 VSS.t89 VSS.n77 0.429621
R3970 VSS.n11 VSS.n535 0.03425
R3971 VSS.n322 VSS.n321 0.0322348
R3972 VSS.n213 VSS.n212 0.0317648
R3973 VSS.t229 VSS.n510 0.0306586
R3974 VSS.n881 VSS.n713 0.0302143
R3975 VSS.n713 VSS.n712 0.0302143
R3976 VSS.n883 VSS.n882 0.0302143
R3977 VSS.n884 VSS.n883 0.0302143
R3978 VSS.n179 VSS.t125 0.0299059
R3979 VSS.n253 VSS.n248 0.0297603
R3980 VSS.n452 VSS.n426 0.0293851
R3981 VSS.n256 VSS.n253 0.0285274
R3982 VSS.n782 VSS.t39 0.0280875
R3983 VSS.n1138 VSS.n1137 0.0270789
R3984 VSS.n951 VSS.n950 0.0261021
R3985 VSS.t22 VSS.n619 0.0255714
R3986 VSS.n875 VSS.n874 0.0249085
R3987 VSS.n742 VSS.n729 0.0241262
R3988 VSS.n436 VSS.n435 0.0220217
R3989 VSS.t237 VSS.t144 0.973907
R3990 VSS.t138 VSS.n101 0.77502
R3991 VSS.n1090 VSS.n292 0.0211397
R3992 VSS.n729 VSS.n293 0.0211033
R3993 VSS.n585 VSS.n584 0.0200929
R3994 VSS.n1092 VSS.n8 0.017369
R3995 VSS.n587 VSS.n585 0.0170781
R3996 VSS.n975 VSS.n974 0.0160639
R3997 VSS.n138 VSS.t224 0.0155709
R3998 VSS.n257 VSS.n256 0.0144726
R3999 VSS.n212 VSS.n182 0.013704
R4000 VSS.t110 VSS.n10 0.277118
R4001 VSS.n1055 VSS.t60 0.257779
R4002 VSS.n1147 VSS.n117 0.257612
R4003 VSS.n104 VSS.n103 0.217812
R4004 VSS.n116 VSS.n115 0.141938
R4005 VSS.t92 VSS.n58 0.123238
R4006 VSS.n858 VSS.t183 0.116106
R4007 VSS.n96 VSS.n91 0.107153
R4008 VSS.t247 VSS.t39 0.107099
R4009 VSS.n676 VSS.t142 0.0598504
R4010 VSS.n108 VSS.n107 0.104986
R4011 VSS.t12 VSS.n113 0.0898077
R4012 VSS.n99 VSS.t204 0.0844219
R4013 VSS.n111 VSS.n96 0.0262779
R4014 VSS.n994 VSS.t92 1.03423
R4015 VSS.t204 VSS.n73 0.411493
R4016 VSS.t19 VSS.n62 0.468863
R4017 VSS.n585 VSS.t110 0.464698
R4018 VSS.n107 VSS.t19 0.432302
R4019 VSS.t233 VSS.n42 0.308711
R4020 VSS.n67 VSS.n77 0.410577
R4021 VSS.n68 VSS.n67 0.389867
R4022 VSS.n1012 VSS.n60 2.68261
R4023 VSS.t110 VSS.t166 1.21611
R4024 VSS.t110 VSS.n26 1.10878
R4025 VSS.t159 VSS.n33 0.326962
R4026 VSS.n1066 VSS.t233 1.02206
R4027 VSS.t144 VSS.n40 1.01881
R4028 VSS.t204 VSS.t110 1.01754
R4029 VSS.t45 VSS.n8 1.00702
C0 VDD a_25120_282778# 0.27009f
C1 OPOUT a_20320_309740# 0.12437f
C2 a_28942_249702# a_21793_252030# 0.00122f
C3 CEN GATE 1.57436f
C4 a_12418_278990# a_10054_278582# 0.03516f
C5 S0 a_25612_279510# 0.30632f
C6 x1.x4.R VDD 4.98597f
C7 a_25120_280506# x1.EN4 0.00438f
C8 x8.schmitt_0.A VDD 1.48799f
C9 DONEb CEN 1.82419f
C10 x6.B a_47649_278076# 0.30358f
C11 DISABLE GATE 1.23667f
C12 a_15729_279867# a_7586_279815# 0
C13 a_19144_310048# CTRLAMP 0.01363f
C14 REFOUT PWRENb 0.09385f
C15 VDD REFAMP 7.18883f
C16 a_19144_309740# a_20320_309740# 0.13955f
C17 a_21793_252030# x2.x3.MINUS 0.22438f
C18 RESET x6.B 1.37808f
C19 DONEb PROG 0.42766f
C20 a_25612_281782# x1.EN3 0.0044f
C21 a_5090_282373# x1.x2.R 0.0301f
C22 a_6089_249377# a_4967_249377# 0.01906f
C23 VDD a_13867_273711# 10.6477f
C24 x1.x1.R VDD 5.20001f
C25 a_40856_278332# VDD 1.26333f
C26 a_9718_309015# a_4934_308695# 0.04671f
C27 x1.OUT1 VDD 3.28938f
C28 a_23654_250994# GATE 0
C29 a_15044_280595# a_7586_279815# 0.00532f
C30 CHRGb CEN 0.00186f
C31 VDD a_12835_310048# 2.90951f
C32 REFOUT x1.EN3 0.51715f
C33 a_9718_309015# x4.VREF 0.00957f
C34 VDD a_12836_251302# 2.91374f
C35 a_18459_310776# REFAMP 0.12536f
C36 x10.MINUS a_12835_309740# 0.09345f
C37 BAT PWRENb 0.59973f
C38 a_39788_278052# VDD 0.58189f
C39 LENb PU 0.03298f
C40 DONEb PD 0.20794f
C41 PROG CHRGb 0.42766f
C42 a_4966_308123# a_4934_308695# 0.33125f
C43 a_10056_287214# VDD 0.1206f
C44 x1.EN1 VDD 2.6757f
C45 x1.S0N S0 3.45814f
C46 VDD a_12150_310776# 6.22184f
C47 x1.S1N a_25612_284054# 0.30837f
C48 VDD a_12151_252030# 9.79901f
C49 a_7586_279815# a_7634_278670# 0.86805f
C50 a_8788_278098# VDD 0.01014f
C51 a_7636_287302# x1.x1.x2.VREF 0
C52 a_28942_249702# x2.x3.OUT 1.49503f
C53 OPOUT CTRLAMP 0.0715f
C54 VDD a_25612_281782# 0
C55 a_12420_287622# a_7588_288447# 0.00755f
C56 a_14837_285088# a_15046_289227# 0
C57 CHRGb PD 0.20794f
C58 a_6088_308123# a_4934_308695# 0.0341f
C59 VDD a_4934_308695# 1.44136f
C60 DISABLE CEN 0.24033f
C61 a_15729_279867# a_15729_279559# 0.13302f
C62 a_15046_289227# a_15731_288499# 0.86973f
C63 a_18459_310776# a_12150_310776# 0.00179f
C64 VDD a_4935_249949# 1.44136f
C65 x6.B PWRENb 0.14057f
C66 VDD REFOUT 7.61758f
C67 a_8363_282343# a_7586_279815# 0.00103f
C68 VDD x4.VREF 2.97291f
C69 x1.EN2 x1.OUT2 0.29231f
C70 OPOUT a_19144_310048# 0.33868f
C71 a_7668_286730# VDD 0.00196f
C72 a_8363_282343# x1.x2.R 0.34548f
C73 a_7586_279815# x1.x2.R 0.08135f
C74 a_10655_284141# a_10431_282563# 0.13302f
C75 a_22462_286211# S0 0
C76 x1.OUT4 x1.x4.x2.VREF 0
C77 a_15044_280595# a_15729_279559# 0.03669f
C78 VDD x1.x3.R 4.724f
C79 VDD a_8363_283268# 1.0501f
C80 VDD a_4887_251094# 10.4978f
C81 VDD a_18665_284488# 0.0216f
C82 a_22478_251302# x2.x3.MINUS 0.09876f
C83 a_19144_309740# a_19144_310048# 0.13302f
C84 x1.EN2 a_25120_282778# 0.48439f
C85 a_22462_286211# x1.S0N 0
C86 a_16907_288191# VDD 1.02265f
C87 a_23654_250994# DISABLE 0.03942f
C88 a_15731_288191# x1.x1.x2.VREF 0.09306f
C89 VDD a_34961_250959# 0.99173f
C90 LATCH a_53474_278076# 0.32051f
C91 BAT VDD 3.22731f
C92 x1.x4.x2.VREF a_14835_276456# 0.00957f
C93 x1.x1.R a_7588_288447# 0.06981f
C94 x1.EN4 x1.OUT2 0.07007f
C95 a_21404_278263# a_22508_278263# 0.00396f
C96 PROG OPOUT 0.72822f
C97 PROG PD 2.90038f
C98 a_7354_308607# a_4934_308695# 0.49277f
C99 x1.x4.x1.OUT x1.OUT2 0.00434f
C100 x1.OUT4 a_8361_274636# 0.02532f
C101 LENb LEN 0.35939f
C102 BAT m2_148463_0# 0.17749f
C103 x1.x4.x1.OUT a_10429_273931# 0.01363f
C104 x1.x4.R a_10054_278582# 0
C105 CE VDD 0.45093f
C106 x2.x3.PLUS a_14012_250994# 0.02155f
C107 VDD a_28942_249702# 4.0514f
C108 a_18663_275856# a_17971_276456# 0.01906f
C109 LATCH a_51049_278076# 0.30419f
C110 x1.x4.x2.VREF a_8361_273711# 0.07645f
C111 a_25120_285050# VDD 0.2709f
C112 a_10056_287214# a_7588_288447# 0.00182f
C113 x1.S1N x1.EN3 0
C114 x1.OUT1 x1.EN2 0.00171f
C115 a_8790_286730# a_10056_287214# 0.01245f
C116 x1.x4.R x1.x4.x1.OUT 0.48832f
C117 x6.B VDD 2.39651f
C118 VDD x2.x3.MINUS 0.84075f
C119 x2.x3.MINUS a_22478_250994# 0.09306f
C120 x5.MINUS a_19144_310048# 0.09876f
C121 a_8361_274636# a_8361_273711# 0.0757f
C122 LATCH a_47649_278076# 0.00544f
C123 a_18663_275856# a_16287_275856# 0
C124 a_12420_287622# x1.x1.x2.VREF 0.00957f
C125 a_17973_285088# VDD 0.00404f
C126 a_9718_309015# x10.MINUS 0
C127 x1.x2.x1.OUT x1.OUT2 0.48835f
C128 a_19144_309740# OPOUT 0.05935f
C129 a_12835_310048# a_4886_309840# 0
C130 RESET LATCH 0.1619f
C131 VDD a_7666_278098# 0.00196f
C132 x1.EN1 a_25612_286326# 0.0044f
C133 x1.EN3 S1 0.20854f
C134 a_21793_252030# GATE 0
C135 x1.EN1 x1.EN2 0.03606f
C136 a_32580_277758# WEH 0
C137 DONEb a_47649_278076# 0.00272f
C138 a_7668_286730# a_7588_288447# 0.16355f
C139 a_10653_275509# a_8361_273711# 0.03669f
C140 a_16289_284488# VDD 0.00134f
C141 x8.schmitt_0.Y a_43777_278925# 0.1906f
C142 a_12420_287622# a_7636_287302# 0.04671f
C143 a_12150_310776# a_4886_309840# 0.03551f
C144 RESET DONEb 0.06581f
C145 VDD a_21358_286211# 0.02309f
C146 VDD a_16905_279559# 1.01692f
C147 a_8790_286730# a_7668_286730# 0.01906f
C148 x1.OUT3 x1.EN3 0.4213f
C149 a_53474_278076# CEN 0.0044f
C150 x1.S1N VDD 1.08599f
C151 x1.OUT4 x1.EN3 0.00932f
C152 a_8788_278098# a_10054_278582# 0.01245f
C153 a_42971_278925# a_43777_278925# 0.13792f
C154 VDD a_4967_249377# 0.00179f
C155 a_7355_249861# a_4935_249949# 0.49277f
C156 REFOUT x1.EN2 0.36705f
C157 x1.x1.R x1.x1.x2.VREF 0.31825f
C158 a_4934_308695# a_4886_309840# 0.86805f
C159 VDD x10.MINUS 0.79269f
C160 OPOUT x5.MINUS 0.45879f
C161 a_51049_278076# CEN 0.00636f
C162 a_24723_308864# a_20320_309740# 0
C163 x4.VREF a_4886_309840# 0.48095f
C164 VDD S1 3.48705f
C165 VDD a_17971_276456# 0.00404f
C166 x1.x3.x2.VREF x1.x3.R 0.3182f
C167 VDD x2.MINUS 2.5941f
C168 x8.schmitt_0.A a_43777_278925# 0.04753f
C169 a_7355_249861# a_4887_251094# 0.00182f
C170 a_12836_250994# a_14012_250994# 0.19212f
C171 a_8363_282343# a_10431_282563# 0.86973f
C172 a_25612_284054# S0 0.31791f
C173 LATCH PWRENb 1.22657f
C174 a_19144_309740# x5.MINUS 0.09345f
C175 OPOUT a_14011_309740# 0.00891f
C176 REFOUT x1.EN4 0.38452f
C177 a_10431_282563# x1.x2.R 0.3942f
C178 OPOUT a_6089_249377# 0.00357f
C179 a_31404_278437# a_32580_277758# 0.25239f
C180 VDD a_16287_275856# 0.00134f
C181 GATE PWRENb 0.48855f
C182 VDD x1.OUT3 1.20227f
C183 VDD a_26682_270558# 0.01517f
C184 x2.x3.OUT GATE 6.00622f
C185 x1.OUT4 VDD 8.68223f
C186 x1.x1.R a_22462_290353# 0.0256f
C187 x1.x3.R a_13869_282343# 0.05923f
C188 RESET CEN 0.0217f
C189 a_10056_287214# x1.x2.x1.OUT 0.00661f
C190 x11.schmitt_0.A CTRLAMP 0.0097f
C191 a_18665_284488# a_13869_282343# 0.16355f
C192 a_9719_250269# a_4935_249949# 0.04671f
C193 x1.OUT1 a_22462_290353# 0.0183f
C194 a_40856_278332# a_43777_278925# 0
C195 a_40856_278332# WEH 0.09706f
C196 DONEb PWRENb 15.0553f
C197 DISABLE a_21793_252030# 0.0207f
C198 a_10056_287214# a_7636_287302# 0.49277f
C199 VDD a_10655_284141# 0.64577f
C200 REFOUT a_25120_280506# 0.14002f
C201 VDD a_16245_283988# 1.46643f
C202 a_25120_285050# x1.EN2 0.00438f
C203 VDD x1.x1.x1.OUT 1.94594f
C204 VDD HALFBAT 1.79463f
C205 VDD a_14835_276456# 0.01082f
C206 a_42971_278925# x8.schmitt_0.Y 0.26594f
C207 a_5044_273700# VDD 0.06351f
C208 a_25791_309144# CTRLAMP 0.02636f
C209 VDD a_20320_309740# 1.20534f
C210 a_9719_250269# a_4887_251094# 0.00755f
C211 a_39788_278052# WEH 0.10081f
C212 PROG x2.x1.OUT 4.16576f
C213 a_16243_275356# a_13867_273711# 0.86805f
C214 a_23654_250994# a_21793_252030# 0.1225f
C215 a_15731_288191# x1.x1.R 0.26628f
C216 a_25120_282778# x1.OUT2 0.2302f
C217 x1.x3.x1.OUT x1.x3.R 0.49006f
C218 VDD a_8361_273711# 6.26049f
C219 x8.schmitt_0.A x8.schmitt_0.Y 0.34776f
C220 x1.x4.R x1.OUT2 0
C221 CE a_33989_250071# 0.31791f
C222 a_24723_308864# CTRLAMP 0.11441f
C223 a_7668_286730# a_7636_287302# 0.33125f
C224 VDD a_22508_281381# 0.10229f
C225 a_20320_309740# a_18459_310776# 0.07096f
C226 x1.x2.x1.OUT a_8363_283268# 1.73099f
C227 x1.x4.R a_10429_273931# 0.3942f
C228 a_17973_285088# a_13869_282343# 0.00342f
C229 a_14011_309740# x5.MINUS 0.00187f
C230 a_14012_250994# a_12836_251302# 0.13602f
C231 LATCH VDD 5.20991f
C232 VDD a_25120_278234# 0.27025f
C233 a_7666_278098# a_10054_278582# 0
C234 a_40856_278332# x8.schmitt_0.Y 0.00767f
C235 x8.schmitt_0.A a_42971_278925# 0.13556f
C236 LENb CE 0.08379f
C237 WEH REFOUT 0.18803f
C238 x1.OUT2 a_13867_273711# 0
C239 CEN PWRENb 0.08769f
C240 x1.S1N a_25612_286326# 0.3227f
C241 VDD GATE 15.485f
C242 a_5090_285737# a_6194_285737# 0.00396f
C243 VDD a_15729_279867# 2.89848f
C244 x1.S1N x1.EN2 0.20331f
C245 m2_148463_0# GATE 0.14843f
C246 a_10655_284141# x1.x2.x2.VREF 0.09306f
C247 x1.EN3 S0 0
C248 DONEb VDD 1.52073f
C249 x6.B LENb 0
C250 a_12836_250994# a_12836_251302# 0.13302f
C251 a_16289_284488# a_13869_282343# 0.00182f
C252 x1.x2.x2.VREF a_16245_283988# 0
C253 a_14012_250994# a_12151_252030# 0.1225f
C254 VDD a_5090_282373# 0.06418f
C255 a_13867_273711# a_10429_273931# 0
C256 DISABLE x2.x3.OUT 1.87068f
C257 VDD a_25612_279510# 0
C258 a_40856_278332# a_42971_278925# 0.00245f
C259 a_4967_249377# a_7355_249861# 0
C260 a_5044_277502# x1.OUT2 0.00587f
C261 a_25612_286326# S1 0
C262 x1.S0N x1.EN3 0.62607f
C263 CE PU 0.03298f
C264 WM VDD 1.08127f
C265 VDD a_15044_280595# 6.20724f
C266 x1.EN2 S1 0.01619f
C267 x1.EN1 x1.OUT2 0.00932f
C268 x10.MINUS a_4886_309840# 0.00151f
C269 x1.x4.R a_13867_273711# 0.06981f
C270 VDD CTRLAMP 2.66115f
C271 a_12835_309740# a_14011_309740# 0.13955f
C272 a_12836_250994# a_12151_252030# 0.03677f
C273 x2.x3.PLUS x2.x3.MINUS 0.59495f
C274 a_23654_250994# x2.x3.OUT 3.4497f
C275 a_12420_287622# a_10056_287214# 0.03516f
C276 a_40856_278332# x8.schmitt_0.A 0.24126f
C277 VDD CHRGb 1.54688f
C278 PD PWRENb 0.3588f
C279 x11.schmitt_0.Y CTRLAMP 0
C280 x1.OUT3 x1.EN2 0.00189f
C281 a_15731_288191# a_16907_288191# 0.10299f
C282 x1.x3.x1.OUT a_16905_279559# 1.73099f
C283 VDD a_19144_310048# 2.93562f
C284 a_12835_310048# REFAMP 0.01368f
C285 a_23654_250994# a_22478_251302# 0.13602f
C286 VDD S0 6.51942f
C287 x1.EN4 S1 0.62921f
C288 a_14837_285088# VDD 0.01082f
C289 a_18459_310776# CTRLAMP 1.03953f
C290 REFOUT x1.OUT2 0.70503f
C291 VDD a_7634_278670# 1.61492f
C292 x1.OUT1 x1.x1.R 0.5147f
C293 a_15731_288499# VDD 2.91371f
C294 VDD CEN 2.45147f
C295 x1.S0N VDD 1.13128f
C296 a_8363_283268# x1.OUT2 0.0205f
C297 a_12150_310776# REFAMP 1.06355f
C298 a_9719_250269# x2.MINUS 0.00957f
C299 a_25120_280506# S1 0.06936f
C300 a_8363_282343# VDD 6.26809f
C301 a_39788_278052# a_40856_278332# 0.1636f
C302 a_18459_310776# a_19144_310048# 0.86973f
C303 x1.OUT3 x1.EN4 0.00321f
C304 VDD a_7586_279815# 10.7102f
C305 REFOUT a_25120_282778# 0.12684f
C306 PROG VDD 38.3275f
C307 VDD DISABLE 5.55126f
C308 x1.OUT4 x1.EN4 0.30219f
C309 RESET a_51049_278076# 0.31791f
C310 VDD x1.x2.R 5.54807f
C311 x1.OUT4 x1.x4.x1.OUT 0.48947f
C312 a_15046_289227# VDD 6.20843f
C313 x1.EN1 x1.OUT1 0.62718f
C314 a_13869_282343# a_16245_283988# 0.86805f
C315 a_27936_308366# CTRLAMP 0.04417f
C316 a_12150_310776# a_12835_310048# 0.86973f
C317 x1.OUT3 a_25120_280506# 0.46666f
C318 x1.x3.x1.OUT a_16287_275856# 0.00661f
C319 x1.x3.x1.OUT x1.OUT3 0.48643f
C320 VDD a_23654_250994# 1.30554f
C321 PU S1 0.07981f
C322 RESET a_47649_278076# 0.01783f
C323 x4.VREF REFAMP 0.0039f
C324 a_12151_252030# a_12836_251302# 0.87704f
C325 a_23654_250994# a_22478_250994# 0.19212f
C326 VDD OPOUT 9.46865f
C327 VDD PD 16.0872f
C328 a_40856_278332# REFOUT 0.0011f
C329 x1.OUT1 REFOUT 0.56566f
C330 a_14837_285088# x1.x2.x2.VREF 0.00957f
C331 x1.x3.x2.VREF a_15729_279867# 0.09876f
C332 x1.x4.x1.OUT a_8361_273711# 1.03953f
C333 a_22462_290353# S1 0
C334 RESET a_43001_277554# 0
C335 x4.VREF a_12835_310048# 0.33892f
C336 VDD a_19144_309740# 0.62232f
C337 OPOUT a_18459_310776# 0.06093f
C338 a_10653_275509# x1.x4.x2.VREF 0.09306f
C339 a_39788_278052# REFOUT 0.07419f
C340 x1.x2.x1.OUT a_10655_284141# 0.04672f
C341 a_8363_282343# x1.x2.x2.VREF 0.07645f
C342 x1.x1.R a_16907_288191# 0.21595f
C343 x1.EN4 a_25120_278234# 0.48439f
C344 x1.x3.x2.VREF a_15044_280595# 0.07645f
C345 x1.EN1 REFOUT 0.09713f
C346 x1.x2.x2.VREF x1.x2.R 0.31819f
C347 a_10056_287214# a_7668_286730# 0
C348 x1.OUT1 a_16907_288191# 0.0179f
C349 x4.VREF a_12150_310776# 0.06156f
C350 VDD a_15729_279559# 0.58667f
C351 a_4887_251094# a_12836_251302# 0
C352 a_12418_278990# a_8361_273711# 0
C353 a_19144_309740# a_18459_310776# 0.03677f
C354 a_16243_275356# a_17971_276456# 0.0341f
C355 a_10653_275509# a_8361_274636# 0.10299f
C356 a_15731_288499# a_7588_288447# 0
C357 a_25612_281782# REFOUT 0.01955f
C358 LATCH LENb 0.15067f
C359 x1.EN4 a_25612_279510# 0.0044f
C360 a_15044_280595# a_13869_282343# 0.00103f
C361 x11.schmitt_0.A a_27906_309737# 0.13556f
C362 x1.S1N x1.OUT2 0
C363 LENb GATE 0.44989f
C364 a_47649_278076# PWRENb 0.31791f
C365 x4.VREF a_4934_308695# 0
C366 a_4887_251094# a_12151_252030# 0.00375f
C367 a_21793_252030# x2.x3.OUT 2.56912f
C368 a_25120_285050# x1.OUT1 0.2302f
C369 x1.x3.x2.VREF a_7634_278670# 0
C370 VDD x5.MINUS 0.75323f
C371 x1.EN2 S0 0.62607f
C372 x1.x3.x1.OUT a_15729_279867# 0.01368f
C373 RESET PWRENb 0.33818f
C374 a_16243_275356# a_16287_275856# 0.49277f
C375 a_15046_289227# a_7588_288447# 0.00532f
C376 DONEb LENb 0.09739f
C377 x1.S0N a_25612_286326# 0.30358f
C378 x1.S0N x1.EN2 0.00151f
C379 a_25791_309144# a_27906_309737# 0.00245f
C380 a_4887_251094# a_4935_249949# 0.86805f
C381 x1.S1N a_25120_282778# 0.02109f
C382 PD a_5831_36764# 0.6151f
C383 a_10054_278582# a_7634_278670# 0.49277f
C384 a_21793_252030# a_22478_251302# 0.87704f
C385 a_14837_285088# a_13869_282343# 0.00755f
C386 x2.MINUS a_12836_250994# 0.09313f
C387 VDD a_14011_309740# 0.93857f
C388 x1.x3.x1.OUT a_15044_280595# 1.03953f
C389 x1.x3.x2.VREF a_7586_279815# 0.44258f
C390 a_25120_285050# x1.EN1 0.48439f
C391 a_15731_288191# x1.x1.x1.OUT 0.04672f
C392 a_16243_275356# a_14835_276456# 0.04671f
C393 VDD a_6089_249377# 0.00404f
C394 x5.MINUS a_18459_310776# 0.65028f
C395 x1.EN4 S0 0.19975f
C396 LENb CHRGb 0.10575f
C397 DONEb PU 0.20708f
C398 a_25791_309144# x11.schmitt_0.A 0.24126f
C399 a_16289_284488# x1.x1.R 0
C400 x1.OUT3 x1.OUT2 0.07329f
C401 a_10054_278582# a_7586_279815# 0.00182f
C402 PD a_3855_36764# 0.00812f
C403 a_25120_282778# S1 0.05088f
C404 x1.OUT4 x1.OUT2 11.1522f
C405 a_33989_250071# CEN 0.30358f
C406 a_32580_277758# HALFBAT 0.43368f
C407 a_8363_282343# a_13869_282343# 0.00532f
C408 VDD a_12835_309740# 0.59713f
C409 a_54864_254859# GATE 0.27461f
C410 a_13869_282343# x1.x2.R 0.06981f
C411 a_14011_309740# a_18459_310776# 0.00135f
C412 VDD a_10431_282563# 3.01489f
C413 a_25120_285050# REFOUT 0.07844f
C414 a_33989_250071# DISABLE 0.00544f
C415 x1.S1N x1.OUT1 0.00656f
C416 CHRGb PU 0.20708f
C417 a_12418_278990# a_7634_278670# 0.04671f
C418 a_8788_278098# a_7666_278098# 0.01906f
C419 LENb CEN 0.08971f
C420 x1.OUT3 a_25120_282778# 0.00312f
C421 VDD x1.x4.x2.VREF 2.60222f
C422 a_5044_273700# x1.OUT2 0
C423 a_31404_278437# HALFBAT 0.01701f
C424 VDD a_21793_252030# 9.94423f
C425 a_21793_252030# a_22478_250994# 0.03677f
C426 VDD a_25612_284054# 0
C427 RESET VDD 3.54613f
C428 x1.x1.x2.VREF a_15731_288499# 0.09876f
C429 x1.x1.R S1 0
C430 x1.x4.R x1.OUT4 1.65932f
C431 a_13867_273711# a_17971_276456# 0.00342f
C432 x10.MINUS a_12835_310048# 0.09876f
C433 LENb PROG 0.47496f
C434 x1.OUT1 S1 0.06505f
C435 a_24723_308864# a_25791_309144# 0.1636f
C436 x1.S1N x1.EN1 0.71779f
C437 x1.OUT2 a_8361_273711# 0
C438 a_12418_278990# a_7586_279815# 0.00755f
C439 VDD a_8361_274636# 0.99762f
C440 a_28712_309737# a_27906_309737# 0.13792f
C441 VDD a_43001_277554# 0.10737f
C442 LATCH LEN 0.40287f
C443 VDD x2.x1.OUT 16.782f
C444 VDD a_27906_309737# 0.74406f
C445 x1.x3.x2.VREF a_15729_279559# 0.09306f
C446 a_22478_251302# x2.x3.OUT 0.00116f
C447 x1.x1.x2.VREF a_15046_289227# 0.07645f
C448 x2.MINUS a_12836_251302# 0.09876f
C449 x8.schmitt_0.Y LATCH 0
C450 x1.x4.R a_5044_273700# 0.02053f
C451 a_13867_273711# a_16287_275856# 0.00182f
C452 a_10429_273931# a_8361_273711# 0.86973f
C453 x10.MINUS a_12150_310776# 0.65031f
C454 a_8363_282343# x1.x2.x1.OUT 1.03953f
C455 PROG x2.x3.PLUS 0.01609f
C456 a_17973_285088# a_18665_284488# 0.01906f
C457 a_22462_290353# S0 0.0038f
C458 x1.OUT4 a_13867_273711# 0.30891f
C459 x1.EN1 S1 0.00835f
C460 x1.x2.x1.OUT x1.x2.R 0.48832f
C461 PROG PU 71.2308f
C462 LENb PD 0.03384f
C463 CE a_28942_249702# 0
C464 a_28712_309737# x11.schmitt_0.A 0.04753f
C465 VDD a_10653_275509# 0.64608f
C466 x11.schmitt_0.Y a_27906_309737# 0.26594f
C467 x1.S1N REFOUT 0.06423f
C468 VDD x11.schmitt_0.A 1.76087f
C469 a_10431_282563# x1.x2.x2.VREF 0.09876f
C470 a_20320_309740# REFAMP 0.02158f
C471 x1.x4.R a_8361_273711# 0.34548f
C472 x1.x1.R x1.x1.x1.OUT 0.36007f
C473 x2.MINUS a_12151_252030# 0.09485f
C474 WM a_32580_277758# 0
C475 a_13867_273711# a_14835_276456# 0.00755f
C476 a_4967_249377# a_4935_249949# 0.33125f
C477 x2.x3.PLUS a_23654_250994# 0.10026f
C478 a_16289_284488# a_18665_284488# 0
C479 a_25612_281782# S1 0.30749f
C480 x1.OUT1 x1.x1.x1.OUT 0.4992f
C481 a_5090_282373# x1.OUT2 0.01986f
C482 x1.x3.R a_16905_279559# 0.2648f
C483 x10.MINUS x4.VREF 0.40181f
C484 a_28712_309737# a_25791_309144# 0
C485 VDD a_18663_275856# 0.02153f
C486 x11.schmitt_0.Y x11.schmitt_0.A 0.34776f
C487 PU PD 86.49271f
C488 VDD a_25791_309144# 1.29784f
C489 a_28712_309737# PWRENb 0
C490 WM x1.OUT2 0.07268f
C491 REFOUT S1 0.13111f
C492 a_6148_277502# x1.OUT2 0
C493 WM a_31404_278437# 0.37278f
C494 x2.MINUS a_4935_249949# 0
C495 VDD PWRENb 7.93006f
C496 a_4967_249377# a_4887_251094# 0.16355f
C497 VDD x2.x3.OUT 8.54916f
C498 a_13867_273711# a_8361_273711# 0.00532f
C499 a_15731_288191# a_15731_288499# 0.13302f
C500 x2.x3.OUT a_22478_250994# 0.00262f
C501 x1.OUT3 a_25612_281782# 0.0128f
C502 x1.x3.x1.OUT a_15729_279559# 0.04672f
C503 x11.schmitt_0.Y a_25791_309144# 0.00767f
C504 a_6089_249377# a_7355_249861# 0.01245f
C505 VDD a_24723_308864# 0.58588f
C506 x11.schmitt_0.Y PWRENb 1.19905f
C507 x1.OUT3 REFOUT 1.62486f
C508 WEH OPOUT 0.07521f
C509 x1.OUT4 REFOUT 0.74093f
C510 x2.MINUS a_4887_251094# 0.45182f
C511 a_9718_309015# VDD 0.0314f
C512 VDD a_22478_251302# 2.91683f
C513 VDD x1.EN3 2.73846f
C514 a_15731_288191# a_15046_289227# 0.03669f
C515 a_22478_251302# a_22478_250994# 0.13302f
C516 LEN CEN 0.71384f
C517 a_25120_285050# x1.S1N 0.06703f
C518 PROG a_14012_250994# 0.1017f
C519 a_16289_284488# a_17973_285088# 0.01245f
C520 x1.x3.R a_16287_275856# 0
C521 x1.OUT3 x1.x3.R 0.50852f
C522 REFOUT HALFBAT 0.03474f
C523 a_27936_308366# x11.schmitt_0.A 0.21732f
C524 a_6088_308123# a_4966_308123# 0.01906f
C525 x1.S0N x1.OUT2 0.00406f
C526 a_4966_308123# VDD 0.00179f
C527 CTRLAMP REFAMP 0.27121f
C528 a_8363_282343# x1.OUT2 0.00141f
C529 a_10655_284141# a_8363_283268# 0.10299f
C530 x1.EN2 a_25612_284054# 0.0044f
C531 a_13869_282343# a_10431_282563# 0
C532 LENb a_53474_278076# 0.00103f
C533 PROG a_12836_250994# 0.05935f
C534 x1.OUT2 x1.x2.R 0.60257f
C535 a_18665_284488# a_16245_283988# 0.33125f
C536 a_27936_308366# a_25791_309144# 0.00302f
C537 a_32580_277758# OPOUT 6.40013f
C538 a_8363_282343# a_12420_287622# 0
C539 a_7354_308607# a_9718_309015# 0.03516f
C540 a_16907_288191# x1.x1.x1.OUT 1.73099f
C541 a_28712_309737# VDD 0.56654f
C542 x1.S0N a_25120_282778# 0.04827f
C543 a_27936_308366# PWRENb 0
C544 a_6088_308123# VDD 0.00404f
C545 a_19144_310048# REFAMP 0.04138f
C546 a_6148_277502# a_5044_277502# 0.00396f
C547 VDD a_22478_250994# 0.60505f
C548 LENb a_51049_278076# 0
C549 x11.schmitt_0.Y a_28712_309737# 0.1906f
C550 REFOUT a_25120_278234# 0.1438f
C551 a_7354_308607# a_4966_308123# 0
C552 x11.schmitt_0.Y VDD 3.1516f
C553 x1.x1.R S0 0.52987f
C554 a_22508_281381# x1.x3.R 0.00459f
C555 x1.OUT1 S0 0.34412f
C556 x1.x1.R a_15731_288499# 0.36057f
C557 VDD a_18459_310776# 6.27693f
C558 x1.x4.x1.OUT a_8361_274636# 1.73099f
C559 REFOUT a_25612_279510# 0.01955f
C560 x1.S0N x1.OUT1 0.0193f
C561 RESET LENb 0
C562 x1.x2.x1.OUT a_10431_282563# 0.01363f
C563 x1.S1N S1 2.64487f
C564 a_7354_308607# a_6088_308123# 0.01245f
C565 a_15729_279867# x1.x3.R 0.39612f
C566 a_7354_308607# VDD 0.00134f
C567 a_17973_285088# a_16245_283988# 0.0341f
C568 x1.EN1 S0 0.00186f
C569 x1.x1.R a_15046_289227# 0.22319f
C570 a_34961_250959# GATE 0.034f
C571 x1.x4.x1.OUT a_10653_275509# 0.04672f
C572 x2.x3.PLUS a_21793_252030# 0.06348f
C573 x1.OUT1 a_15046_289227# 0.0014f
C574 x1.OUT3 a_16905_279559# 0.01737f
C575 OPOUT REFAMP 0.46938f
C576 a_8788_278098# a_7634_278670# 0.0341f
C577 PROG a_12836_251302# 0.37836f
C578 x1.S0N x1.EN1 0.20095f
C579 a_15044_280595# x1.x3.R 0.35375f
C580 VDD x1.x2.x2.VREF 2.60227f
C581 a_38304_271110# a_38304_270558# 0.01269f
C582 a_16289_284488# x1.x1.x1.OUT 0.00661f
C583 a_16289_284488# a_16245_283988# 0.49277f
C584 a_27936_308366# VDD 0.18559f
C585 a_10056_287214# x1.x2.R 0
C586 x2.x3.PLUS x2.x1.OUT 0.05086f
C587 a_28942_249702# GATE 3.22671f
C588 x1.EN2 x1.EN3 0.03606f
C589 CE GATE 0
C590 x1.S0N a_25612_281782# 0.31791f
C591 REFOUT S0 0.10825f
C592 PROG a_12151_252030# 0.31768f
C593 a_8788_278098# a_7586_279815# 0.00342f
C594 LATCH x6.B 1.28034f
C595 a_9718_309015# a_4886_309840# 0.00755f
C596 x1.OUT3 S1 0.31974f
C597 a_16287_275856# a_17971_276456# 0.01245f
C598 a_27936_308366# x11.schmitt_0.Y 0.32212f
C599 a_53474_278076# LEN 0.31791f
C600 VDD a_5831_36764# 2.38282f
C601 a_43777_278925# RESET 0
C602 CHRGb a_34961_250959# 0.37709f
C603 x1.S0N REFOUT 0.06117f
C604 a_39788_278052# OPOUT 0.0017f
C605 a_7588_288447# VDD 10.7599f
C606 x1.x3.R S0 0.01315f
C607 x6.B DONEb 0.36166f
C608 LENb PWRENb 0.00596f
C609 a_8790_286730# VDD 0.01016f
C610 x1.EN4 x1.EN3 0.03606f
C611 a_4966_308123# a_4886_309840# 0.16355f
C612 a_16243_275356# x1.x4.x2.VREF 0
C613 VDD a_3855_36764# 1.20325f
C614 CE CHRGb 1.50792f
C615 a_16907_288191# a_15731_288499# 0.14661f
C616 a_25612_286326# VDD 0
C617 a_8363_282343# a_8363_283268# 0.0757f
C618 x1.x3.R a_7586_279815# 0.06981f
C619 a_34961_250959# CEN 0.0053f
C620 VDD x1.EN2 2.81164f
C621 VDD x1.x3.x2.VREF 2.60102f
C622 a_8363_283268# x1.x2.R 0.26608f
C623 PROG a_4887_251094# 0.08501f
C624 VDD a_7355_249861# 0.00134f
C625 x2.x3.PLUS x2.x3.OUT 0.00332f
C626 a_25120_280506# x1.EN3 0.48439f
C627 OPOUT a_4935_249949# 0.03935f
C628 x5.MINUS REFAMP 0
C629 a_14835_276456# a_16287_275856# 0.03516f
C630 OPOUT REFOUT 0.13237f
C631 PU PWRENb 0.32816f
C632 a_15729_279867# a_16905_279559# 0.14661f
C633 a_6088_308123# a_4886_309840# 0.00342f
C634 a_25120_285050# S0 0.04822f
C635 VDD a_4886_309840# 10.659f
C636 a_5044_273700# x1.OUT4 0.02365f
C637 DISABLE a_34961_250959# 0.28254f
C638 a_16907_288191# a_15046_289227# 0.07588f
C639 x8.schmitt_0.Y a_47649_278076# 0
C640 VDD a_10054_278582# 0.1205f
C641 a_28942_249702# CEN 0.00212f
C642 CE CEN 0.14713f
C643 VDD a_13869_282343# 10.4712f
C644 x2.x3.PLUS a_22478_251302# 0.33888f
C645 a_14012_250994# x2.x1.OUT 3.22121f
C646 x8.schmitt_0.Y RESET 1.20617f
C647 x1.S0N a_25120_285050# 0.02111f
C648 OPOUT a_4887_251094# 0.13019f
C649 a_14011_309740# REFAMP 1.63466f
C650 a_15044_280595# a_16905_279559# 0.07588f
C651 VDD x1.EN4 2.74132f
C652 VDD a_33989_250071# 0.00983f
C653 x1.OUT4 a_8361_273711# 0.00232f
C654 a_43777_278925# PWRENb 0.06706f
C655 VDD x1.x4.x1.OUT 1.94221f
C656 DISABLE a_28942_249702# 1.68157f
C657 PROG CE 0.47496f
C658 CE DISABLE 0.62631f
C659 a_10429_273931# x1.x4.x2.VREF 0.09876f
C660 WEH PWRENb 0.03423f
C661 x6.B CEN 0.00462f
C662 x8.schmitt_0.Y a_43001_277554# 0.32212f
C663 x1.OUT3 a_22508_281381# 0.01814f
C664 BAT OPOUT 0.60952f
C665 a_7666_278098# a_7634_278670# 0.33125f
C666 x1.OUT2 a_8361_274636# 0.00375f
C667 a_12836_250994# x2.x1.OUT 0.00262f
C668 VDD a_9719_250269# 0.01082f
C669 S1 a_25612_279510# 0.31791f
C670 a_14011_309740# a_12835_310048# 0.14661f
C671 a_16243_275356# a_18663_275856# 0.33125f
C672 LENb VDD 0.53997f
C673 x1.OUT4 a_25120_278234# 0.23031f
C674 a_7354_308607# a_4886_309840# 0.00182f
C675 VDD a_25120_280506# 0.27009f
C676 x1.x4.R x1.x4.x2.VREF 0.31874f
C677 VDD x1.x3.x1.OUT 1.90779f
C678 a_14837_285088# a_16289_284488# 0.03516f
C679 a_23654_250994# a_28942_249702# 0.0053f
C680 a_10429_273931# a_8361_274636# 0.14628f
C681 VDD a_12418_278990# 0.0252f
C682 a_7666_278098# a_7586_279815# 0.16355f
C683 CE PD 0.03384f
C684 x1.x1.x2.VREF VDD 2.60102f
C685 a_15729_279559# x1.x3.R 0.26628f
C686 x1.S1N S0 0.24858f
C687 a_12835_309740# a_12835_310048# 0.13302f
C688 a_14011_309740# a_12150_310776# 0.07588f
C689 x1.OUT3 a_25612_279510# 0.00256f
C690 VDD x2.x3.PLUS 1.43421f
C691 a_3855_36764# a_5831_36764# 0.03049f
C692 a_8790_286730# a_7588_288447# 0.00342f
C693 x2.x3.PLUS a_22478_250994# 0.05966f
C694 x1.x4.R a_8361_274636# 0.26609f
C695 VDD x1.x2.x1.OUT 1.98739f
C696 VDD PU 33.622f
C697 a_13867_273711# x1.x4.x2.VREF 0.44258f
C698 a_10429_273931# a_10653_275509# 0.13302f
C699 WM a_26682_270558# 0.01339f
C700 x1.S0N x1.S1N 0.26331f
C701 LEN PWRENb 0.0027f
C702 x8.schmitt_0.A a_43001_277554# 0.21732f
C703 x1.OUT4 WM 0
C704 a_7636_287302# VDD 1.61497f
C705 a_13869_282343# x1.x2.x2.VREF 0.44258f
C706 S0 S1 18.5428f
C707 x8.schmitt_0.Y PWRENb 0.05212f
C708 a_12835_309740# a_12150_310776# 0.03677f
C709 x1.x4.R a_10653_275509# 0.26628f
C710 VDD a_22462_290353# 0.0297f
C711 a_14011_309740# x4.VREF 0.13005f
C712 a_6089_249377# a_4935_249949# 0.0341f
C713 WM HALFBAT 0.54961f
C714 a_15044_280595# a_14835_276456# 0
C715 a_21404_278263# VDD 0.0198f
C716 a_43777_278925# VDD 0.51086f
C717 a_40856_278332# a_43001_277554# 0.00302f
C718 x1.S0N S1 2.96657f
C719 WEH VDD 1.11076f
C720 a_42971_278925# PWRENb 0.00475f
C721 x1.OUT3 S0 0.07612f
C722 PROG S1 2.85587f
C723 a_22462_286211# a_21358_286211# 0.00396f
C724 x1.OUT4 S0 0
C725 a_20320_309740# CTRLAMP 1.60761f
C726 x2.x1.OUT a_12836_251302# 0.00116f
C727 x1.EN3 x1.OUT2 0.08837f
C728 a_12835_309740# x4.VREF 0.05935f
C729 a_6089_249377# a_4887_251094# 0.00342f
C730 PROG x2.MINUS 0.30791f
C731 x1.S0N x1.OUT3 0.00484f
C732 OPOUT a_4967_249377# 0.05193f
C733 LATCH DONEb 0.37524f
C734 VDD a_16243_275356# 1.46632f
C735 a_15731_288191# VDD 0.58667f
C736 a_14837_285088# a_16245_283988# 0.04671f
C737 x8.schmitt_0.A PWRENb 0.03277f
C738 a_25791_309144# REFAMP 0.097f
C739 a_20320_309740# a_19144_310048# 0.14144f
C740 DONEb GATE 0.75719f
C741 x2.x1.OUT a_12151_252030# 2.52611f
C742 a_15731_288499# x1.x1.x1.OUT 0.01368f
C743 a_25120_282778# x1.EN3 0.00438f
C744 a_13867_273711# a_18663_275856# 0.16355f
C745 PD S1 0.0606f
C746 a_10431_282563# a_8363_283268# 0.14627f
C747 VDD a_14012_250994# 1.30554f
C748 REFOUT a_25612_284054# 0.01955f
C749 a_32580_277758# VDD 7.34153f
C750 a_8363_282343# a_10655_284141# 0.03669f
C751 VDD LEN 0.69214f
C752 a_15729_279559# a_16905_279559# 0.10299f
C753 a_10655_284141# x1.x2.R 0.26628f
C754 a_40856_278332# PWRENb 0.01171f
C755 a_15044_280595# a_15729_279867# 0.86973f
C756 x1.x1.x2.VREF a_7588_288447# 0.44258f
C757 a_24723_308864# REFAMP 0.02805f
C758 x8.schmitt_0.Y VDD 3.1146f
C759 PU a_5831_36764# 0.00302f
C760 a_15046_289227# x1.x1.x1.OUT 1.03953f
C761 CHRGb GATE 0.01785f
C762 VDD a_12836_250994# 0.60505f
C763 VDD x1.OUT2 9.99051f
C764 a_22508_281381# S0 0
C765 a_9719_250269# a_7355_249861# 0.03516f
C766 x1.x4.x1.OUT a_10054_278582# 0.00661f
C767 a_31404_278437# VDD 0.76341f
C768 S0 a_25120_278234# 0.02109f
C769 a_7636_287302# a_7588_288447# 0.86805f
C770 a_12420_287622# VDD 0.02515f
C771 x1.x3.x2.VREF a_12418_278990# 0.00957f
C772 VDD a_10429_273931# 3.01552f
C773 a_42971_278925# VDD 0.67823f
C774 PU a_3855_36764# 0.34973f
C775 x6.B a_51049_278076# 0.0044f
C776 a_8790_286730# a_7636_287302# 0.0341f
C777 LATCH CEN 0.3154f
C778 PD VSS 69.75328f
C779 PU VSS 43.31714f
C780 CHRGb VSS 43.2258f
C781 CE VSS 30.6303f
C782 PROG VSS 0.227p
C783 LENb VSS 38.9066f
C784 DONEb VSS 71.6256f
C785 BAT VSS 72.6679f
C786 S1 VSS 38.7904f
C787 S0 VSS 25.2146f
C788 PWRENb VSS 0.12096p
C789 GATE VSS 69.0566f
C790 VDD VSS 1.29753p
C791 m2_148463_0# VSS 0.12381p ; **FLOATING
C792 a_5831_36764# VSS 1.7018f
C793 a_3855_36764# VSS 2.45852f
C794 a_33989_250071# VSS 0.24039f
C795 a_6089_249377# VSS 2.02972f
C796 a_7355_249861# VSS 2.60738f
C797 a_9719_250269# VSS 2.367f
C798 a_4967_249377# VSS 1.5478f
C799 a_34961_250959# VSS 1.09893f
C800 a_28942_249702# VSS 4.53907f
C801 DISABLE VSS 7.06332f
C802 a_23654_250994# VSS 7.97756f
C803 x2.x3.PLUS VSS 4.40226f
C804 a_22478_250994# VSS 1.94124f
C805 x2.x3.MINUS VSS 2.72197f
C806 x2.x3.OUT VSS 6.78719f
C807 a_22478_251302# VSS 0.06648f
C808 a_21793_252030# VSS 1.18083f
C809 a_54864_254859# VSS 0.60354f
C810 a_14012_250994# VSS 8.00615f
C811 a_12836_250994# VSS 1.94051f
C812 x2.MINUS VSS 1.19075f
C813 a_12836_251302# VSS 0.02275f
C814 a_12151_252030# VSS 1.34919f
C815 a_4935_249949# VSS 3.21535f
C816 a_4887_251094# VSS 1.56955f
C817 x2.x1.OUT VSS 5.28554f
C818 a_54864_264981# VSS 0.98524f
C819 a_54864_275577# VSS 0.98524f
C820 a_53474_278076# VSS 0.21995f
C821 a_51049_278076# VSS 0.21995f
C822 a_47649_278076# VSS 0.24047f
C823 a_43001_277554# VSS 1.1578f
C824 a_38304_270558# VSS 2.62914f
C825 a_26682_270558# VSS 0.96418f
C826 a_38304_271110# VSS 0.95175f
C827 a_10429_273931# VSS 0.12871f
C828 a_13867_273711# VSS 1.46043f
C829 a_16243_275356# VSS 3.24903f
C830 x1.x4.x2.VREF VSS 1.06883f
C831 a_8361_274636# VSS 3.04702f
C832 a_10653_275509# VSS 2.04529f
C833 a_18663_275856# VSS 1.5988f
C834 a_17971_276456# VSS 2.03452f
C835 a_16287_275856# VSS 2.60075f
C836 a_14835_276456# VSS 2.35711f
C837 a_8361_273711# VSS 1.00392f
C838 CEN VSS 16.5293f
C839 LEN VSS 1.22616f
C840 x6.B VSS 2.27465f
C841 LATCH VSS 4.78566f
C842 RESET VSS 6.42597f
C843 a_43777_278925# VSS 0.17031f
C844 x8.schmitt_0.Y VSS 3.28872f
C845 x8.schmitt_0.A VSS 1.58552f
C846 a_40856_278332# VSS 1.43666f
C847 a_39788_278052# VSS 1.88248f
C848 WEH VSS 2.39368f
C849 a_32580_277758# VSS 7.99599f
C850 a_31404_278437# VSS 2.80255f
C851 WM VSS 6.71823f
C852 HALFBAT VSS 3.12438f
C853 a_25120_278234# VSS 1.04445f
C854 a_25612_279510# VSS 0.21995f
C855 x1.EN4 VSS 1.2708f
C856 a_25120_280506# VSS 0.88156f
C857 a_22508_278263# VSS 0.86882f
C858 a_21404_278263# VSS 0.92489f
C859 a_6148_277502# VSS 0.88138f
C860 x1.OUT4 VSS 6.31558f
C861 a_5044_273700# VSS 0.83659f
C862 x1.x4.R VSS 2.83069f
C863 a_5044_277502# VSS 0.86129f
C864 a_8788_278098# VSS 2.03452f
C865 a_10054_278582# VSS 2.65763f
C866 a_12418_278990# VSS 2.45179f
C867 a_7666_278098# VSS 1.59988f
C868 a_16905_279559# VSS 2.98607f
C869 x1.x3.R VSS 2.85206f
C870 a_15729_279559# VSS 1.89175f
C871 a_25612_281782# VSS 0.21995f
C872 x1.OUT3 VSS 4.98532f
C873 a_22508_281381# VSS 0.85528f
C874 a_15729_279867# VSS 0.01323f
C875 a_15044_280595# VSS 0.92629f
C876 x1.x3.x2.VREF VSS 1.05097f
C877 a_7634_278670# VSS 3.31954f
C878 a_7586_279815# VSS 1.7377f
C879 x1.EN3 VSS 1.21041f
C880 a_25120_282778# VSS 0.93646f
C881 a_10431_282563# VSS 0.12921f
C882 a_25612_284054# VSS 0.21995f
C883 x1.EN2 VSS 1.2128f
C884 a_13869_282343# VSS 1.55709f
C885 a_16245_283988# VSS 3.24901f
C886 x1.x2.x2.VREF VSS 1.06955f
C887 a_8363_283268# VSS 3.00789f
C888 a_10655_284141# VSS 2.04528f
C889 REFOUT VSS 13.9199f
C890 a_18665_284488# VSS 1.59882f
C891 a_25120_285050# VSS 0.92746f
C892 a_17973_285088# VSS 2.03452f
C893 a_16289_284488# VSS 2.60075f
C894 a_14837_285088# VSS 2.35711f
C895 a_8363_282343# VSS 1.00153f
C896 a_25612_286326# VSS 0.21995f
C897 x1.EN1 VSS 1.24787f
C898 x1.S1N VSS 4.01375f
C899 x1.S0N VSS 4.28007f
C900 a_22462_286211# VSS 0.86913f
C901 a_22462_290353# VSS 0.83251f
C902 a_21358_286211# VSS 0.91081f
C903 a_6194_285737# VSS 0.94015f
C904 x1.OUT2 VSS 12.7196f
C905 a_5090_282373# VSS 0.83415f
C906 x1.x2.R VSS 2.81008f
C907 a_5090_285737# VSS 0.86129f
C908 a_8790_286730# VSS 2.03452f
C909 x1.OUT1 VSS 6.19547f
C910 a_10056_287214# VSS 2.65802f
C911 a_12420_287622# VSS 2.4515f
C912 a_7668_286730# VSS 1.59988f
C913 a_16907_288191# VSS 3.02608f
C914 x1.x1.R VSS 3.39636f
C915 a_15731_288191# VSS 1.89175f
C916 a_15731_288499# VSS 0.01323f
C917 a_15046_289227# VSS 0.92861f
C918 x1.x1.x2.VREF VSS 1.05055f
C919 a_7636_287302# VSS 3.32003f
C920 a_7588_288447# VSS 1.75499f
C921 a_27936_308366# VSS 1.09286f
C922 a_6088_308123# VSS 2.03893f
C923 a_7354_308607# VSS 2.60848f
C924 a_9718_309015# VSS 2.36452f
C925 a_4966_308123# VSS 1.5992f
C926 a_28712_309737# VSS 0.21048f
C927 x11.schmitt_0.Y VSS 3.24438f
C928 x11.schmitt_0.A VSS 1.60046f
C929 a_25791_309144# VSS 1.40909f
C930 a_24723_308864# VSS 1.90302f
C931 a_20320_309740# VSS 3.17899f
C932 OPOUT VSS 58.6024f
C933 a_19144_309740# VSS 1.92376f
C934 x5.MINUS VSS 1.82958f
C935 a_14011_309740# VSS 3.22325f
C936 a_12835_309740# VSS 1.92139f
C937 x10.MINUS VSS 2.16813f
C938 x4.VREF VSS 1.10638f
C939 CTRLAMP VSS 7.23212f
C940 a_19144_310048# VSS 0.01533f
C941 a_18459_310776# VSS 0.80248f
C942 REFAMP VSS 5.98168f
C943 a_12835_310048# VSS 0.05053f
C944 a_12150_310776# VSS 0.82339f
C945 a_4934_308695# VSS 3.21535f
C946 a_4886_309840# VSS 1.5293f
C947 x1.x4.x1.OUT VSS 7.63211f
C948 x1.x3.x1.OUT VSS 7.57686f
C949 x1.x2.x1.OUT VSS 7.59842f
C950 x1.x1.x1.OUT VSS 7.62883f
C951 VDD.t97 VSS 0.07115f
C952 VDD.n0 VSS 0.14607f
C953 VDD.n1 VSS 0.02203f
C954 VDD.t139 VSS 0.575f
C955 VDD.t28 VSS 7.49161f
C956 VDD.t36 VSS 17.4246f
C957 VDD.n3 VSS 0.1458f
C958 VDD.n4 VSS 0.53053f
C959 VDD.t154 VSS 2.15244f
C960 VDD.t158 VSS 0.07501f
C961 VDD.n5 VSS 0.13701f
C962 VDD.n6 VSS 0.04571f
C963 VDD.t155 VSS 0.07501f
C964 VDD.n7 VSS 0.04571f
C965 VDD.t253 VSS 0.06171f
C966 VDD.n8 VSS 0.04322f
C967 VDD.t255 VSS 0.05984f
C968 VDD.n9 VSS 0.38853f
C969 VDD.n10 VSS 0.55611f
C970 VDD.n11 VSS 0.02312f
C971 VDD.n12 VSS 0.12874f
C972 VDD.n13 VSS 7.65912f
C973 VDD.n14 VSS 0.02135f
C974 VDD.n15 VSS 0.3112f
C975 VDD.n16 VSS 0.24289f
C976 VDD.t15 VSS 2.10947f
C977 VDD.n17 VSS 0.34354f
C978 VDD.n18 VSS 1.54807f
C979 VDD.n19 VSS 0.04239f
C980 VDD.n20 VSS 0.01432f
C981 VDD.n21 VSS 0.71031f
C982 VDD.n22 VSS 0.07288f
C983 VDD.n23 VSS 0.0735f
C984 VDD.n24 VSS 0.00696f
C985 VDD.n25 VSS 0.18833f
C986 VDD.t179 VSS 0.05984f
C987 VDD.n26 VSS 0.04571f
C988 VDD.n27 VSS 4.01377f
C989 VDD.t92 VSS 0.07501f
C990 VDD.t94 VSS 0.07501f
C991 VDD.n28 VSS 0.10839f
C992 VDD.t90 VSS 18.893f
C993 VDD.n29 VSS 0.46498f
C994 VDD.n30 VSS 0.13775f
C995 VDD.n31 VSS 0.09169f
C996 VDD.t18 VSS 0.05984f
C997 VDD.n32 VSS 0.07502f
C998 VDD.t1 VSS 0.05984f
C999 VDD.n33 VSS 0.09638f
C1000 VDD.n34 VSS 13.4146f
C1001 VDD.n35 VSS 0.37062f
C1002 VDD.t164 VSS 0.05984f
C1003 VDD.n36 VSS 0.03921f
C1004 VDD.n37 VSS 0.02839f
C1005 VDD.n38 VSS 0.02135f
C1006 VDD.n39 VSS 0.21535f
C1007 VDD.t160 VSS 0.36426f
C1008 VDD.t162 VSS 8.09216f
C1009 VDD.n40 VSS 0.15279f
C1010 VDD.n41 VSS 0.07416f
C1011 VDD.t185 VSS 6.2635f
C1012 VDD.n42 VSS 0.08041f
C1013 VDD.n43 VSS 0.03742f
C1014 VDD.n45 VSS 0.49071f
C1015 VDD.n46 VSS 0.07263f
C1016 VDD.n47 VSS 0.43966f
C1017 VDD.n48 VSS 0.1059f
C1018 VDD.t35 VSS 2.75686f
C1019 VDD.n49 VSS 0.06682f
C1020 VDD.n50 VSS 0.05197f
C1021 VDD.n51 VSS 17.0869f
C1022 VDD.t166 VSS 0.03129f
C1023 VDD.n52 VSS 0.06669f
C1024 VDD.n53 VSS 0.10285f
C1025 VDD.n54 VSS 0.16104f
C1026 VDD.n55 VSS 0.03057f
C1027 VDD.n56 VSS 0.06212f
C1028 VDD.n57 VSS 0.30301f
C1029 VDD.n58 VSS 0.99571f
C1030 VDD.n59 VSS 0.47663f
C1031 VDD.t135 VSS 0.77085f
C1032 VDD.t242 VSS 0.82455f
C1033 VDD.t120 VSS 0.77085f
C1034 VDD.n60 VSS 0.04541f
C1035 VDD.t118 VSS 0.82455f
C1036 VDD.n61 VSS 0.04039f
C1037 VDD.n62 VSS 0.05273f
C1038 VDD.n63 VSS 0.00441f
C1039 VDD.n64 VSS 0.03204f
C1040 VDD.n65 VSS 0.05221f
C1041 VDD.n66 VSS 0.00441f
C1042 VDD.n67 VSS 0.03204f
C1043 VDD.n68 VSS 0.05086f
C1044 VDD.n69 VSS 0.03242f
C1045 VDD.n70 VSS 0.05197f
C1046 VDD.t193 VSS 1.29994f
C1047 VDD.t57 VSS 2.26393f
C1048 VDD.n71 VSS 0.02773f
C1049 VDD.n72 VSS 0.02311f
C1050 VDD.n73 VSS 0.04065f
C1051 VDD.n74 VSS 0.04167f
C1052 VDD.n75 VSS 0.06212f
C1053 VDD.n76 VSS 0.02311f
C1054 VDD.n77 VSS 0.04065f
C1055 VDD.n78 VSS 0.04167f
C1056 VDD.n79 VSS 0.02311f
C1057 VDD.n80 VSS 0.06212f
C1058 VDD.n81 VSS 0.02311f
C1059 VDD.n82 VSS 0.0353f
C1060 VDD.t49 VSS 0.37703f
C1061 VDD.t0 VSS 0.67057f
C1062 VDD.n83 VSS 0.08049f
C1063 VDD.t41 VSS 1.05802f
C1064 VDD.n84 VSS 0.09169f
C1065 VDD.t17 VSS 2.17354f
C1066 VDD.n85 VSS 0.7505f
C1067 VDD.n86 VSS 3.82712f
C1068 VDD.t61 VSS 2.29375f
C1069 VDD.t63 VSS 2.35939f
C1070 VDD.n87 VSS 0.10839f
C1071 VDD.t157 VSS 2.35939f
C1072 VDD.t38 VSS 2.4213f
C1073 VDD.t180 VSS 1.40403f
C1074 VDD.t93 VSS 2.15244f
C1075 VDD.n88 VSS 0.10839f
C1076 VDD.t89 VSS 2.35939f
C1077 VDD.t4 VSS 2.29375f
C1078 VDD.t2 VSS 2.35939f
C1079 VDD.n89 VSS 0.10839f
C1080 VDD.t83 VSS 2.15244f
C1081 VDD.t85 VSS 2.29375f
C1082 VDD.t87 VSS 2.35939f
C1083 VDD.n90 VSS 0.54956f
C1084 VDD.n91 VSS 6.66215f
C1085 VDD.n92 VSS 0.27341f
C1086 VDD.n93 VSS 0.54313f
C1087 VDD.n94 VSS 0.09705f
C1088 VDD.n95 VSS 0.08084f
C1089 VDD.t187 VSS 1.30858f
C1090 VDD.n96 VSS 0.28383f
C1091 VDD.n97 VSS 0.08084f
C1092 VDD.n98 VSS 0.09054f
C1093 VDD.n99 VSS 0.11584f
C1094 VDD.n100 VSS 0.03287f
C1095 VDD.n101 VSS 0.03753f
C1096 VDD.n102 VSS 0.20681f
C1097 VDD.t189 VSS 0.62337f
C1098 VDD.n103 VSS 0.13364f
C1099 VDD.n104 VSS 0.08022f
C1100 VDD.n105 VSS 0.13646f
C1101 VDD.t190 VSS 0.64692f
C1102 VDD.n106 VSS 0.03745f
C1103 VDD.n107 VSS 0.45978f
C1104 VDD.t192 VSS 0.6421f
C1105 VDD.n108 VSS 0.03829f
C1106 VDD.n109 VSS 0.11074f
C1107 VDD.n110 VSS 0.07288f
C1108 VDD.n111 VSS 0.0336f
C1109 VDD.n112 VSS 0.07816f
C1110 VDD.t241 VSS 0.8354f
C1111 VDD.n113 VSS 0.04628f
C1112 VDD.n114 VSS 0.08022f
C1113 VDD.n115 VSS 0.0735f
C1114 VDD.n116 VSS 0.13364f
C1115 VDD.n117 VSS 0.11074f
C1116 VDD.n118 VSS 0.03287f
C1117 VDD.n119 VSS 0.55171f
C1118 VDD.t161 VSS 0.62337f
C1119 VDD.n120 VSS 0.07288f
C1120 VDD.t163 VSS 0.23345f
C1121 VDD.n121 VSS 2.8461f
C1122 VDD.t102 VSS 0.02326f
C1123 VDD.n122 VSS 0.04681f
C1124 VDD.n123 VSS 0.03316f
C1125 VDD.n124 VSS 0.3112f
C1126 VDD.n125 VSS 0.03316f
C1127 VDD.n126 VSS 0.02514f
C1128 VDD.n127 VSS 0.04333f
C1129 VDD.n128 VSS 0.02971f
C1130 VDD.n129 VSS 0.0668f
C1131 VDD.n130 VSS 0.05291f
C1132 VDD.n131 VSS 0.04238f
C1133 VDD.t126 VSS 0.16565f
C1134 VDD.t124 VSS 0.3064f
C1135 VDD.n132 VSS 0.38079f
C1136 VDD.t125 VSS 0.05984f
C1137 VDD.t127 VSS 0.16687f
C1138 VDD.t129 VSS 0.02527f
C1139 VDD.n133 VSS 0.90037f
C1140 VDD.n134 VSS 0.55674f
C1141 VDD.t128 VSS 0.2817f
C1142 VDD.n135 VSS 0.25187f
C1143 VDD.t165 VSS 0.30011f
C1144 VDD.t167 VSS 0.30011f
C1145 VDD.n136 VSS 0.0154f
C1146 VDD.n137 VSS 0.20007f
C1147 VDD.t123 VSS 0.20007f
C1148 VDD.n138 VSS 0.21123f
C1149 VDD.t130 VSS 0.03346f
C1150 VDD.n139 VSS 0.05097f
C1151 VDD.n140 VSS 0.04761f
C1152 VDD.n141 VSS 0.06051f
C1153 VDD.n142 VSS 0.03316f
C1154 VDD.t119 VSS 0.02326f
C1155 VDD.t121 VSS 0.02326f
C1156 VDD.n143 VSS 0.05522f
C1157 VDD.n144 VSS 0.03316f
C1158 VDD.n145 VSS 0.02135f
C1159 VDD.n146 VSS 0.04182f
C1160 VDD.n147 VSS 0.03815f
C1161 VDD.n148 VSS 0.02953f
C1162 VDD.n149 VSS 0.02839f
C1163 VDD.t101 VSS 0.59572f
C1164 VDD.n150 VSS 4.54647f
C1165 VDD.n151 VSS 0.88664f
C1166 VDD.t13 VSS 0.00775f
C1167 VDD.t73 VSS 0.00759f
C1168 VDD.n152 VSS 0.03391f
C1169 VDD.t105 VSS 0.01553f
C1170 VDD.n153 VSS 0.0102f
C1171 VDD.t259 VSS 0.01518f
C1172 VDD.n154 VSS 0.99585f
C1173 VDD.n155 VSS 0.64931f
C1174 VDD.n156 VSS 0.35804f
C1175 VDD.n157 VSS 0.03061f
C1176 VDD.n158 VSS 0.01129f
C1177 VDD.t9 VSS 0.01518f
C1178 VDD.n159 VSS 0.03033f
C1179 VDD.n160 VSS 4.59745f
C1180 VDD.n161 VSS 1.24546f
C1181 VDD.t110 VSS 0.11967f
C1182 VDD.n162 VSS 0.55775f
C1183 VDD.n163 VSS 0.08324f
C1184 VDD.n164 VSS 0.12471f
C1185 VDD.n165 VSS 0.04699f
C1186 VDD.t108 VSS 1.30135f
C1187 VDD.n166 VSS 0.04628f
C1188 VDD.n167 VSS 0.07386f
C1189 VDD.t113 VSS 0.05984f
C1190 VDD.t109 VSS 0.03036f
C1191 VDD.t226 VSS 0.02261f
C1192 VDD.t228 VSS 0.00632f
C1193 VDD.t230 VSS 0.02261f
C1194 VDD.t232 VSS 0.00632f
C1195 VDD.t234 VSS 0.02261f
C1196 VDD.t236 VSS 0.00632f
C1197 VDD.t238 VSS 0.02261f
C1198 VDD.t240 VSS 0.00632f
C1199 VDD.n168 VSS 0.17895f
C1200 VDD.n169 VSS 0.42879f
C1201 VDD.n170 VSS 0.15065f
C1202 VDD.n171 VSS 0.47984f
C1203 VDD.n172 VSS 0.0735f
C1204 VDD.t114 VSS 0.10207f
C1205 VDD.n173 VSS 0.13193f
C1206 VDD.t111 VSS 0.38275f
C1207 VDD.n174 VSS 0.68895f
C1208 VDD.n175 VSS 0.07288f
C1209 VDD.n176 VSS 0.0439f
C1210 VDD.n177 VSS 0.11084f
C1211 VDD.t117 VSS 0.11967f
C1212 VDD.n178 VSS 0.04164f
C1213 VDD.n179 VSS 0.062f
C1214 VDD.n180 VSS 0.05447f
C1215 VDD.n181 VSS 0.10008f
C1216 VDD.n182 VSS 0.04941f
C1217 VDD.n183 VSS 0.03459f
C1218 VDD.n184 VSS 0.10008f
C1219 VDD.t31 VSS 0.0155f
C1220 VDD.n185 VSS 0.03583f
C1221 VDD.t27 VSS 0.20515f
C1222 VDD.n186 VSS 0.02972f
C1223 VDD.t247 VSS 0.13942f
C1224 VDD.n187 VSS 0.04333f
C1225 VDD.n188 VSS 0.03722f
C1226 VDD.n189 VSS 0.14607f
C1227 VDD.t248 VSS 0.13127f
C1228 VDD.n190 VSS 0.02151f
C1229 VDD.n191 VSS 0.13907f
C1230 VDD.t82 VSS 0.13907f
C1231 VDD.n192 VSS 0.15324f
C1232 VDD.n193 VSS 0.02909f
C1233 VDD.n195 VSS 0.04306f
C1234 VDD.n196 VSS 0.03722f
C1235 VDD.t243 VSS 0.13907f
C1236 VDD.n197 VSS 0.07021f
C1237 VDD.n198 VSS 0.06089f
C1238 VDD.n199 VSS 0.0897f
C1239 VDD.n200 VSS 0.3632f
C1240 VDD.n201 VSS 0.04164f
C1241 VDD.n202 VSS 0.04503f
C1242 VDD.n203 VSS 0.026f
C1243 VDD.n204 VSS 0.05106f
C1244 VDD.n205 VSS 0.141f
C1245 VDD.n206 VSS 0.04333f
C1246 VDD.n207 VSS 0.05114f
C1247 VDD.n208 VSS 0.03722f
C1248 VDD.t96 VSS 0.13907f
C1249 VDD.n209 VSS 0.54624f
C1250 VDD.n210 VSS 0.38079f
C1251 VDD.n211 VSS 0.48042f
C1252 VDD.t136 VSS 0.20007f
C1253 VDD.n212 VSS 0.04333f
C1254 VDD.n213 VSS 0.04238f
C1255 VDD.n214 VSS 0.06501f
C1256 VDD.n215 VSS 0.07687f
C1257 VDD.t137 VSS 0.1016f
C1258 VDD.n216 VSS 0.0102f
C1259 VDD.n217 VSS 0.02953f
C1260 VDD.n218 VSS 0.0668f
C1261 VDD.n219 VSS 0.05291f
C1262 VDD.n220 VSS 0.04681f
C1263 VDD.n221 VSS 0.0154f
C1264 VDD.n222 VSS 0.20007f
C1265 VDD.t16 VSS 0.30011f
C1266 VDD.t14 VSS 0.30011f
C1267 VDD.n223 VSS 0.02839f
C1268 VDD.n224 VSS 0.03316f
C1269 VDD.n225 VSS 0.03815f
C1270 VDD.n226 VSS 0.03316f
C1271 VDD.n227 VSS 0.03316f
C1272 VDD.n228 VSS 0.02135f
C1273 VDD.n229 VSS 0.04165f
C1274 VDD.n230 VSS 0.05738f
C1275 VDD.n231 VSS 0.04541f
C1276 VDD.n232 VSS 0.03316f
C1277 VDD.n233 VSS 0.02839f
C1278 VDD.t184 VSS 0.59572f
C1279 VDD.n234 VSS 0.05555f
C1280 VDD.n235 VSS 0.03921f
C1281 VDD.n236 VSS 0.21123f
C1282 VDD.t141 VSS 0.2817f
C1283 VDD.n237 VSS 0.25187f
C1284 VDD.t140 VSS 0.16565f
C1285 VDD.t138 VSS 0.3064f
C1286 VDD.t250 VSS 0.29944f
C1287 VDD.n238 VSS 0.14607f
C1288 VDD.t249 VSS 0.13942f
C1289 VDD.n239 VSS 0.13907f
C1290 VDD.n240 VSS 0.0154f
C1291 VDD.n241 VSS 0.0102f
C1292 VDD.n242 VSS 0.03921f
C1293 VDD.n243 VSS 0.04164f
C1294 VDD.t245 VSS 0.66378f
C1295 VDD.n244 VSS 0.0248f
C1296 VDD.n245 VSS 0.13907f
C1297 VDD.t246 VSS 0.13942f
C1298 VDD.t142 VSS 17.1182f
C1299 VDD.n246 VSS 5.47728f
C1300 VDD.n247 VSS 15.1376f
C1301 VDD.n248 VSS 0.03753f
C1302 VDD.t26 VSS 0.11967f
C1303 VDD.n249 VSS 0.60102f
C1304 VDD.t23 VSS 0.11967f
C1305 VDD.t24 VSS 0.30726f
C1306 VDD.t25 VSS 0.05055f
C1307 VDD.n250 VSS 0.70451f
C1308 VDD.n251 VSS 0.51403f
C1309 VDD.n252 VSS 0.00766f
C1310 VDD.t22 VSS 3.80653f
C1311 VDD.t194 VSS 0.03101f
C1312 VDD.t58 VSS 0.03101f
C1313 VDD.n253 VSS 0.08241f
C1314 VDD.n254 VSS 0.03753f
C1315 VDD.n255 VSS 0.04635f
C1316 VDD.n256 VSS 0.04324f
C1317 VDD.n257 VSS 0.04328f
C1318 VDD.t145 VSS 0.0155f
C1319 VDD.t50 VSS 0.00775f
C1320 VDD.n258 VSS 0.02277f
C1321 VDD.n259 VSS 0.05144f
C1322 VDD.n260 VSS 0.05144f
C1323 VDD.n261 VSS 0.0173f
C1324 VDD.n262 VSS 0.09679f
C1325 VDD.n263 VSS 0.02262f
C1326 VDD.n264 VSS 0.10466f
C1327 VDD.t144 VSS 0.13907f
C1328 VDD.n265 VSS 0.14607f
C1329 VDD.t30 VSS 0.13942f
C1330 VDD.n266 VSS 0.13907f
C1331 VDD.n267 VSS 0.01741f
C1332 VDD.t19 VSS 0.18692f
C1333 VDD.t20 VSS 0.02527f
C1334 VDD.n268 VSS 0.27142f
C1335 VDD.t21 VSS 0.05984f
C1336 VDD.n269 VSS 0.1224f
C1337 VDD.n270 VSS 0.04325f
C1338 VDD.t53 VSS 1.62388f
C1339 VDD.t51 VSS 0.27221f
C1340 VDD.n271 VSS 0.69281f
C1341 VDD.n272 VSS 0.05144f
C1342 VDD.n273 VSS 0.05975f
C1343 VDD.n274 VSS 0.07424f
C1344 VDD.n275 VSS 0.20798f
C1345 VDD.t52 VSS 0.03036f
C1346 VDD.n276 VSS 0.12654f
C1347 VDD.n277 VSS 0.04608f
C1348 VDD.n278 VSS 0.63792f
C1349 VDD.t32 VSS 0.59964f
C1350 VDD.t116 VSS 0.65067f
C1351 VDD.n279 VSS 0.08022f
C1352 VDD.n280 VSS 0.41904f
C1353 VDD.n281 VSS 0.05637f
C1354 VDD.n282 VSS 0.04937f
C1355 VDD.n283 VSS 0.13364f
C1356 VDD.n284 VSS 0.03753f
C1357 VDD.n285 VSS 0.03547f
C1358 VDD.n286 VSS 0.67236f
C1359 VDD.n287 VSS 0.51274f
C1360 VDD.n288 VSS 0.24513f
C1361 VDD.t112 VSS 0.22989f
C1362 VDD.t115 VSS 0.05055f
C1363 VDD.n289 VSS 0.78271f
C1364 VDD.n290 VSS 0.14187f
C1365 VDD.n291 VSS 0.22234f
C1366 VDD.n292 VSS 0.18021f
C1367 VDD.n293 VSS 0.21535f
C1368 VDD.n294 VSS 0.13646f
C1369 VDD.n295 VSS 0.20721f
C1370 VDD.n296 VSS 0.10876f
C1371 VDD.n297 VSS 0.34235f
C1372 VDD.n298 VSS 1.23509f
C1373 VDD.t195 VSS 0.16655f
C1374 VDD.t197 VSS 0.16844f
C1375 VDD.t199 VSS 0.16844f
C1376 VDD.t201 VSS 0.16844f
C1377 VDD.t203 VSS 0.16844f
C1378 VDD.t205 VSS 0.16844f
C1379 VDD.t207 VSS 0.16844f
C1380 VDD.t209 VSS 0.16844f
C1381 VDD.t211 VSS 0.16844f
C1382 VDD.t213 VSS 0.16844f
C1383 VDD.t215 VSS 0.16844f
C1384 VDD.t217 VSS 0.16844f
C1385 VDD.t219 VSS 0.16844f
C1386 VDD.t221 VSS 0.16844f
C1387 VDD.t223 VSS 0.16844f
C1388 VDD.t225 VSS 0.16844f
C1389 VDD.t227 VSS 0.16844f
C1390 VDD.t229 VSS 0.16844f
C1391 VDD.t231 VSS 0.16844f
C1392 VDD.t233 VSS 0.16844f
C1393 VDD.t235 VSS 0.11525f
C1394 VDD.t172 VSS 0.38275f
C1395 VDD.n299 VSS 0.15097f
C1396 VDD.n300 VSS 0.05411f
C1397 VDD.n301 VSS 0.35918f
C1398 VDD.n302 VSS 0.08084f
C1399 VDD.n303 VSS 0.16196f
C1400 VDD.t169 VSS 0.03036f
C1401 VDD.n304 VSS 0.29192f
C1402 VDD.n305 VSS 0.10604f
C1403 VDD.n306 VSS 0.21535f
C1404 VDD.n307 VSS 0.09725f
C1405 VDD.n308 VSS 0.16233f
C1406 VDD.t168 VSS 1.30135f
C1407 VDD.n309 VSS 0.10876f
C1408 VDD.n310 VSS 0.13364f
C1409 VDD.n311 VSS 0.0439f
C1410 VDD.t177 VSS 0.11967f
C1411 VDD.n312 VSS 0.24513f
C1412 VDD.t171 VSS 0.11967f
C1413 VDD.t196 VSS 0.0155f
C1414 VDD.t198 VSS 0.02261f
C1415 VDD.t200 VSS 0.00632f
C1416 VDD.t202 VSS 0.02261f
C1417 VDD.t204 VSS 0.00632f
C1418 VDD.t206 VSS 0.02261f
C1419 VDD.t208 VSS 0.00632f
C1420 VDD.t210 VSS 0.02261f
C1421 VDD.t212 VSS 0.00632f
C1422 VDD.t214 VSS 0.02261f
C1423 VDD.t216 VSS 0.00632f
C1424 VDD.t218 VSS 0.02261f
C1425 VDD.t220 VSS 0.00632f
C1426 VDD.t222 VSS 0.02261f
C1427 VDD.t224 VSS 0.00632f
C1428 VDD.n313 VSS 0.3356f
C1429 VDD.n314 VSS 1.21306f
C1430 VDD.n315 VSS 1.28408f
C1431 VDD.t170 VSS 0.05984f
C1432 VDD.n316 VSS 0.29737f
C1433 VDD.n317 VSS 0.73969f
C1434 VDD.n318 VSS 0.27427f
C1435 VDD.n319 VSS 0.51274f
C1436 VDD.n320 VSS 0.03753f
C1437 VDD.t174 VSS 0.65067f
C1438 VDD.t29 VSS 0.68895f
C1439 VDD.t176 VSS 0.65067f
C1440 VDD.n321 VSS 0.04404f
C1441 VDD.n322 VSS 0.03557f
C1442 VDD.n323 VSS 0.67236f
C1443 VDD.n324 VSS 0.03547f
C1444 VDD.n325 VSS 0.20798f
C1445 VDD.n326 VSS 0.13193f
C1446 VDD.n327 VSS 0.12471f
C1447 VDD.n328 VSS 0.04699f
C1448 VDD.n329 VSS 0.0735f
C1449 VDD.n330 VSS 0.08022f
C1450 VDD.n331 VSS 0.04628f
C1451 VDD.n332 VSS 0.03309f
C1452 VDD.n333 VSS 0.93986f
C1453 VDD.n334 VSS 0.08275f
C1454 VDD.n335 VSS 0.96802f
C1455 VDD.t173 VSS 0.22989f
C1456 VDD.t175 VSS 0.05055f
C1457 VDD.n336 VSS 0.8475f
C1458 VDD.n337 VSS 0.14187f
C1459 VDD.n338 VSS 0.22234f
C1460 VDD.n339 VSS 0.20721f
C1461 VDD.n340 VSS 0.13646f
C1462 VDD.n341 VSS 0.07288f
C1463 VDD.n342 VSS 0.68895f
C1464 VDD.n343 VSS 0.05326f
C1465 VDD.n344 VSS 0.08158f
C1466 VDD.n345 VSS 0.11834f
C1467 VDD.n346 VSS 0.09139f
C1468 VDD.n347 VSS 0.27394f
C1469 VDD.n348 VSS 0.04628f
C1470 VDD.n349 VSS 0.05503f
C1471 VDD.t244 VSS 0.8354f
C1472 VDD.t95 VSS 0.45004f
C1473 VDD.n350 VSS 0.13364f
C1474 VDD.n351 VSS 0.0968f
C1475 VDD.n352 VSS 0.19212f
C1476 VDD.n353 VSS 0.03745f
C1477 VDD.t103 VSS 0.05354f
C1478 VDD.t257 VSS 0.03101f
C1479 VDD.n354 VSS 0.41516f
C1480 VDD.n355 VSS 0.07814f
C1481 VDD.n356 VSS 0.10584f
C1482 VDD.n357 VSS 0.13902f
C1483 VDD.t149 VSS 0.03036f
C1484 VDD.n358 VSS 0.04628f
C1485 VDD.n359 VSS 0.41516f
C1486 VDD.t146 VSS 0.8354f
C1487 VDD.n360 VSS 0.07816f
C1488 VDD.n361 VSS 0.03287f
C1489 VDD.n362 VSS 0.08022f
C1490 VDD.n363 VSS 0.0735f
C1491 VDD.n364 VSS 0.13364f
C1492 VDD.n365 VSS 0.11074f
C1493 VDD.n366 VSS 0.62472f
C1494 VDD.t150 VSS 0.62337f
C1495 VDD.t147 VSS 0.049f
C1496 VDD.n367 VSS 0.05197f
C1497 VDD.t156 VSS 2.32761f
C1498 VDD.n368 VSS 0.19932f
C1499 VDD.t152 VSS 0.07319f
C1500 VDD.t151 VSS 0.31677f
C1501 VDD.n369 VSS 0.47424f
C1502 VDD.n370 VSS 0.04322f
C1503 VDD.n371 VSS 0.05503f
C1504 VDD.n372 VSS 0.03745f
C1505 VDD.n373 VSS 0.59491f
C1506 VDD.n374 VSS 0.0968f
C1507 VDD.t153 VSS 0.45004f
C1508 VDD.n375 VSS 0.03829f
C1509 VDD.n376 VSS 0.03753f
C1510 VDD.n377 VSS 0.03603f
C1511 VDD.n378 VSS 0.03401f
C1512 VDD.t148 VSS 1.40403f
C1513 VDD.n379 VSS 0.1228f
C1514 VDD.n380 VSS 0.08022f
C1515 VDD.n381 VSS 0.0735f
C1516 VDD.n382 VSS 0.12082f
C1517 VDD.n383 VSS 0.15976f
C1518 VDD.n384 VSS 0.05479f
C1519 VDD.n385 VSS 0.04015f
C1520 VDD.n386 VSS 0.11074f
C1521 VDD.n387 VSS 0.03829f
C1522 VDD.n388 VSS 0.03753f
C1523 VDD.n389 VSS 0.03605f
C1524 VDD.n390 VSS 0.05209f
C1525 VDD.n391 VSS 0.03002f
C1526 VDD.n392 VSS 0.31704f
C1527 VDD.n393 VSS 0.11017f
C1528 VDD.t39 VSS 0.09062f
C1529 VDD.n394 VSS 0.00826f
C1530 VDD.t256 VSS 1.40403f
C1531 VDD.n395 VSS 0.47424f
C1532 VDD.t252 VSS 0.31677f
C1533 VDD.n396 VSS 0.62472f
C1534 VDD.n397 VSS 0.59491f
C1535 VDD.n398 VSS 0.17765f
C1536 VDD.n399 VSS 0.13592f
C1537 VDD.n400 VSS 0.07288f
C1538 VDD.t254 VSS 0.62337f
C1539 VDD.n401 VSS 2.33186f
C1540 VDD.n402 VSS 0.2187f
C1541 VDD.t81 VSS 0.05984f
C1542 VDD.t77 VSS 0.54858f
C1543 VDD.n403 VSS 0.04628f
C1544 VDD.n404 VSS 0.05503f
C1545 VDD.t262 VSS 0.8354f
C1546 VDD.t33 VSS 0.45004f
C1547 VDD.n405 VSS 0.13364f
C1548 VDD.n406 VSS 0.0968f
C1549 VDD.n407 VSS 0.21535f
C1550 VDD.n408 VSS 0.03287f
C1551 VDD.t44 VSS 0.0507f
C1552 VDD.n409 VSS 0.83225f
C1553 VDD.n410 VSS 0.41516f
C1554 VDD.n411 VSS 0.11985f
C1555 VDD.n412 VSS 0.24358f
C1556 VDD.n413 VSS 0.11841f
C1557 VDD.n414 VSS 0.08084f
C1558 VDD.n415 VSS 0.0735f
C1559 VDD.n416 VSS 0.08022f
C1560 VDD.n417 VSS 0.07814f
C1561 VDD.n418 VSS 0.08158f
C1562 VDD.n419 VSS 0.00525f
C1563 VDD.n420 VSS 0.35345f
C1564 VDD.t86 VSS 0.07501f
C1565 VDD.n421 VSS 0.08084f
C1566 VDD.n422 VSS 0.05197f
C1567 VDD.n423 VSS 0.0996f
C1568 VDD.n424 VSS 0.11841f
C1569 VDD.n425 VSS 0.10839f
C1570 VDD.n426 VSS 0.09864f
C1571 VDD.n427 VSS 0.54504f
C1572 VDD.t88 VSS 0.07501f
C1573 VDD.n428 VSS 0.42486f
C1574 VDD.n429 VSS 0.10839f
C1575 VDD.n430 VSS 0.08084f
C1576 VDD.n431 VSS 0.08084f
C1577 VDD.n432 VSS 0.05197f
C1578 VDD.n433 VSS 0.4291f
C1579 VDD.n434 VSS 0.35345f
C1580 VDD.t84 VSS 0.07501f
C1581 VDD.n435 VSS 0.45757f
C1582 VDD.n436 VSS 0.34531f
C1583 VDD.t79 VSS 0.03036f
C1584 VDD.n437 VSS 0.23295f
C1585 VDD.n438 VSS 0.04571f
C1586 VDD.t78 VSS 1.40403f
C1587 VDD.n439 VSS 0.10839f
C1588 VDD.n440 VSS 0.09864f
C1589 VDD.n441 VSS 0.19354f
C1590 VDD.n442 VSS 0.04763f
C1591 VDD.n443 VSS 0.02726f
C1592 VDD.n444 VSS 0.03605f
C1593 VDD.n445 VSS 0.03753f
C1594 VDD.n446 VSS 0.03829f
C1595 VDD.n447 VSS 0.11074f
C1596 VDD.n448 VSS 0.03745f
C1597 VDD.n449 VSS 0.47424f
C1598 VDD.t76 VSS 0.31677f
C1599 VDD.n450 VSS 0.62472f
C1600 VDD.n451 VSS 0.59491f
C1601 VDD.n452 VSS 0.14521f
C1602 VDD.n453 VSS 0.1458f
C1603 VDD.n454 VSS 0.09063f
C1604 VDD.n455 VSS 0.13646f
C1605 VDD.n456 VSS 0.07288f
C1606 VDD.t80 VSS 0.62337f
C1607 VDD.n457 VSS 0.04322f
C1608 VDD.n458 VSS 0.3562f
C1609 VDD.n459 VSS 0.19622f
C1610 VDD.n460 VSS 3.80191f
C1611 VDD.n461 VSS 2.97538f
C1612 VDD.t66 VSS 0.07501f
C1613 VDD.n462 VSS 0.48695f
C1614 VDD.n463 VSS 0.54313f
C1615 VDD.n464 VSS 0.11841f
C1616 VDD.n465 VSS 0.08084f
C1617 VDD.t62 VSS 0.07501f
C1618 VDD.n466 VSS 0.08084f
C1619 VDD.n467 VSS 0.05197f
C1620 VDD.n468 VSS 0.61617f
C1621 VDD.n469 VSS 0.54313f
C1622 VDD.t64 VSS 0.07501f
C1623 VDD.n470 VSS 0.10839f
C1624 VDD.n471 VSS 0.95183f
C1625 VDD.n472 VSS 0.18275f
C1626 VDD.n473 VSS 0.10839f
C1627 VDD.n474 VSS 0.08084f
C1628 VDD.n475 VSS 0.05197f
C1629 VDD.n476 VSS 0.0996f
C1630 VDD.n477 VSS 0.11841f
C1631 VDD.n478 VSS 0.12437f
C1632 VDD.n479 VSS 0.05959f
C1633 VDD.t65 VSS 1.75313f
C1634 VDD.n480 VSS 0.93798f
C1635 VDD.n481 VSS 0.56928f
C1636 VDD.n482 VSS 0.95656f
C1637 VDD.t237 VSS 0.13713f
C1638 VDD.t239 VSS 0.16655f
C1639 VDD.n483 VSS 0.30325f
C1640 VDD.t47 VSS 3.45297f
C1641 VDD.n484 VSS 3.08098f
C1642 VDD.n485 VSS 0.0384f
C1643 VDD.n486 VSS 0.93986f
C1644 VDD.n487 VSS 0.0916f
C1645 VDD.n488 VSS 4.41245f
C1646 VDD.n489 VSS 5.1674f
C1647 VDD.n490 VSS 1.39827f
C1648 VDD.n491 VSS 0.03696f
C1649 VDD.n492 VSS 0.05368f
C1650 VDD.n493 VSS 0.14572f
C1651 VDD.n494 VSS 0.02906f
C1652 VDD.n495 VSS 0.04634f
C1653 VDD.t68 VSS 0.00776f
C1654 VDD.n496 VSS 0.03033f
C1655 VDD.n497 VSS 0.03033f
C1656 VDD.t55 VSS 0.00776f
C1657 VDD.n498 VSS 0.04634f
C1658 VDD.n499 VSS 0.04942f
C1659 VDD.t258 VSS 0.19824f
C1660 VDD.n500 VSS 0.04442f
C1661 VDD.t12 VSS 0.19971f
C1662 VDD.n501 VSS 0.04054f
C1663 VDD.n502 VSS 0.23174f
C1664 VDD.n503 VSS 0.04054f
C1665 VDD.n504 VSS 0.0126f
C1666 VDD.n505 VSS 0.19809f
C1667 VDD.t72 VSS 0.19809f
C1668 VDD.n506 VSS 0.18855f
C1669 VDD.n507 VSS 0.18867f
C1670 VDD.t104 VSS 0.19824f
C1671 VDD.n508 VSS 0.19824f
C1672 VDD.n509 VSS 0.01697f
C1673 VDD.n510 VSS 0.04627f
C1674 VDD.n511 VSS 0.0295f
C1675 VDD.n512 VSS 0.14572f
C1676 VDD.t56 VSS 0.19824f
C1677 VDD.n513 VSS 0.09875f
C1678 VDD.t11 VSS 0.01518f
C1679 VDD.n514 VSS 0.06392f
C1680 VDD.n515 VSS 0.03061f
C1681 VDD.t106 VSS 0.19824f
C1682 VDD.n516 VSS 0.04622f
C1683 VDD.n517 VSS 0.04436f
C1684 VDD.t107 VSS 0.01518f
C1685 VDD.n518 VSS 0.03061f
C1686 VDD.n519 VSS 0.04622f
C1687 VDD.n520 VSS 0.04436f
C1688 VDD.n521 VSS 0.15678f
C1689 VDD.t261 VSS 0.01518f
C1690 VDD.n522 VSS 0.06392f
C1691 VDD.n523 VSS 0.04081f
C1692 VDD.t99 VSS 0.00776f
C1693 VDD.n524 VSS 0.01678f
C1694 VDD.n525 VSS 0.03696f
C1695 VDD.t100 VSS 0.19824f
C1696 VDD.n526 VSS 0.18949f
C1697 VDD.t98 VSS 0.19824f
C1698 VDD.n527 VSS 0.14572f
C1699 VDD.n528 VSS 0.14572f
C1700 VDD.n529 VSS 0.0295f
C1701 VDD.n530 VSS 0.04634f
C1702 VDD.n531 VSS 0.02906f
C1703 VDD.n532 VSS 0.04942f
C1704 VDD.n533 VSS 0.09875f
C1705 VDD.n534 VSS 0.15678f
C1706 VDD.t260 VSS 0.19824f
C1707 VDD.n535 VSS 0.14572f
C1708 VDD.n536 VSS 0.04634f
C1709 VDD.t75 VSS 0.01518f
C1710 VDD.t71 VSS 0.01518f
C1711 VDD.n537 VSS 0.06392f
C1712 VDD.n538 VSS 0.09875f
C1713 VDD.n539 VSS 0.04081f
C1714 VDD.t132 VSS 0.19824f
C1715 VDD.t8 VSS 0.19824f
C1716 VDD.n540 VSS 0.0295f
C1717 VDD.n541 VSS 0.04622f
C1718 VDD.n542 VSS 0.04436f
C1719 VDD.n543 VSS 0.01697f
C1720 VDD.n544 VSS 0.19824f
C1721 VDD.t70 VSS 0.19824f
C1722 VDD.n545 VSS 0.15678f
C1723 VDD.n546 VSS 0.15678f
C1724 VDD.t134 VSS 0.19824f
C1725 VDD.n547 VSS 0.18949f
C1726 VDD.n548 VSS 0.03696f
C1727 VDD.n549 VSS 0.02906f
C1728 VDD.n550 VSS 0.04942f
C1729 VDD.n551 VSS 0.01678f
C1730 VDD.t133 VSS 0.00776f
C1731 VDD.n552 VSS 0.06212f
C1732 VDD.n553 VSS 0.0295f
C1733 VDD.n554 VSS 0.14572f
C1734 VDD.t74 VSS 0.19824f
C1735 VDD.n555 VSS 0.19824f
C1736 VDD.n556 VSS 0.01697f
C1737 VDD.n557 VSS 0.01293f
C1738 VDD.n558 VSS 0.36871f
C1739 VDD.n559 VSS 0.31056f
C1740 VDD.n560 VSS 0.46908f
C1741 VDD.n561 VSS 0.36871f
C1742 VDD.n562 VSS 0.01293f
C1743 VDD.n563 VSS 0.01697f
C1744 VDD.n564 VSS 0.19824f
C1745 VDD.t10 VSS 0.19824f
C1746 VDD.n565 VSS 0.15678f
C1747 VDD.n566 VSS 0.15678f
C1748 VDD.n567 VSS 0.04081f
C1749 VDD.n568 VSS 0.02906f
C1750 VDD.n569 VSS 0.03696f
C1751 VDD.n570 VSS 0.18949f
C1752 VDD.t54 VSS 0.19824f
C1753 VDD.n571 VSS 0.14572f
C1754 VDD.n572 VSS 0.01678f
C1755 VDD.n573 VSS 0.0361f
C1756 VDD.n574 VSS 0.04337f
C1757 VDD.n575 VSS 0.07838f
C1758 VDD.n576 VSS 0.0353f
C1759 VDD.n577 VSS 0.01678f
C1760 VDD.n578 VSS 0.14572f
C1761 VDD.t67 VSS 0.19824f
C1762 VDD.n579 VSS 0.18949f
C1763 VDD.t69 VSS 0.19876f
C1764 VDD.n580 VSS 0.23563f
C1765 VDD.n581 VSS 0.86802f
C1766 VDD.n582 VSS 0.46006f
C1767 VDD.n583 VSS 0.36871f
C1768 VDD.n584 VSS 0.26471f
C1769 VDD.n585 VSS 0.15689f
C1770 VDD.n586 VSS 0.63329f
C1771 VDD.n587 VSS 0.70414f
C1772 VDD.n588 VSS 3.38594f
C1773 VDD.n589 VSS 1.70606f
C1774 VDD.n590 VSS 5.69415f
C1775 VDD.t40 VSS 0.0306f
C1776 VDD.n591 VSS 0.72838f
C1777 VDD.n592 VSS 0.1458f
C1778 VDD.n593 VSS 0.47424f
C1779 VDD.n594 VSS 0.03745f
C1780 VDD.t182 VSS 0.31677f
C1781 VDD.t178 VSS 0.62337f
C1782 VDD.n595 VSS 0.03829f
C1783 VDD.n596 VSS 0.11074f
C1784 VDD.n597 VSS 0.07288f
C1785 VDD.n598 VSS 0.13364f
C1786 VDD.n599 VSS 0.08022f
C1787 VDD.n600 VSS 0.03753f
C1788 VDD.n601 VSS 0.07816f
C1789 VDD.n602 VSS 0.41516f
C1790 VDD.n603 VSS 0.03287f
C1791 VDD.n604 VSS 0.08084f
C1792 VDD.n605 VSS 0.08084f
C1793 VDD.n606 VSS 0.19588f
C1794 VDD.n607 VSS 0.08084f
C1795 VDD.t181 VSS 0.03101f
C1796 VDD.n608 VSS 0.05503f
C1797 VDD.n609 VSS 0.04322f
C1798 VDD.n610 VSS 0.04628f
C1799 VDD.n611 VSS 0.35425f
C1800 VDD.n612 VSS 0.05197f
C1801 VDD.t91 VSS 2.29375f
C1802 VDD.n613 VSS 0.05197f
C1803 VDD.n614 VSS 0.08084f
C1804 VDD.n615 VSS 0.15213f
C1805 VDD.n616 VSS 0.03401f
C1806 VDD.n617 VSS 0.03603f
C1807 VDD.t251 VSS 0.8354f
C1808 VDD.n618 VSS 0.13646f
C1809 VDD.n619 VSS 0.09063f
C1810 VDD.n620 VSS 0.0968f
C1811 VDD.t34 VSS 0.45004f
C1812 VDD.n621 VSS 0.62472f
C1813 VDD.n622 VSS 0.59491f
C1814 VDD.n623 VSS 0.30064f
C1815 VDD.n624 VSS 3.74403f
C1816 VDD.t59 VSS 5.1635f
C1817 VDD.n625 VSS 2.61656f
C1818 VDD.n626 VSS 0.04322f
C1819 VDD.n627 VSS 0.05503f
C1820 VDD.n628 VSS 0.03745f
C1821 VDD.n629 VSS 0.45978f
C1822 VDD.n630 VSS 0.10304f
C1823 VDD.n631 VSS 0.1458f
C1824 VDD.n632 VSS 0.13646f
C1825 VDD.n633 VSS 0.09063f
C1826 VDD.n634 VSS 0.0968f
C1827 VDD.t122 VSS 0.45004f
C1828 VDD.n635 VSS 0.03829f
C1829 VDD.n636 VSS 0.03753f
C1830 VDD.n637 VSS 0.03603f
C1831 VDD.n638 VSS 0.41516f
C1832 VDD.n639 VSS 0.04571f
C1833 VDD.t159 VSS 1.0098f
C1834 VDD.n640 VSS 0.00525f
C1835 VDD.n641 VSS 0.13574f
C1836 VDD.n642 VSS 0.27623f
C1837 VDD.n643 VSS 0.48428f
C1838 VDD.n644 VSS 0.63124f
C1839 VDD.n645 VSS 0.10304f
C1840 VDD.n646 VSS 0.1458f
C1841 VDD.n647 VSS 0.09063f
C1842 VDD.n648 VSS 0.0968f
C1843 VDD.t131 VSS 0.45004f
C1844 VDD.n649 VSS 0.55171f
C1845 VDD.t191 VSS 0.23345f
C1846 VDD.n650 VSS 0.37062f
C1847 VDD.n651 VSS 0.05503f
C1848 VDD.n652 VSS 0.04322f
C1849 VDD.n653 VSS 0.04628f
C1850 VDD.n654 VSS 0.03309f
C1851 VDD.t188 VSS 0.32229f
C1852 VDD.n655 VSS 0.29737f
C1853 VDD.n656 VSS 0.07816f
C1854 VDD.n657 VSS 0.00525f
C1855 VDD.n658 VSS 0.08158f
C1856 VDD.n659 VSS 0.21535f
C1857 VDD.n660 VSS 0.0735f
C1858 VDD.t183 VSS 0.8354f
C1859 VDD.n661 VSS 0.03603f
C1860 VDD.n662 VSS 0.02437f
C1861 VDD.n663 VSS 0.08618f
C1862 VDD.n664 VSS 0.16302f
C1863 VDD.n665 VSS 0.11841f
C1864 VDD.n666 VSS 0.08084f
C1865 VDD.n667 VSS 0.05197f
C1866 VDD.t5 VSS 0.69118f
C1867 VDD.n668 VSS 0.54313f
C1868 VDD.n669 VSS 0.10839f
C1869 VDD.t3 VSS 1.02684f
C1870 VDD.n670 VSS 0.18275f
C1871 VDD.n671 VSS 0.10839f
C1872 VDD.n672 VSS 0.08084f
C1873 VDD.n673 VSS 0.05197f
C1874 VDD.n674 VSS 0.0996f
C1875 VDD.n675 VSS 0.11841f
C1876 VDD.n676 VSS 0.12519f
C1877 VDD.n677 VSS 0.0597f
C1878 VDD.t6 VSS 2.06061f
C1879 VDD.n678 VSS 0.05411f
C1880 VDD.t7 VSS 0.56221f
C1881 VDD.n679 VSS 0.43203f
C1882 VDD.n680 VSS 4.45644f
C1883 VDD.n681 VSS 8.32622f
C1884 VDD.n682 VSS 3.82534f
C1885 VDD.n683 VSS 0.13839f
C1886 VDD.n684 VSS 0.0573f
C1887 VDD.n685 VSS 0.05738f
C1888 VDD.t45 VSS 0.60262f
C1889 VDD.n686 VSS 0.12687f
C1890 VDD.t43 VSS 0.05984f
C1891 VDD.t42 VSS 0.71163f
C1892 VDD.n687 VSS 0.08049f
C1893 VDD.n688 VSS 0.23682f
C1894 VDD.n689 VSS 0.04727f
C1895 VDD.t186 VSS 0.30686f
C1896 VDD.n690 VSS 23.4563f
C1897 VDD.n691 VSS 17.1417f
C1898 VDD.n692 VSS 0.10256f
C1899 VDD.n693 VSS 0.08371f
C1900 PWRENb.t2 VSS 0.26279f
C1901 PWRENb.t1 VSS 0.26288f
C1902 PWRENb.n0 VSS 2.56586f
C1903 PWRENb.t5 VSS 0.04722f
C1904 PWRENb.t4 VSS 0.07304f
C1905 PWRENb.n1 VSS 0.24072f
C1906 PWRENb.t3 VSS 0.20964f
C1907 PWRENb.t0 VSS 0.20973f
C1908 PWRENb.n2 VSS 12.9781f
C1909 S0.n0 VSS 10.6464f
C1910 S0.t4 VSS 0.16482f
C1911 S0.t0 VSS 0.33452f
C1912 S0.t1 VSS 0.5304f
C1913 S0.n1 VSS 2.2893f
C1914 S0.t2 VSS 0.34281f
C1915 S0.t3 VSS 0.53022f
C1916 S0.n2 VSS 1.53159f
C1917 S0.n3 VSS 3.12041f
C1918 S0.t5 VSS 0.39442f
C1919 S1.n0 VSS 13.3226f
C1920 S1.t0 VSS 0.25201f
C1921 S1.t1 VSS 0.38978f
C1922 S1.n1 VSS 1.25087f
C1923 S1.t2 VSS 0.24591f
C1924 S1.t3 VSS 0.38991f
C1925 S1.n2 VSS 0.89214f
C1926 S1.n3 VSS 1.9605f
C1927 S1.t5 VSS 0.28539f
C1928 S1.t4 VSS 0.11991f
C1929 DONEb.t1 VSS 0.1746f
C1930 DONEb.t0 VSS 0.17038f
C1931 DONEb.n0 VSS 8.92797f
C1932 PROG.t10 VSS 0.036f
C1933 PROG.t8 VSS 0.036f
C1934 PROG.t7 VSS 0.036f
C1935 PROG.t6 VSS 0.036f
C1936 PROG.t9 VSS 0.036f
C1937 PROG.t1 VSS 0.036f
C1938 PROG.t0 VSS 0.036f
C1939 PROG.t2 VSS 0.036f
C1940 PROG.t3 VSS 0.036f
C1941 PROG.t4 VSS 0.036f
C1942 PROG.t5 VSS 0.036f
C1943 PROG.n0 VSS 1.23139f
C1944 PROG.n1 VSS 58.0867f
C1945 PROG.t12 VSS 0.20302f
C1946 PROG.t11 VSS 0.02933f
C1947 PU.t0 VSS 50.6692f
C1948 PU.n0 VSS 14.2087f
C1949 PU.n1 VSS 13.5632f
C1950 PU.n2 VSS 10.4796f
C1951 PU.n3 VSS 10.4798f
C1952 PU.n4 VSS 65.078f
C1953 PU.n5 VSS 18.2739f
C1954 PD.n0 VSS 2.10172f
C1955 PD.n1 VSS 4.4424f
C1956 PD.n2 VSS 1.57338f
C1957 PD.n3 VSS 1.57326f
C1958 PD.n4 VSS 1.57326f
C1959 PD.t0 VSS 27.4608f
C1960 PD.n5 VSS 7.25147f
C1961 PD.n6 VSS 6.93038f
C1962 PD.n7 VSS 5.49741f
C1963 PD.n8 VSS 3.44104f
C1964 PD.n9 VSS 3.26983f
C1965 PD.n10 VSS 32.9617f
C1966 PD.n11 VSS 2.53308f
C1967 PD.n12 VSS 0.24014f
.ends
