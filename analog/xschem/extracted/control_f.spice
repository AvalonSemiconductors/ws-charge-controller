* NGSPICE file created from flattened.ext - technology: gf180mcuD

.subckt control_f VDD VSS PD PU PWRENb PROG DONEb CHRGb S0 S1 CE LENb BAT GATE
X0 x1.x2.x1.OUT a_8363_282343# VDD.t66 VDD.t65 pfet_06v0 ad=3.52p pd=16.88u as=3.52p ps=16.88u w=8u l=1.1u
X1 a_33989_250071# CE DISABLE VSS.t11 nfet_06v0 ad=1.96p pd=3.96u as=0.88p ps=4.88u w=2u l=0.7u
X2 VSS.t47 a_23654_250994# x2.x3.OUT VSS.t48 nfet_06v0 ad=4.16p pd=16.52u as=4.16p ps=16.52u w=16u l=1.4u
D0 a_16289_284488# VSS.t29 diode_pd2nw_06v0 pj=12u area=5p
X3 a_4935_249949# a_4935_249949# a_7355_249861# VSS.t266 nfet_06v0 ad=4.4p pd=20.88u as=4.4p ps=20.88u w=10u l=2.5u
X4 VDD.t209 x11.schmitt_0.Y PWRENb.t3 VDD.t208 pfet_06v0 ad=3.52p pd=16.88u as=2.08p ps=8.52u w=8u l=0.55u
D1 a_7354_308607# VSS.t93 diode_pd2nw_06v0 pj=12u area=5p
X5 a_26682_270558# a_38304_271110# VSS.t6 ppolyf_u_1k_6p0 r_width=1u r_length=57.5u
X6 x2.x3.OUT a_28942_249702# GATE VSS.t110 nfet_06v0 ad=2.08p pd=8.52u as=3.52p ps=16.88u w=8u l=0.7u
X7 x2.x3.OUT DISABLE GATE VDD.t38 pfet_06v0 ad=3.52p pd=16.88u as=2.08p ps=8.52u w=8u l=0.7u
X8 a_10653_275509# x1.x4.x2.VREF a_10429_273931# VDD.t2 pfet_06v0 ad=1.76p pd=8.88u as=1.76p ps=8.88u w=4u l=1.1u
X9 x1.OUT2 x1.x2.x1.OUT VSS.t8 VSS.t239 nfet_06v0 ad=1.04p pd=4.52u as=1.76p ps=8.88u w=4u l=0.7u
D2 a_14835_276456# VSS.t73 diode_pd2nw_06v0 pj=12u area=5p
X10 a_13867_273711# a_13867_273711# VDD.t110 VDD.t109 pfet_06v0 ad=4.4p pd=20.88u as=4.4p ps=20.88u w=10u l=5u
X11 VDD.t162 a_4886_309840# x4.VREF VDD.t161 pfet_06v0 ad=4.4p pd=20.88u as=4.4p ps=20.88u w=10u l=5u
X12 x1.x2.x2.VREF a_14837_285088# VSS.t92 ppolyf_u_1k_6p0 r_width=1u r_length=5u
X13 a_10655_284141# x1.x2.x2.VREF a_10431_282563# VDD.t39 pfet_06v0 ad=1.76p pd=8.88u as=1.76p ps=8.88u w=4u l=1.1u
X14 x8.schmitt_0.A a_40856_278332# VSS.t167 VSS.t246 nfet_06v0 ad=1.32p pd=6.88u as=1.32p ps=6.88u w=3u l=1.4u
X15 x2.x3.OUT a_23654_250994# VSS.t47 VSS.t46 nfet_06v0 ad=4.16p pd=16.52u as=4.16p ps=16.52u w=16u l=1.4u
X16 VDD.t131 x6.B LATCH VDD.t130 pfet_06v0 ad=0.88p pd=4.88u as=0.88p ps=4.88u w=2u l=0.55u
X17 VDD.t57 a_4887_251094# a_4935_249949# VDD.t56 pfet_06v0 ad=4.4p pd=20.88u as=4.4p ps=20.88u w=10u l=5u
X18 VDD.t7 a_5090_282373# VSS.t4 ppolyf_u_1k r_width=1u r_length=2u
X19 PWRENb.t1 x11.schmitt_0.Y VSS.t253 VSS.t255 nfet_06v0 ad=2.08p pd=8.52u as=3.52p ps=16.88u w=8u l=0.7u
X20 x10.MINUS REFAMP VSS.t53 ppolyf_u_1k_6p0 r_width=1u r_length=20u
X21 VSS.t60 a_10653_275509# a_10653_275509# VSS.t58 nfet_06v0 ad=1.32p pd=6.88u as=1.32p ps=6.88u w=3u l=1.4u
X22 a_12418_278990# x1.x3.x2.VREF VSS.t224 ppolyf_u_1k_6p0 r_width=1u r_length=5u
X23 a_39788_278052# a_39788_278052# VSS.t167 VSS.t166 nfet_06v0 ad=1.32p pd=6.88u as=1.32p ps=6.88u w=3u l=1.4u
X24 VDD.t247 x2.x1.OUT PROG.t8 VDD.t246 pfet_06v0 ad=0.52p pd=2.52u as=0.52p ps=2.52u w=2u l=1u
X25 a_32580_277758# OPOUT cap_mim_2f0_m4m5_noshield c_width=5u c_length=5u
X26 VSS.t183 a_10655_284141# a_10655_284141# VSS.t182 nfet_06v0 ad=1.32p pd=6.88u as=1.32p ps=6.88u w=3u l=1.4u
D3 a_6088_308123# VSS.t134 diode_pd2nw_06v0 pj=12u area=5p
X27 VSS.t207 S1.t5 x1.S1N VSS.t206 nfet_06v0 ad=0.44p pd=2.88u as=0.44p ps=2.88u w=1u l=0.7u
X28 a_6194_285737# x1.OUT2 VSS.t43 ppolyf_u_1k r_width=1u r_length=16u
X29 VSS.t230 a_32580_277758# OPOUT VSS.t229 nfet_06v0 ad=7.04p pd=32.88u as=4.16p ps=16.52u w=16u l=1.4u
X30 VDD.t199 a_12151_252030# x2.x1.OUT VDD.t196 pfet_06v0 ad=7.04p pd=32.88u as=4.16p ps=16.52u w=16u l=1.1u
X31 VDD.t180 a_32580_277758# OPOUT VDD.t179 pfet_06v0 ad=7.04p pd=32.88u as=4.16p ps=16.52u w=16u l=1.1u
X32 x2.x3.OUT a_21793_252030# VDD.t154 VDD.t153 pfet_06v0 ad=4.16p pd=16.52u as=7.04p ps=32.88u w=16u l=1.1u
X33 VDD.t182 a_32580_277758# OPOUT VDD.t179 pfet_06v0 ad=4.16p pd=16.52u as=4.16p ps=16.52u w=16u l=1.1u
X34 PD.t0 a_5831_36764# VSS.t114 VSS.t112 nfet_06v0 ad=2.08p pd=8.52u as=3.52p ps=16.88u w=8u l=0.7u
X35 a_4887_251094# a_4935_249949# a_4967_249377# VSS.t265 nfet_06v0 ad=4.4p pd=20.88u as=4.4p ps=20.88u w=10u l=2.5u
X36 RESET x8.schmitt_0.Y VSS.t201 VSS.t200 nfet_06v0 ad=3.52p pd=16.88u as=2.08p ps=8.52u w=8u l=0.7u
X37 VDD.t235 x2.x1.OUT PROG.t10 VDD.t234 pfet_06v0 ad=0.52p pd=2.52u as=0.52p ps=2.52u w=2u l=1u
X38 GATE DISABLE x2.x3.OUT VDD.t38 pfet_06v0 ad=2.08p pd=8.52u as=3.52p ps=16.88u w=8u l=0.7u
X39 a_12836_251302# PROG.t12 a_14012_250994# VDD.t9 pfet_06v0 ad=1.76p pd=8.88u as=1.76p ps=8.88u w=4u l=1.1u
X40 a_27936_308366# x11.schmitt_0.A VSS.t13 VSS.t143 nfet_06v0 ad=1.76p pd=8.88u as=1.76p ps=8.88u w=4u l=0.7u
X41 a_16905_279559# a_15729_279559# VSS.t76 VSS.t75 nfet_06v0 ad=1.32p pd=6.88u as=1.32p ps=6.88u w=3u l=1.4u
X42 LEN LENb VSS.t10 VSS.t9 nfet_06v0 ad=0.44p pd=2.88u as=0.44p ps=2.88u w=1u l=0.7u
X43 a_5831_36764# a_5831_36764# VDD.t78 VDD.t61 pfet_06v0 ad=2.08p pd=8.52u as=3.52p ps=16.88u w=8u l=0.55u
X44 VDD.t194 HALFBAT a_32580_277758# VDD.t193 pfet_06v0 ad=1.76p pd=8.88u as=1.76p ps=8.88u w=4u l=1.1u
X45 VSS.t262 a_14012_250994# x2.x1.OUT VSS.t48 nfet_06v0 ad=4.16p pd=16.52u as=4.16p ps=16.52u w=16u l=1.4u
X46 a_27906_309737# x11.schmitt_0.A VDD.t101 VDD.t100 pfet_06v0 ad=1.76p pd=8.88u as=1.76p ps=8.88u w=4u l=0.55u
X47 VDD.t89 a_15046_289227# a_15731_288499# VDD.t88 pfet_06v0 ad=3.52p pd=16.88u as=3.52p ps=16.88u w=8u l=1.1u
X48 PROG.t4 x2.x1.OUT VDD.t221 VDD.t220 pfet_06v0 ad=0.52p pd=2.52u as=0.52p ps=2.52u w=2u l=1u
X49 a_28942_249702# DISABLE VDD.t37 VDD.t36 pfet_06v0 ad=1.76p pd=8.88u as=1.76p ps=8.88u w=4u l=0.7u
X50 a_19144_309740# a_19144_309740# VSS.t147 VSS.t146 nfet_06v0 ad=1.32p pd=6.88u as=1.32p ps=6.88u w=3u l=1.4u
X51 VDD.t55 a_4887_251094# a_4887_251094# VDD.t54 pfet_06v0 ad=4.4p pd=20.88u as=4.4p ps=20.88u w=10u l=5u
X52 x1.EN4 S0.t0 VDD.t84 VDD.t83 pfet_06v0 ad=0.88p pd=4.88u as=0.88p ps=4.88u w=2u l=0.55u
X53 x2.x3.MINUS x2.x3.OUT VSS.t204 ppolyf_u_1k_6p0 r_width=1u r_length=10u
X54 VDD.t149 a_21793_252030# a_22478_251302# VDD.t145 pfet_06v0 ad=3.52p pd=16.88u as=3.52p ps=16.88u w=8u l=1.1u
X55 x1.OUT4 a_5044_273700# VSS.t221 ppolyf_u_1k r_width=1u r_length=2u
X56 VDD.t6 LATCH x6.B VDD.t91 pfet_06v0 ad=0.88p pd=4.88u as=0.88p ps=4.88u w=2u l=0.55u
X57 x2.x1.OUT a_14012_250994# VSS.t262 VSS.t46 nfet_06v0 ad=4.16p pd=16.52u as=4.16p ps=16.52u w=16u l=1.4u
X58 x1.EN1 x1.S1N a_25612_286326# VSS.t81 nfet_06v0 ad=0.88p pd=4.88u as=1.96p ps=3.96u w=2u l=0.7u
X59 VDD.t6 LATCH DONEb.t1 VDD.t90 pfet_06v0 ad=3.52p pd=16.88u as=3.52p ps=16.88u w=8u l=0.55u
X60 a_16287_275856# a_16243_275356# a_16243_275356# VSS.t95 nfet_06v0 ad=4.4p pd=20.88u as=4.4p ps=20.88u w=10u l=2.5u
X61 PWRENb.t0 x11.schmitt_0.Y VSS.t253 VSS.t252 nfet_06v0 ad=3.52p pd=16.88u as=2.08p ps=8.52u w=8u l=0.7u
X62 a_25612_286326# x1.S0N VSS.t27 VSS.t26 nfet_06v0 ad=1.96p pd=3.96u as=0.88p ps=4.88u w=2u l=0.7u
X63 x1.EN2 x1.S1N VDD.t43 VDD.t42 pfet_06v0 ad=0.88p pd=4.88u as=0.88p ps=4.88u w=2u l=0.55u
X64 VDD.t93 a_15044_280595# a_15729_279867# VDD.t174 pfet_06v0 ad=3.52p pd=16.88u as=3.52p ps=16.88u w=8u l=1.1u
D4 a_8788_278098# VSS.t256 diode_pd2nw_06v0 pj=12u area=5p
X65 VDD.t239 x2.x1.OUT PROG.t0 VDD.t238 pfet_06v0 ad=0.52p pd=2.52u as=0.52p ps=2.52u w=2u l=1u
X66 VSS.t269 VDD.t128 cap_mim_2f0_m4m5_noshield c_width=25u c_length=25u
X67 GATE a_28942_249702# x2.x3.OUT VSS.t21 nfet_06v0 ad=3.52p pd=16.88u as=2.08p ps=8.52u w=8u l=0.7u
X68 a_14011_309740# a_12835_309740# VSS.t163 VSS.t162 nfet_06v0 ad=1.32p pd=6.88u as=1.32p ps=6.88u w=3u l=1.4u
X69 a_22508_281381# x1.OUT3 VSS.t35 ppolyf_u_1k r_width=1u r_length=2u
X70 VSS.t69 x1.x3.x1.OUT x1.OUT3 VSS.t68 nfet_06v0 ad=1.76p pd=8.88u as=1.04p ps=4.52u w=4u l=0.7u
X71 GATE DISABLE x2.x3.OUT VDD.t38 pfet_06v0 ad=2.08p pd=8.52u as=2.08p ps=8.52u w=8u l=0.7u
X72 RESET x8.schmitt_0.Y VDD.t136 VDD.t137 pfet_06v0 ad=2.08p pd=8.52u as=2.08p ps=8.52u w=8u l=0.55u
X73 a_54864_264981# a_54864_254859# VSS.t91 ppolyf_u_1k_6p0 r_width=1u r_length=50u
X74 VDD.t195 a_5044_273700# VSS.t247 ppolyf_u_1k r_width=1u r_length=2u
X75 LATCH PWRENb.t5 VDD.t156 VDD.t155 pfet_06v0 ad=0.88p pd=4.88u as=0.88p ps=4.88u w=2u l=0.55u
X76 VDD.t152 a_21793_252030# x2.x3.OUT VDD.t151 pfet_06v0 ad=4.16p pd=16.52u as=4.16p ps=16.52u w=16u l=1.1u
X77 VDD.t93 a_7586_279815# a_7634_278670# VDD.t93 pfet_06v0 ad=4.4p pd=20.88u as=4.4p ps=20.88u w=10u l=5u
D5 a_17971_276456# VSS.t178 diode_pd2nw_06v0 pj=12u area=5p
X78 x2.x1.OUT a_12151_252030# VDD.t205 VDD.t204 pfet_06v0 ad=4.16p pd=16.52u as=7.04p ps=32.88u w=16u l=1.1u
X79 x8.schmitt_0.Y x8.schmitt_0.A a_42971_278925# VDD.t191 pfet_06v0 ad=1.76p pd=8.88u as=1.76p ps=8.88u w=4u l=0.55u
X80 VDD.t114 a_18459_310776# a_19144_310048# VDD.t113 pfet_06v0 ad=3.52p pd=16.88u as=3.52p ps=16.88u w=8u l=1.1u
X81 a_19144_310048# OPOUT a_20320_309740# VDD.t45 pfet_06v0 ad=1.76p pd=8.88u as=1.76p ps=8.88u w=4u l=1.1u
X82 a_24723_308864# a_24723_308864# VSS.t13 VSS.t159 nfet_06v0 ad=1.32p pd=6.88u as=1.32p ps=6.88u w=3u l=1.4u
X83 VSS.t195 a_22462_286211# VSS.t5 ppolyf_u_1k r_width=1u r_length=10u
X84 a_22478_251302# x2.x3.MINUS a_22478_250994# VDD.t98 pfet_06v0 ad=1.76p pd=8.88u as=1.76p ps=8.88u w=4u l=1.1u
X85 VDD.t53 WEH a_40856_278332# VDD.t52 pfet_06v0 ad=1.32p pd=6.88u as=1.32p ps=6.88u w=3u l=1.1u
X86 a_6194_285737# x1.x2.R VSS.t43 ppolyf_u_1k r_width=1u r_length=16.21u
X87 x2.x3.OUT a_23654_250994# VSS.t50 VSS.t49 nfet_06v0 ad=4.16p pd=16.52u as=7.04p ps=32.88u w=16u l=1.4u
X88 PROG.t3 x2.x1.OUT VDD.t257 VDD.t256 pfet_06v0 ad=0.52p pd=2.52u as=0.52p ps=2.52u w=2u l=1u
X89 VDD.t112 a_18459_310776# a_18459_310776# VDD.t111 pfet_06v0 ad=1.76p pd=8.88u as=1.76p ps=8.88u w=4u l=1.1u
X90 a_15046_289227# VSS.t170 VSS.t169 ppolyf_u_1k_6p0 r_width=1u r_length=11u
X91 x1.x4.x1.OUT a_8361_273711# VDD.t187 VDD.t186 pfet_06v0 ad=3.52p pd=16.88u as=3.52p ps=16.88u w=8u l=1.1u
D6 a_12420_287622# VSS.t79 diode_pd2nw_06v0 pj=12u area=5p
D7 x1.x1.R x1.x1.x1.OUT diode_pd2nw_06v0 pj=1.8u area=0.2025p
X92 a_16245_283988# a_13869_282343# VDD.t93 VDD.t95 pfet_06v0 ad=4.4p pd=20.88u as=4.4p ps=20.88u w=10u l=5u
X93 OPOUT a_32580_277758# VDD.t181 VDD.t179 pfet_06v0 ad=4.16p pd=16.52u as=4.16p ps=16.52u w=16u l=1.1u
D8 a_16287_275856# VSS.t36 diode_pd2nw_06v0 pj=12u area=5p
X94 VDD.t243 x2.x1.OUT PROG.t5 VDD.t242 pfet_06v0 ad=0.52p pd=2.52u as=0.52p ps=2.52u w=2u l=1u
X95 a_28942_249702# DISABLE VSS.t72 VSS.t71 nfet_06v0 ad=1.76p pd=8.88u as=1.76p ps=8.88u w=4u l=0.7u
X96 x2.x3.PLUS OPOUT VSS.t215 ppolyf_u_1k_6p0 r_width=1u r_length=10u
X97 x1.EN3 S1.t2 VDD.t140 VDD.t139 pfet_06v0 ad=0.88p pd=4.88u as=0.88p ps=4.88u w=2u l=0.55u
X98 VDD.t144 S1.t0 x1.EN4 VDD.t143 pfet_06v0 ad=0.88p pd=4.88u as=0.88p ps=4.88u w=2u l=0.55u
X99 OPOUT a_32580_277758# VDD.t183 VDD.t179 pfet_06v0 ad=4.16p pd=16.52u as=7.04p ps=32.88u w=16u l=1.1u
X100 OPOUT a_32580_277758# VSS.t231 VSS.t229 nfet_06v0 ad=4.16p pd=16.52u as=7.04p ps=32.88u w=16u l=1.4u
X101 a_12151_252030# VSS.t145 VSS.t144 ppolyf_u_1k_6p0 r_width=1u r_length=11u
X102 a_25612_284054# x1.S1N VSS.t83 VSS.t82 nfet_06v0 ad=1.96p pd=3.96u as=0.88p ps=4.88u w=2u l=0.7u
X103 x1.OUT4 x1.x4.x1.OUT VSS.t123 VSS.t122 nfet_06v0 ad=1.04p pd=4.52u as=1.76p ps=8.88u w=4u l=0.7u
X104 a_26682_270558# a_38304_270558# VSS.t6 ppolyf_u_1k_6p0 r_width=1u r_length=57.5u
X105 VSS.t201 x8.schmitt_0.Y RESET VSS.t202 nfet_06v0 ad=2.08p pd=8.52u as=2.08p ps=8.52u w=8u l=0.7u
X106 a_18665_284488# a_16245_283988# a_13869_282343# VSS.t88 nfet_06v0 ad=4.4p pd=20.88u as=4.4p ps=20.88u w=10u l=2.5u
X107 a_7634_278670# a_7634_278670# a_10054_278582# VSS.t52 nfet_06v0 ad=4.4p pd=20.88u as=4.4p ps=20.88u w=10u l=2.5u
D9 a_54864_254859# GATE diode_pd2nw_06v0 pj=1.8u area=0.2025p
X108 VDD.t6 LENb LEN VDD.t8 pfet_06v0 ad=0.44p pd=2.88u as=0.44p ps=2.88u w=1u l=0.55u
X109 a_19144_310048# x5.MINUS a_19144_309740# VDD.t157 pfet_06v0 ad=1.76p pd=8.88u as=1.76p ps=8.88u w=4u l=1.1u
X110 VSS.t8 a_8363_283268# x1.x2.x1.OUT VSS.t7 nfet_06v0 ad=3.52p pd=16.88u as=3.52p ps=16.88u w=8u l=1.4u
X111 VSS.t231 a_32580_277758# OPOUT VSS.t229 nfet_06v0 ad=4.16p pd=16.52u as=4.16p ps=16.52u w=16u l=1.4u
X112 DONEb.t0 LATCH VSS.t127 VSS.t126 nfet_06v0 ad=3.52p pd=16.88u as=3.52p ps=16.88u w=8u l=0.7u
X113 a_12835_310048# x4.VREF a_14011_309740# VDD.t158 pfet_06v0 ad=1.76p pd=8.88u as=1.76p ps=8.88u w=4u l=1.1u
X114 VDD.t1 REFAMP a_25791_309144# VDD.t0 pfet_06v0 ad=1.32p pd=6.88u as=1.32p ps=6.88u w=3u l=1.1u
X115 VSS.t253 x11.schmitt_0.Y PWRENb.t1 VSS.t254 nfet_06v0 ad=2.08p pd=8.52u as=2.08p ps=8.52u w=8u l=0.7u
X116 a_7666_278098# a_8788_278098# VSS.t161 ppolyf_u_1k_6p0 r_width=1u r_length=5u
X117 x6.B RESET VDD.t6 VDD.t117 pfet_06v0 ad=0.88p pd=4.88u as=0.88p ps=4.88u w=2u l=0.55u
X118 VDD.t231 x2.x1.OUT PROG.t2 VDD.t230 pfet_06v0 ad=0.52p pd=2.52u as=0.52p ps=2.52u w=2u l=1u
X119 a_34961_250959# DISABLE VSS.t70 VSS.t21 nfet_06v0 ad=0.44p pd=2.88u as=0.44p ps=2.88u w=1u l=0.7u
X120 a_12150_310776# VSS.t97 VSS.t96 ppolyf_u_1k_6p0 r_width=1u r_length=11u
X121 PROG.t8 x2.x1.OUT VDD.t249 VDD.t248 pfet_06v0 ad=0.52p pd=2.52u as=0.52p ps=2.52u w=2u l=1u
X122 VDD.t203 a_12151_252030# x2.x1.OUT VDD.t202 pfet_06v0 ad=4.16p pd=16.52u as=4.16p ps=16.52u w=16u l=1.1u
X123 VDD.t13 a_25791_309144# x11.schmitt_0.A VDD.t12 pfet_06v0 ad=1.32p pd=6.88u as=1.32p ps=6.88u w=3u l=1.1u
X124 a_4934_308695# a_4934_308695# a_7354_308607# VSS.t158 nfet_06v0 ad=4.4p pd=20.88u as=4.4p ps=20.88u w=10u l=2.5u
X125 PROG.t6 x2.x1.OUT VDD.t217 VDD.t216 pfet_06v0 ad=0.52p pd=2.52u as=0.52p ps=2.52u w=2u l=1u
D10 a_10056_287214# VSS.t89 diode_pd2nw_06v0 pj=12u area=5p
X126 VSS.t116 S0.t5 x1.S0N VSS.t115 nfet_06v0 ad=0.44p pd=2.88u as=0.44p ps=2.88u w=1u l=0.7u
X127 OPOUT a_32580_277758# VSS.t231 VSS.t229 nfet_06v0 ad=4.16p pd=16.52u as=4.16p ps=16.52u w=16u l=1.4u
X128 a_10429_273931# a_8361_273711# VDD.t185 VDD.t184 pfet_06v0 ad=3.52p pd=16.88u as=3.52p ps=16.88u w=8u l=1.1u
X129 x1.x1.x1.OUT a_16907_288191# cap_mim_2f0_m4m5_noshield c_width=5u c_length=5u
X130 CTRLAMP a_20320_309740# cap_mim_2f0_m4m5_noshield c_width=5u c_length=5u
X131 VSS.t45 a_23654_250994# x2.x3.OUT VSS.t44 nfet_06v0 ad=7.04p pd=32.88u as=4.16p ps=16.52u w=16u l=1.4u
X132 a_9719_250269# x2.MINUS VSS.t54 ppolyf_u_1k_6p0 r_width=1u r_length=5u
X133 x5.MINUS CTRLAMP VSS.t258 ppolyf_u_1k_6p0 r_width=1u r_length=50u
X134 x1.OUT1 x1.x1.x1.OUT VSS.t139 VSS.t138 nfet_06v0 ad=1.04p pd=4.52u as=1.76p ps=8.88u w=4u l=0.7u
X135 x1.x4.x2.VREF a_14835_276456# VSS.t18 ppolyf_u_1k_6p0 r_width=1u r_length=5u
X136 a_7588_288447# a_7636_287302# a_7668_286730# VSS.t86 nfet_06v0 ad=4.4p pd=20.88u as=4.4p ps=20.88u w=10u l=2.5u
X137 VDD.t82 S0.t2 x1.EN2 VDD.t81 pfet_06v0 ad=0.88p pd=4.88u as=0.88p ps=4.88u w=2u l=0.55u
X138 x1.x3.x1.OUT a_16905_279559# cap_mim_2f0_m4m5_noshield c_width=5u c_length=5u
X139 a_12836_251302# x2.MINUS a_12836_250994# VDD.t9 pfet_06v0 ad=1.76p pd=8.88u as=1.76p ps=8.88u w=4u l=1.1u
X140 BAT WEH VSS.t155 ppolyf_u_1k_6p0 r_width=1u r_length=60u
X141 a_43001_277554# x8.schmitt_0.A VSS.t167 VSS.t244 nfet_06v0 ad=1.76p pd=8.88u as=1.76p ps=8.88u w=4u l=0.7u
X142 VDD.t72 a_28942_249702# GATE VDD.t69 pfet_06v0 ad=2.08p pd=8.52u as=2.08p ps=8.52u w=8u l=0.7u
X143 VSS.t20 a_8361_273711# VSS.t19 ppolyf_u_1k_6p0 r_width=1u r_length=11u
X144 x2.x1.OUT a_14012_250994# VSS.t264 VSS.t49 nfet_06v0 ad=4.16p pd=16.52u as=7.04p ps=32.88u w=16u l=1.4u
X145 VDD.t116 a_18459_310776# CTRLAMP VDD.t115 pfet_06v0 ad=3.52p pd=16.88u as=3.52p ps=16.88u w=8u l=1.1u
X146 a_42971_278925# x8.schmitt_0.A VDD.t53 VDD.t190 pfet_06v0 ad=1.76p pd=8.88u as=1.76p ps=8.88u w=4u l=0.55u
X147 a_7668_286730# a_8790_286730# VSS.t132 ppolyf_u_1k_6p0 r_width=1u r_length=5u
X148 VSS.t8 a_8363_282343# VSS.t103 ppolyf_u_1k_6p0 r_width=1u r_length=11u
X149 VDD.t136 x8.schmitt_0.Y RESET VDD.t135 pfet_06v0 ad=3.52p pd=16.88u as=2.08p ps=8.52u w=8u l=0.55u
X150 VDD.t119 CEN DISABLE VDD.t118 pfet_06v0 ad=0.88p pd=4.88u as=0.88p ps=4.88u w=2u l=0.55u
X151 VDD.t51 a_7588_288447# x1.x1.x2.VREF VDD.t50 pfet_06v0 ad=4.4p pd=20.88u as=4.4p ps=20.88u w=10u l=5u
X152 a_10431_282563# a_8363_282343# VDD.t68 VDD.t67 pfet_06v0 ad=3.52p pd=16.88u as=3.52p ps=16.88u w=8u l=1.1u
X153 x1.OUT2 x1.EN2 REFOUT VDD.t76 pfet_06v0 ad=1.76p pd=8.88u as=1.76p ps=8.88u w=4u l=0.55u
X154 VDD.t150 a_21793_252030# a_21793_252030# VDD.t145 pfet_06v0 ad=1.76p pd=8.88u as=1.76p ps=8.88u w=4u l=1.1u
X155 a_22462_290353# x1.OUT1 VSS.t23 ppolyf_u_1k r_width=1u r_length=2u
X156 a_6148_277502# x1.x4.R VSS.t221 ppolyf_u_1k r_width=1u r_length=18.4u
X157 VDD.t6 LATCH CEN VDD.t92 pfet_06v0 ad=0.88p pd=4.88u as=0.88p ps=4.88u w=2u l=0.55u
X158 a_23654_250994# a_22478_250994# VSS.t187 VSS.t11 nfet_06v0 ad=1.32p pd=6.88u as=1.32p ps=6.88u w=3u l=1.4u
X159 PROG.t9 x2.x1.OUT VDD.t253 VDD.t252 pfet_06v0 ad=0.52p pd=2.52u as=0.52p ps=2.52u w=2u l=1u
X160 VSS.t113 VDD.t103 cap_mim_2f0_m4m5_noshield c_width=5u c_length=5u
X161 VSS.t113 a_5831_36764# PD.t0 VSS.t112 nfet_06v0 ad=3.52p pd=16.88u as=2.08p ps=8.52u w=8u l=0.7u
X162 a_5090_285737# VSS.t185 VSS.t184 ppolyf_u_1k r_width=1u r_length=10u
X163 x1.OUT1 a_21358_286211# VSS.t57 ppolyf_u_1k r_width=1u r_length=20.1u
X164 a_53474_278076# LEN CEN VSS.t2 nfet_06v0 ad=1.96p pd=3.96u as=0.88p ps=4.88u w=2u l=0.7u
X165 a_4886_309840# a_4934_308695# a_4966_308123# VSS.t157 nfet_06v0 ad=4.4p pd=20.88u as=4.4p ps=20.88u w=10u l=2.5u
X166 x1.x3.x1.OUT a_16905_279559# VSS.t62 VSS.t61 nfet_06v0 ad=3.52p pd=16.88u as=3.52p ps=16.88u w=8u l=1.4u
X167 REFOUT WM VSS.t190 ppolyf_u_1k_6p0 r_width=1u r_length=10u
X168 a_31404_278437# a_31404_278437# VSS.t229 VSS.t235 nfet_06v0 ad=1.32p pd=6.88u as=1.32p ps=6.88u w=3u l=1.4u
X169 a_14012_250994# x2.x1.OUT cap_mim_2f0_m4m5_noshield c_width=5u c_length=5u
X170 VDD.t93 a_7586_279815# a_7586_279815# VDD.t93 pfet_06v0 ad=4.4p pd=20.88u as=4.4p ps=20.88u w=10u l=5u
X171 a_3855_36764# a_3855_36764# VSS.t102 VSS.t100 nfet_06v0 ad=2.08p pd=8.52u as=3.52p ps=16.88u w=8u l=0.7u
X172 VDD.t136 x8.schmitt_0.Y RESET VDD.t138 pfet_06v0 ad=2.08p pd=8.52u as=3.52p ps=16.88u w=8u l=0.55u
X173 PU.t0 a_3855_36764# VDD.t62 VDD.t60 pfet_06v0 ad=2.08p pd=8.52u as=3.52p ps=16.88u w=8u l=0.55u
X174 VSS.t261 a_14012_250994# x2.x1.OUT VSS.t44 nfet_06v0 ad=7.04p pd=32.88u as=4.16p ps=16.52u w=16u l=1.4u
X175 VSS.t268 VDD.t3 cap_mim_2f0_m4m5_noshield c_width=35u c_length=35u
X176 VDD.t227 x2.x1.OUT PROG.t7 VDD.t226 pfet_06v0 ad=0.52p pd=2.52u as=0.52p ps=2.52u w=2u l=1u
X177 a_21793_252030# VSS.t213 VSS.t144 ppolyf_u_1k_6p0 r_width=1u r_length=11u
X178 x10.MINUS VSS.t15 VSS.t14 ppolyf_u_1k_6p0 r_width=1u r_length=10u
X179 x1.x1.x1.OUT a_16907_288191# VSS.t105 VSS.t104 nfet_06v0 ad=3.52p pd=16.88u as=3.52p ps=16.88u w=8u l=1.4u
X180 x1.OUT1 a_25120_285050# REFOUT VSS.t133 nfet_06v0 ad=1.76p pd=8.88u as=1.76p ps=8.88u w=4u l=0.7u
X181 a_15729_279867# x1.x3.x2.VREF a_15729_279559# VDD.t26 pfet_06v0 ad=1.76p pd=8.88u as=1.76p ps=8.88u w=4u l=1.1u
X182 a_23654_250994# x2.x3.OUT cap_mim_2f0_m4m5_noshield c_width=5u c_length=5u
X183 VDD.t59 a_4887_251094# x2.MINUS VDD.t58 pfet_06v0 ad=4.4p pd=20.88u as=4.4p ps=20.88u w=10u l=5u
X184 VDD.t47 a_7588_288447# a_7588_288447# VDD.t46 pfet_06v0 ad=4.4p pd=20.88u as=4.4p ps=20.88u w=10u l=5u
X185 GATE a_28942_249702# x2.x3.OUT VSS.t109 nfet_06v0 ad=2.08p pd=8.52u as=2.08p ps=8.52u w=8u l=0.7u
X186 VDD.t176 a_15044_280595# x1.x3.x1.OUT VDD.t175 pfet_06v0 ad=3.52p pd=16.88u as=3.52p ps=16.88u w=8u l=1.1u
X187 VDD.t259 x2.x1.OUT PROG.t11 VDD.t258 pfet_06v0 ad=0.52p pd=2.52u as=0.88p ps=4.88u w=2u l=1u
X188 x1.EN4 S1.t1 a_25612_279510# VSS.t210 nfet_06v0 ad=0.88p pd=4.88u as=1.96p ps=3.96u w=2u l=0.7u
X189 VSS.t177 x6.B a_47649_278076# VSS.t176 nfet_06v0 ad=0.88p pd=4.88u as=1.96p ps=3.96u w=2u l=0.7u
D11 a_10054_278582# VSS.t227 diode_pd2nw_06v0 pj=12u area=5p
D12 x1.x4.R x1.x4.x1.OUT diode_pd2nw_06v0 pj=1.8u area=0.2025p
D13 a_9719_250269# VSS.t171 diode_pd2nw_06v0 pj=12u area=5p
X190 a_15731_288499# x1.x1.R a_16907_288191# VDD.t14 pfet_06v0 ad=1.76p pd=8.88u as=1.76p ps=8.88u w=4u l=1.1u
X191 a_12420_287622# x1.x1.x2.VREF VSS.t154 ppolyf_u_1k_6p0 r_width=1u r_length=5u
X192 a_7586_279815# a_7634_278670# a_7666_278098# VSS.t51 nfet_06v0 ad=4.4p pd=20.88u as=4.4p ps=20.88u w=10u l=2.5u
X193 PROG.t5 x2.x1.OUT VDD.t245 VDD.t244 pfet_06v0 ad=0.52p pd=2.52u as=0.52p ps=2.52u w=2u l=1u
X194 CHRGb a_34961_250959# VSS.t22 VSS.t21 nfet_06v0 ad=3.52p pd=16.88u as=3.52p ps=16.88u w=8u l=0.7u
X195 x2.x1.OUT x2.x3.PLUS VSS.t21 ppolyf_u_1k_6p0 r_width=1u r_length=10u
X196 VDD.t160 a_4886_309840# a_4934_308695# VDD.t159 pfet_06v0 ad=4.4p pd=20.88u as=4.4p ps=20.88u w=10u l=5u
X197 CTRLAMP a_20320_309740# VSS.t220 VSS.t219 nfet_06v0 ad=3.52p pd=16.88u as=3.52p ps=16.88u w=8u l=1.4u
X198 x1.OUT2 a_25120_282778# REFOUT VSS.t63 nfet_06v0 ad=1.76p pd=8.88u as=1.76p ps=8.88u w=4u l=0.7u
X199 a_25612_279510# S0.t1 VSS.t119 VSS.t118 nfet_06v0 ad=1.96p pd=3.96u as=0.88p ps=4.88u w=2u l=0.7u
D14 x1.x3.R x1.x3.x1.OUT diode_pd2nw_06v0 pj=1.8u area=0.2025p
X200 a_16243_275356# a_13867_273711# VDD.t108 VDD.t107 pfet_06v0 ad=4.4p pd=20.88u as=4.4p ps=20.88u w=10u l=5u
X201 a_22478_251302# x2.x3.PLUS a_23654_250994# VDD.t98 pfet_06v0 ad=1.76p pd=8.88u as=1.76p ps=8.88u w=4u l=1.1u
X202 x11.schmitt_0.Y x11.schmitt_0.A a_27936_308366# VSS.t143 nfet_06v0 ad=1.76p pd=8.88u as=1.76p ps=8.88u w=4u l=0.7u
X203 x1.EN2 S0.t3 a_25612_284054# VSS.t117 nfet_06v0 ad=0.88p pd=4.88u as=1.96p ps=3.96u w=2u l=0.7u
X204 DISABLE CE VDD.t11 VDD.t10 pfet_06v0 ad=0.88p pd=4.88u as=0.88p ps=4.88u w=2u l=0.55u
X205 a_15731_288499# x1.x1.x2.VREF a_15731_288191# VDD.t132 pfet_06v0 ad=1.76p pd=8.88u as=1.76p ps=8.88u w=4u l=1.1u
X206 VSS.t131 LATCH a_53474_278076# VSS.t130 nfet_06v0 ad=0.88p pd=4.88u as=1.96p ps=3.96u w=2u l=0.7u
X207 PWRENb.t3 x11.schmitt_0.Y VDD.t211 VDD.t210 pfet_06v0 ad=2.08p pd=8.52u as=2.08p ps=8.52u w=8u l=0.55u
X208 x1.OUT4 a_25120_278234# REFOUT VSS.t225 nfet_06v0 ad=1.76p pd=8.88u as=1.76p ps=8.88u w=4u l=0.7u
X209 x2.x3.PLUS VSS.t248 cap_mim_2f0_m4m5_noshield c_width=5u c_length=5u
X210 a_12835_310048# x10.MINUS a_12835_309740# VDD.t25 pfet_06v0 ad=1.76p pd=8.88u as=1.76p ps=8.88u w=4u l=1.1u
X211 VSS.t250 x11.schmitt_0.Y a_28712_309737# VDD.t206 pfet_06v0 ad=0.88p pd=4.88u as=0.88p ps=4.88u w=2u l=0.55u
X212 x1.OUT1 x1.EN1 REFOUT VDD.t32 pfet_06v0 ad=1.76p pd=8.88u as=1.76p ps=8.88u w=4u l=0.55u
X213 a_6148_277502# x1.OUT4 VSS.t221 ppolyf_u_1k r_width=1u r_length=18.4u
X214 a_15044_280595# VSS.t62 VSS.t205 ppolyf_u_1k_6p0 r_width=1u r_length=11u
X215 VSS.t1 a_8361_274636# x1.x4.x1.OUT VSS.t0 nfet_06v0 ad=3.52p pd=16.88u as=3.52p ps=16.88u w=8u l=1.4u
X216 VDD.t170 a_12150_310776# REFAMP VDD.t169 pfet_06v0 ad=3.52p pd=16.88u as=3.52p ps=16.88u w=8u l=1.1u
X217 a_5090_285737# x1.x2.R VSS.t173 ppolyf_u_1k r_width=1u r_length=10u
D15 x1.x2.R x1.x2.x1.OUT diode_pd2nw_06v0 pj=1.8u area=0.2025p
X218 x1.x2.x2.VREF a_13869_282343# VDD.t94 VDD.t93 pfet_06v0 ad=4.4p pd=20.88u as=4.4p ps=20.88u w=10u l=5u
X219 VDD.t77 a_5831_36764# a_5831_36764# VDD.t61 pfet_06v0 ad=3.52p pd=16.88u as=2.08p ps=8.52u w=8u l=0.55u
X220 x1.x1.R a_21358_286211# VSS.t57 ppolyf_u_1k r_width=1u r_length=20.1u
D16 VSS.t66 x1.x3.x1.OUT diode_nd2ps_06v0 pj=8u area=4p
X221 VDD.t53 a_40856_278332# x8.schmitt_0.A VDD.t192 pfet_06v0 ad=1.32p pd=6.88u as=1.32p ps=6.88u w=3u l=1.1u
D17 VSS.t120 x1.x4.x1.OUT diode_nd2ps_06v0 pj=8u area=4p
X222 WM a_38304_271110# VSS.t6 ppolyf_u_1k_6p0 r_width=1u r_length=57.5u
X223 VDD.t219 x2.x1.OUT PROG.t4 VDD.t218 pfet_06v0 ad=0.52p pd=2.52u as=0.52p ps=2.52u w=2u l=1u
X224 REFOUT VSS.t42 cap_mim_2f0_m4m5_noshield c_width=10u c_length=10u
X225 a_4967_249377# a_6089_249377# VSS.t189 ppolyf_u_1k_6p0 r_width=1u r_length=5u
X226 a_12836_250994# a_12836_250994# VSS.t193 VSS.t11 nfet_06v0 ad=1.32p pd=6.88u as=1.32p ps=6.88u w=3u l=1.4u
D18 VSS.t136 x1.x1.x1.OUT diode_nd2ps_06v0 pj=8u area=4p
X227 a_5044_277502# VSS.t243 VSS.t3 ppolyf_u_1k r_width=1u r_length=10u
X228 VSS.t198 x8.schmitt_0.Y a_43777_278925# VDD.t133 pfet_06v0 ad=0.88p pd=4.88u as=0.88p ps=4.88u w=2u l=0.55u
X229 a_8363_282343# a_8363_282343# VDD.t64 VDD.t63 pfet_06v0 ad=1.76p pd=8.88u as=1.76p ps=8.88u w=4u l=1.1u
X230 VDD.t53 REFOUT a_39788_278052# VDD.t99 pfet_06v0 ad=1.32p pd=6.88u as=1.32p ps=6.88u w=3u l=1.1u
X231 a_18663_275856# a_16243_275356# a_13867_273711# VSS.t95 nfet_06v0 ad=4.4p pd=20.88u as=4.4p ps=20.88u w=10u l=2.5u
X232 a_47649_278076# PWRENb.t4 LATCH VSS.t211 nfet_06v0 ad=1.96p pd=3.96u as=0.88p ps=4.88u w=2u l=0.7u
X233 a_18459_310776# VSS.t217 VSS.t216 ppolyf_u_1k_6p0 r_width=1u r_length=11u
X234 BAT HALFBAT VSS.t226 ppolyf_u_1k_6p0 r_width=1u r_length=40u
X235 VSS.t129 LATCH a_51049_278076# VSS.t128 nfet_06v0 ad=0.88p pd=4.88u as=1.96p ps=3.96u w=2u l=0.7u
X236 VDD.t164 a_4886_309840# a_4886_309840# VDD.t163 pfet_06v0 ad=4.4p pd=20.88u as=4.4p ps=20.88u w=10u l=5u
X237 VSS.t42 a_22508_278263# VSS.t242 ppolyf_u_1k r_width=1u r_length=10u
X238 WEH VSS.t17 VSS.t16 ppolyf_u_1k_6p0 r_width=1u r_length=80u
X239 x1.OUT4 x1.EN4 REFOUT VDD.t122 pfet_06v0 ad=1.76p pd=8.88u as=1.76p ps=8.88u w=4u l=0.55u
D19 a_8790_286730# VSS.t259 diode_pd2nw_06v0 pj=12u area=5p
X240 a_22462_290353# VDD.t17 VSS.t23 ppolyf_u_1k r_width=1u r_length=2u
X241 CEN LEN VDD.t6 VDD.t5 pfet_06v0 ad=0.88p pd=4.88u as=0.88p ps=4.88u w=2u l=0.55u
X242 a_40856_278332# a_39788_278052# VSS.t167 VSS.t168 nfet_06v0 ad=1.32p pd=6.88u as=1.32p ps=6.88u w=3u l=1.4u
X243 x2.x3.OUT a_28942_249702# GATE VSS.t108 nfet_06v0 ad=2.08p pd=8.52u as=2.08p ps=8.52u w=8u l=0.7u
X244 a_5044_277502# x1.x4.R VSS.t3 ppolyf_u_1k r_width=1u r_length=10u
X245 x1.x3.R a_21404_278263# VSS.t234 ppolyf_u_1k r_width=1u r_length=9.98u
X246 PROG.t10 x2.x1.OUT VDD.t237 VDD.t236 pfet_06v0 ad=0.52p pd=2.52u as=0.52p ps=2.52u w=2u l=1u
X247 x2.x3.OUT DISABLE GATE VDD.t38 pfet_06v0 ad=2.08p pd=8.52u as=2.08p ps=8.52u w=8u l=0.7u
X248 VDD.t125 a_7586_279815# x1.x3.x2.VREF VDD.t93 pfet_06v0 ad=4.4p pd=20.88u as=4.4p ps=20.88u w=10u l=5u
X249 x1.OUT3 x1.x3.x1.OUT VSS.t65 VSS.t64 nfet_06v0 ad=1.04p pd=4.52u as=1.76p ps=8.88u w=4u l=0.7u
X250 VDD.t255 x2.x1.OUT PROG.t3 VDD.t254 pfet_06v0 ad=0.52p pd=2.52u as=0.52p ps=2.52u w=2u l=1u
X251 a_25612_281782# S1.t3 VSS.t209 VSS.t208 nfet_06v0 ad=1.96p pd=3.96u as=0.88p ps=4.88u w=2u l=0.7u
X252 VSS.t59 a_10653_275509# a_8361_274636# VSS.t58 nfet_06v0 ad=1.32p pd=6.88u as=1.32p ps=6.88u w=3u l=1.4u
X253 a_25791_309144# a_24723_308864# VSS.t13 VSS.t159 nfet_06v0 ad=1.32p pd=6.88u as=1.32p ps=6.88u w=3u l=1.4u
X254 VDD.t178 WM a_31404_278437# VDD.t177 pfet_06v0 ad=1.76p pd=8.88u as=1.76p ps=8.88u w=4u l=1.1u
X255 a_8361_274636# x1.x4.R a_10429_273931# VDD.t171 pfet_06v0 ad=1.76p pd=8.88u as=1.76p ps=8.88u w=4u l=1.1u
X256 VDD.t223 x2.x1.OUT PROG.t1 VDD.t222 pfet_06v0 ad=0.52p pd=2.52u as=0.52p ps=2.52u w=2u l=1u
X257 VDD.t70 a_28942_249702# GATE VDD.t69 pfet_06v0 ad=3.52p pd=16.88u as=2.08p ps=8.52u w=8u l=0.7u
X258 VSS.t181 a_10655_284141# a_8363_283268# VSS.t180 nfet_06v0 ad=1.32p pd=6.88u as=1.32p ps=6.88u w=3u l=1.4u
X259 x1.OUT3 a_25120_280506# REFOUT VSS.t218 nfet_06v0 ad=1.76p pd=8.88u as=1.76p ps=8.88u w=4u l=0.7u
X260 VDD.t134 x8.schmitt_0.Y a_43001_277554# VSS.t199 nfet_06v0 ad=0.88p pd=4.88u as=0.88p ps=4.88u w=2u l=0.7u
X261 PROG.t0 x2.x1.OUT VDD.t241 VDD.t240 pfet_06v0 ad=0.52p pd=2.52u as=0.52p ps=2.52u w=2u l=1u
D20 a_7355_249861# VSS.t98 diode_pd2nw_06v0 pj=12u area=5p
X262 a_4966_308123# a_6088_308123# VSS.t214 ppolyf_u_1k_6p0 r_width=1u r_length=5u
X263 x11.schmitt_0.A a_25791_309144# VSS.t13 VSS.t12 nfet_06v0 ad=1.32p pd=6.88u as=1.32p ps=6.88u w=3u l=1.4u
X264 VSS.t42 x1.EN1 a_25120_285050# VSS.t41 nfet_06v0 ad=0.44p pd=2.88u as=0.44p ps=2.88u w=1u l=0.7u
X265 a_8363_283268# x1.x2.R a_10431_282563# VDD.t33 pfet_06v0 ad=1.76p pd=8.88u as=1.76p ps=8.88u w=4u l=1.1u
D21 VSS.t237 x1.x2.x1.OUT diode_nd2ps_06v0 pj=8u area=4p
X266 VDD.t31 x1.EN1 a_25120_285050# VDD.t30 pfet_06v0 ad=0.44p pd=2.88u as=0.44p ps=2.88u w=1u l=0.55u
X267 a_17973_285088# a_18665_284488# VSS.t186 ppolyf_u_1k_6p0 r_width=1u r_length=5u
X268 x1.OUT3 a_21404_278263# VSS.t234 ppolyf_u_1k r_width=1u r_length=9.98u
X269 VDD.t142 S1.t4 x1.S1N VDD.t141 pfet_06v0 ad=0.44p pd=2.88u as=0.44p ps=2.88u w=1u l=0.55u
D22 a_14837_285088# VSS.t24 diode_pd2nw_06v0 pj=12u area=5p
X270 x2.x3.MINUS VSS.t192 VSS.t191 ppolyf_u_1k_6p0 r_width=1u r_length=10u
X271 a_13869_282343# a_13869_282343# VDD.t97 VDD.t96 pfet_06v0 ad=4.4p pd=20.88u as=4.4p ps=20.88u w=10u l=5u
X272 a_51049_278076# RESET x6.B VSS.t152 nfet_06v0 ad=1.96p pd=3.96u as=0.88p ps=4.88u w=2u l=0.7u
X273 REFAMP a_14011_309740# cap_mim_2f0_m4m5_noshield c_width=5u c_length=5u
X274 a_20320_309740# a_19144_309740# VSS.t149 VSS.t148 nfet_06v0 ad=1.32p pd=6.88u as=1.32p ps=6.88u w=3u l=1.4u
X275 a_15729_279559# a_15729_279559# VSS.t78 VSS.t77 nfet_06v0 ad=1.32p pd=6.88u as=1.32p ps=6.88u w=3u l=1.4u
X276 PROG.t7 x2.x1.OUT VDD.t229 VDD.t228 pfet_06v0 ad=0.52p pd=2.52u as=0.52p ps=2.52u w=2u l=1u
X277 VDD.t16 a_34961_250959# CHRGb VDD.t15 pfet_06v0 ad=3.52p pd=16.88u as=3.52p ps=16.88u w=8u l=0.55u
X278 REFAMP a_14011_309740# VSS.t107 VSS.t106 nfet_06v0 ad=3.52p pd=16.88u as=3.52p ps=16.88u w=8u l=1.4u
X279 VDD.t19 x1.S0N x1.EN3 VDD.t18 pfet_06v0 ad=0.88p pd=4.88u as=0.88p ps=4.88u w=2u l=0.55u
X280 a_17971_276456# a_18663_275856# VSS.t3 ppolyf_u_1k_6p0 r_width=1u r_length=5u
X281 x1.x2.x1.OUT a_8363_283268# cap_mim_2f0_m4m5_noshield c_width=5u c_length=5u
X282 x1.x4.x1.OUT a_8361_274636# cap_mim_2f0_m4m5_noshield c_width=5u c_length=5u
X283 a_7636_287302# a_7636_287302# a_10056_287214# VSS.t87 nfet_06v0 ad=4.4p pd=20.88u as=4.4p ps=20.88u w=10u l=2.5u
X284 HALFBAT VSS.t56 VSS.t55 ppolyf_u_1k_6p0 r_width=1u r_length=40u
X285 VDD.t215 x2.x1.OUT PROG.t6 VDD.t214 pfet_06v0 ad=0.88p pd=4.88u as=0.52p ps=2.52u w=2u l=1u
X286 VSS.t267 VDD.t22 cap_mim_2f0_m4m5_noshield c_width=100u c_length=100u
D23 a_12418_278990# VSS.t222 diode_pd2nw_06v0 pj=12u area=5p
X287 VSS.t42 x1.EN4 a_25120_278234# VSS.t156 nfet_06v0 ad=0.44p pd=2.88u as=0.44p ps=2.88u w=1u l=0.7u
X288 VSS.t101 a_3855_36764# a_3855_36764# VSS.t100 nfet_06v0 ad=3.52p pd=16.88u as=2.08p ps=8.52u w=8u l=0.7u
X289 x2.x3.OUT a_21793_252030# VDD.t148 VDD.t147 pfet_06v0 ad=4.16p pd=16.52u as=4.16p ps=16.52u w=16u l=1.1u
X290 VDD.t213 x11.schmitt_0.Y PWRENb.t2 VDD.t212 pfet_06v0 ad=2.08p pd=8.52u as=3.52p ps=16.88u w=8u l=0.55u
X291 VDD.t207 x11.schmitt_0.Y a_27936_308366# VSS.t251 nfet_06v0 ad=0.88p pd=4.88u as=0.88p ps=4.88u w=2u l=0.7u
X292 x1.OUT3 x1.EN3 REFOUT VDD.t29 pfet_06v0 ad=1.76p pd=8.88u as=1.76p ps=8.88u w=4u l=0.55u
X293 VDD.t121 x1.EN4 a_25120_278234# VDD.t120 pfet_06v0 ad=0.44p pd=2.88u as=0.44p ps=2.88u w=1u l=0.55u
D24 a_6089_249377# VSS.t174 diode_pd2nw_06v0 pj=12u area=5p
X294 VSS.t125 x1.x4.x1.OUT x1.OUT4 VSS.t124 nfet_06v0 ad=1.76p pd=8.88u as=1.04p ps=4.52u w=4u l=0.7u
X295 GATE a_28942_249702# VDD.t73 VDD.t69 pfet_06v0 ad=2.08p pd=8.52u as=3.52p ps=16.88u w=8u l=0.7u
X296 x5.MINUS VSS.t85 VSS.t84 ppolyf_u_1k_6p0 r_width=1u r_length=10u
X297 VDD.t47 a_15046_289227# x1.x1.x1.OUT VDD.t87 pfet_06v0 ad=3.52p pd=16.88u as=3.52p ps=16.88u w=8u l=1.1u
X298 a_15731_288191# a_15731_288191# VSS.t32 VSS.t31 nfet_06v0 ad=1.32p pd=6.88u as=1.32p ps=6.88u w=3u l=1.4u
X299 VDD.t86 a_15046_289227# a_15046_289227# VDD.t85 pfet_06v0 ad=1.76p pd=8.88u as=1.76p ps=8.88u w=4u l=1.1u
X300 a_15729_279867# x1.x3.R a_16905_279559# VDD.t44 pfet_06v0 ad=1.76p pd=8.88u as=1.76p ps=8.88u w=4u l=1.1u
X301 a_16289_284488# a_16245_283988# a_16245_283988# VSS.t88 nfet_06v0 ad=4.4p pd=20.88u as=4.4p ps=20.88u w=10u l=2.5u
X302 a_12835_309740# a_12835_309740# VSS.t165 VSS.t164 nfet_06v0 ad=1.32p pd=6.88u as=1.32p ps=6.88u w=3u l=1.4u
D25 a_9718_309015# VSS.t196 diode_pd2nw_06v0 pj=12u area=5p
X303 a_16907_288191# a_15731_288191# VSS.t34 VSS.t33 nfet_06v0 ad=1.32p pd=6.88u as=1.32p ps=6.88u w=3u l=1.4u
X304 x1.EN1 x1.S0N VDD.t21 VDD.t20 pfet_06v0 ad=0.88p pd=4.88u as=0.88p ps=4.88u w=2u l=0.55u
X305 VDD.t127 CTRLAMP a_24723_308864# VDD.t126 pfet_06v0 ad=1.32p pd=6.88u as=1.32p ps=6.88u w=3u l=1.1u
X306 VSS.t141 x1.x1.x1.OUT x1.OUT1 VSS.t140 nfet_06v0 ad=1.76p pd=8.88u as=1.04p ps=4.52u w=4u l=0.7u
X307 VSS.t241 x1.x2.x1.OUT x1.OUT2 VSS.t240 nfet_06v0 ad=1.76p pd=8.88u as=1.04p ps=4.52u w=4u l=0.7u
X308 VSS.t42 x1.EN2 a_25120_282778# VSS.t111 nfet_06v0 ad=0.44p pd=2.88u as=0.44p ps=2.88u w=1u l=0.7u
X309 VDD.t173 a_15044_280595# a_15044_280595# VDD.t172 pfet_06v0 ad=1.76p pd=8.88u as=1.76p ps=8.88u w=4u l=1.1u
X310 x1.OUT2 a_5090_282373# VSS.t43 ppolyf_u_1k r_width=1u r_length=2u
X311 x1.x4.x2.VREF a_13867_273711# VDD.t106 VDD.t105 pfet_06v0 ad=4.4p pd=20.88u as=4.4p ps=20.88u w=10u l=5u
X312 VSS.t70 CEN a_33989_250071# VSS.t11 nfet_06v0 ad=0.88p pd=4.88u as=1.96p ps=3.96u w=2u l=0.7u
X313 VDD.t35 DISABLE a_34961_250959# VDD.t34 pfet_06v0 ad=0.44p pd=2.88u as=0.44p ps=2.88u w=1u l=0.55u
X314 VDD.t75 x1.EN2 a_25120_282778# VDD.t74 pfet_06v0 ad=0.44p pd=2.88u as=0.44p ps=2.88u w=1u l=0.55u
X315 PROG.t2 x2.x1.OUT VDD.t233 VDD.t232 pfet_06v0 ad=0.52p pd=2.52u as=0.52p ps=2.52u w=2u l=1u
X316 GATE a_28942_249702# VDD.t71 VDD.t69 pfet_06v0 ad=2.08p pd=8.52u as=2.08p ps=8.52u w=8u l=0.7u
X317 VDD.t251 x2.x1.OUT PROG.t9 VDD.t250 pfet_06v0 ad=0.52p pd=2.52u as=0.52p ps=2.52u w=2u l=1u
X318 a_8361_273711# a_8361_273711# VDD.t189 VDD.t188 pfet_06v0 ad=1.76p pd=8.88u as=1.76p ps=8.88u w=4u l=1.1u
X319 a_22508_281381# VDD.t24 VSS.t35 ppolyf_u_1k r_width=1u r_length=2u
X320 x2.x1.OUT a_12151_252030# VDD.t201 VDD.t200 pfet_06v0 ad=4.16p pd=16.52u as=4.16p ps=16.52u w=16u l=1.1u
X321 a_9718_309015# x4.VREF VSS.t212 ppolyf_u_1k_6p0 r_width=1u r_length=5u
X322 VDD.t168 a_12150_310776# a_12835_310048# VDD.t167 pfet_06v0 ad=3.52p pd=16.88u as=3.52p ps=16.88u w=8u l=1.1u
X323 VDD.t80 S0.t4 x1.S0N VDD.t79 pfet_06v0 ad=0.44p pd=2.88u as=0.44p ps=2.88u w=1u l=0.55u
X324 a_32580_277758# a_31404_278437# VSS.t229 VSS.t235 nfet_06v0 ad=1.32p pd=6.88u as=1.32p ps=6.88u w=3u l=1.4u
X325 x8.schmitt_0.Y x8.schmitt_0.A a_43001_277554# VSS.t245 nfet_06v0 ad=1.76p pd=8.88u as=1.76p ps=8.88u w=4u l=0.7u
X326 a_54864_275577# a_54864_264981# VSS.t91 ppolyf_u_1k_6p0 r_width=1u r_length=50u
X327 VDD.t49 a_7588_288447# a_7636_287302# VDD.t48 pfet_06v0 ad=4.4p pd=20.88u as=4.4p ps=20.88u w=10u l=5u
D26 a_17973_285088# VSS.t150 diode_pd2nw_06v0 pj=12u area=5p
X328 OPOUT a_38304_270558# VSS.t38 ppolyf_u_1k_6p0 r_width=1u r_length=57.5u
X329 VDD.t198 a_12151_252030# a_12836_251302# VDD.t196 pfet_06v0 ad=3.52p pd=16.88u as=3.52p ps=16.88u w=8u l=1.1u
X330 x1.x3.R a_22508_278263# VSS.t242 ppolyf_u_1k r_width=1u r_length=10u
X331 BAT a_54864_275577# VSS.t91 ppolyf_u_1k_6p0 r_width=1u r_length=50u
X332 a_22478_250994# a_22478_250994# VSS.t188 VSS.t11 nfet_06v0 ad=1.32p pd=6.88u as=1.32p ps=6.88u w=3u l=1.4u
X333 VDD.t166 a_12150_310776# a_12150_310776# VDD.t165 pfet_06v0 ad=1.76p pd=8.88u as=1.76p ps=8.88u w=4u l=1.1u
X334 VDD.t146 a_21793_252030# x2.x3.OUT VDD.t145 pfet_06v0 ad=7.04p pd=32.88u as=4.16p ps=16.52u w=16u l=1.1u
X335 x11.schmitt_0.Y x11.schmitt_0.A a_27906_309737# VDD.t102 pfet_06v0 ad=1.76p pd=8.88u as=1.76p ps=8.88u w=4u l=0.55u
X336 x1.EN3 x1.S0N a_25612_281782# VSS.t28 nfet_06v0 ad=0.88p pd=4.88u as=1.96p ps=3.96u w=2u l=0.7u
X337 VDD.t61 a_3855_36764# PU.t0 VDD.t60 pfet_06v0 ad=3.52p pd=16.88u as=2.08p ps=8.52u w=8u l=0.55u
X338 VDD.t197 a_12151_252030# a_12151_252030# VDD.t196 pfet_06v0 ad=1.76p pd=8.88u as=1.76p ps=8.88u w=4u l=1.1u
X339 PROG.t1 x2.x1.OUT VDD.t225 VDD.t224 pfet_06v0 ad=0.52p pd=2.52u as=0.52p ps=2.52u w=2u l=1u
X340 VDD.t41 x1.S1N x1.EN1 VDD.t40 pfet_06v0 ad=0.88p pd=4.88u as=0.88p ps=4.88u w=2u l=0.55u
X341 VSS.t40 x1.EN3 a_25120_280506# VSS.t39 nfet_06v0 ad=0.44p pd=2.88u as=0.44p ps=2.88u w=1u l=0.7u
X342 RESET x8.schmitt_0.Y VSS.t201 VSS.t202 nfet_06v0 ad=2.08p pd=8.52u as=3.52p ps=16.88u w=8u l=0.7u
X343 a_14012_250994# a_12836_250994# VSS.t194 VSS.t11 nfet_06v0 ad=1.32p pd=6.88u as=1.32p ps=6.88u w=3u l=1.4u
X344 x1.x1.R a_22462_286211# VSS.t5 ppolyf_u_1k r_width=1u r_length=10u
X345 VDD.t28 x1.EN3 a_25120_280506# VDD.t27 pfet_06v0 ad=0.44p pd=2.88u as=0.44p ps=2.88u w=1u l=0.55u
R0 PD.n10 PD.n1 54.9632
R1 PD.n5 PD 49.9364
R2 PD.n7 PD.n6 45.3235
R3 PD.n6 PD.n5 45.3219
R4 PD.n10 PD.t0 32.8056
R5 PD.n8 PD.n7 26.5698
R6 PD.n9 PD.n0 24.3294
R7 PD.n3 PD.n9 18.4135
R8 PD.n4 PD.n8 18.4135
R9 PD.n2 PD.n11 18.4119
R10 PD.n11 PD.n10 14.6898
R11 PD.n12 PD 5.45066
R12 PD PD.n12 4.61655
R13 PD.n2 PD 4.61655
R14 PD.n2 PD 4.61655
R15 PD.n11 PD 4.61655
R16 PD.n1 PD 4.61655
R17 PD.n1 PD 4.61655
R18 PD.n3 PD 4.61655
R19 PD.n3 PD 4.61655
R20 PD.n9 PD 4.61655
R21 PD.n0 PD 4.61655
R22 PD.n0 PD 4.61655
R23 PD.n4 PD 4.61655
R24 PD.n4 PD 4.61655
R25 PD.n8 PD 4.61655
R26 PD.n7 PD 4.61655
R27 PD.n6 PD 4.61655
R28 PD.n5 PD 4.61655
R29 PD.n0 PD.n4 2.57996
R30 PD.n1 PD.n3 2.57836
R31 PD.n12 PD.n2 1.74586
R32 PU.n5 PU.n4 76.8348
R33 PU.n0 PU 50.0706
R34 PU.n5 PU.n3 45.3235
R35 PU.n1 PU.n0 45.3235
R36 PU.n2 PU.n1 45.3219
R37 PU.n4 PU.t0 31.1917
R38 PU.n3 PU.n2 24.6959
R39 PU.n4 PU 18.5561
R40 PU PU.n5 4.74918
R41 PU.n3 PU 4.74918
R42 PU.n2 PU 4.74918
R43 PU.n1 PU 4.74918
R44 PU.n0 PU 4.74918
R45 PROG.n0 PROG.t12 40.929
R46 PROG PROG.n1 15.8534
R47 PROG.n0 PROG.t11 3.8699
R48 PROG.n1 PROG.t6 2.8012
R49 PROG.n1 PROG.t4 2.8012
R50 PROG.n1 PROG.t1 2.8012
R51 PROG.n1 PROG.t7 2.8012
R52 PROG.n1 PROG.t2 2.8012
R53 PROG.n1 PROG.t10 2.8012
R54 PROG.n0 PROG.t0 2.8012
R55 PROG.n0 PROG.t5 2.8012
R56 PROG.n0 PROG.t8 2.8012
R57 PROG.n0 PROG.t9 2.8012
R58 PROG.n0 PROG.t3 2.8012
R59 PROG.n1 PROG.n0 1.50794
R60 DONEb DONEb.n0 290.293
R61 DONEb.n0 DONEb.t1 2.97601
R62 DONEb.n0 DONEb.t0 2.83463
R63 S1 S1.n0 130.685
R64 S1.n1 S1.t0 30.5819
R65 S1.n2 S1.t2 30.5671
R66 S1.n0 S1.t4 22.8804
R67 S1.n0 S1.t5 21.0723
R68 S1.n3 S1.n1 13.3366
R69 S1.n1 S1.t1 12.7383
R70 S1.n2 S1.t3 12.7381
R71 S1.n0 S1.n3 12.2933
R72 S1.n3 S1.n2 1.63407
R73 S0 S0.n0 76.3054
R74 S0.n2 S0.t2 30.5819
R75 S0.n1 S0.t0 30.5671
R76 S0.n0 S0.t4 22.8789
R77 S0.n0 S0.t5 21.2036
R78 S0.n3 S0.n1 19.1069
R79 S0.n2 S0.t3 12.7383
R80 S0.n1 S0.t1 12.7381
R81 S0.n3 S0.n2 10.9934
R82 S0.n0 S0.n3 9.04525
R83 PWRENb PWRENb.n2 329.079
R84 PWRENb.n2 PWRENb.n0 72.2501
R85 PWRENb.n1 PWRENb.t5 30.5819
R86 PWRENb.n1 PWRENb.t4 12.7383
R87 PWRENb.n2 PWRENb.n1 4.70505
R88 PWRENb.n0 PWRENb.t0 2.32738
R89 PWRENb.n0 PWRENb.t2 2.28715
R90 PWRENb.n0 PWRENb.t3 2.22981
R91 PWRENb.n0 PWRENb.t1 2.20527
R92 VDD.n269 VDD.t34 2618.32
R93 VDD.t61 VDD.n31 1.10603
R94 VDD.t15 VDD.t34 2112.85
R95 VDD.t193 VDD.t179 1835.47
R96 VDD.t95 VDD.n6 1.23508
R97 VDD.t163 VDD.t159 1495.28
R98 VDD.t161 VDD.t159 1495.28
R99 VDD.t107 VDD.t105 1495.28
R100 VDD.t107 VDD.t109 1495.28
R101 VDD.t48 VDD.t46 1495.28
R102 VDD.t48 VDD.t50 1495.28
R103 VDD.t54 VDD.t56 1495.28
R104 VDD.t58 VDD.t56 1495.28
R105 VDD.n62 VDD.t90 1464.91
R106 VDD.t172 VDD.n4 0.5733
R107 VDD.t63 VDD.n21 0.573219
R108 VDD.t188 VDD.t105 1288.45
R109 VDD.t50 VDD.t85 1288.45
R110 VDD.t38 VDD.t69 1190.7
R111 VDD.t161 VDD.t165 1166.37
R112 VDD.t90 VDD.n205 1162.28
R113 VDD.n479 VDD.n303 1006.4
R114 VDD.n477 VDD.t58 790.434
R115 VDD.t99 VDD.t52 750.769
R116 VDD.t192 VDD.t52 750.769
R117 VDD.t126 VDD.t0 750.769
R118 VDD.t12 VDD.t0 750.769
R119 VDD.n480 VDD.n177 698.601
R120 VDD.t177 VDD.t193 683.721
R121 VDD.n276 VDD.t38 616.279
R122 VDD.t174 VDD.t26 563.324
R123 VDD.t67 VDD.t39 563.324
R124 VDD.t113 VDD.t157 563.324
R125 VDD.t25 VDD.t167 563.324
R126 VDD.t184 VDD.t2 563.324
R127 VDD.t132 VDD.t88 563.324
R128 VDD.n197 VDD.t8 532.242
R129 VDD.n323 VDD.n177 527.14
R130 VDD.n499 VDD.n498 447.075
R131 VDD.n17 VDD.t192 409.522
R132 VDD.t12 VDD.n139 409.522
R133 VDD.t190 VDD.t191 382.623
R134 VDD.t102 VDD.t100 382.623
R135 VDD.t44 VDD.n369 375.932
R136 VDD.n395 VDD.t33 375.932
R137 VDD.t45 VDD.n135 375.932
R138 VDD.n636 VDD.t158 375.932
R139 VDD.n447 VDD.t171 375.932
R140 VDD.n607 VDD.t14 375.932
R141 VDD.t172 VDD.t26 339.829
R142 VDD.t63 VDD.t39 339.829
R143 VDD.t111 VDD.t157 339.829
R144 VDD.t25 VDD.t165 339.829
R145 VDD.t188 VDD.t2 339.829
R146 VDD.t132 VDD.t85 339.829
R147 VDD.t258 VDD.t256 333.334
R148 VDD.t254 VDD.t252 333.334
R149 VDD.t252 VDD.t250 333.334
R150 VDD.t250 VDD.t248 333.334
R151 VDD.t248 VDD.t246 333.334
R152 VDD.t246 VDD.t244 333.334
R153 VDD.t244 VDD.t242 333.334
R154 VDD.t242 VDD.t240 333.334
R155 VDD.t240 VDD.t238 333.334
R156 VDD.t238 VDD.t236 333.334
R157 VDD.t236 VDD.t234 333.334
R158 VDD.t234 VDD.t232 333.334
R159 VDD.t232 VDD.t230 333.334
R160 VDD.t230 VDD.t228 333.334
R161 VDD.t228 VDD.t226 333.334
R162 VDD.t226 VDD.t224 333.334
R163 VDD.t224 VDD.t222 333.334
R164 VDD.t222 VDD.t220 333.334
R165 VDD.t220 VDD.t218 333.334
R166 VDD.t218 VDD.t216 333.334
R167 VDD.t216 VDD.t214 333.334
R168 VDD.n480 VDD.t258 325.462
R169 VDD.t214 VDD.n177 325.462
R170 VDD.n54 VDD.t92 276.12
R171 VDD.t155 VDD.n243 276.12
R172 VDD.n0 VDD.t91 276.12
R173 VDD.t10 VDD.n270 276.12
R174 VDD.n197 VDD.t5 275.219
R175 VDD.t5 VDD.n196 275.219
R176 VDD.n196 VDD.t92 275.219
R177 VDD.n244 VDD.t155 275.219
R178 VDD.n244 VDD.t130 275.219
R179 VDD.t130 VDD.n205 275.219
R180 VDD.n62 VDD.t117 275.219
R181 VDD.n250 VDD.t117 275.219
R182 VDD.t91 VDD.n250 275.219
R183 VDD.n271 VDD.t10 275.219
R184 VDD.n271 VDD.t118 275.219
R185 VDD.t118 VDD.n269 275.219
R186 VDD.n375 VDD.n371 220.15
R187 VDD.n396 VDD.n394 220.15
R188 VDD.n608 VDD.n579 220.15
R189 VDD.n616 VDD.n7 220.15
R190 VDD.n637 VDD.n122 220.15
R191 VDD.n448 VDD.n446 220.15
R192 VDD.n242 VDD.n241 212.653
R193 VDD.n150 VDD.n147 212.653
R194 VDD.t256 VDD.n479 209.43
R195 VDD.n292 VDD.n280 196.875
R196 VDD.n330 VDD.n324 196.875
R197 VDD.n494 VDD.t79 194.802
R198 VDD.n33 VDD.t122 193.65
R199 VDD.n498 VDD.t141 193.226
R200 VDD.t141 VDD.n497 193.226
R201 VDD.n497 VDD.t79 193.226
R202 VDD.t122 VDD.n570 193.077
R203 VDD.n570 VDD.t120 193.077
R204 VDD.t120 VDD.n569 193.077
R205 VDD.t83 VDD.n485 193.077
R206 VDD.n536 VDD.t83 193.077
R207 VDD.t143 VDD.n536 193.077
R208 VDD.n537 VDD.t143 193.077
R209 VDD.t29 VDD.n538 193.077
R210 VDD.n539 VDD.t29 193.077
R211 VDD.n539 VDD.t27 193.077
R212 VDD.t27 VDD.n527 193.077
R213 VDD.t139 VDD.n546 193.077
R214 VDD.n547 VDD.t139 193.077
R215 VDD.n547 VDD.t18 193.077
R216 VDD.t18 VDD.n526 193.077
R217 VDD.t76 VDD.n513 193.077
R218 VDD.n518 VDD.t76 193.077
R219 VDD.t74 VDD.n518 193.077
R220 VDD.n519 VDD.t74 193.077
R221 VDD.n520 VDD.t42 193.077
R222 VDD.n556 VDD.t42 193.077
R223 VDD.t81 VDD.n556 193.077
R224 VDD.n557 VDD.t81 193.077
R225 VDD.n558 VDD.t32 193.077
R226 VDD.n562 VDD.t32 193.077
R227 VDD.t30 VDD.n562 193.077
R228 VDD.n563 VDD.t30 193.077
R229 VDD.n504 VDD.t20 193.077
R230 VDD.n500 VDD.t20 193.077
R231 VDD.n500 VDD.t40 193.077
R232 VDD.t40 VDD.n499 193.077
R233 VDD.n17 VDD.t190 191.311
R234 VDD.t191 VDD.n227 191.311
R235 VDD.n227 VDD.t133 191.311
R236 VDD.n241 VDD.t133 191.311
R237 VDD.t100 VDD.n139 191.311
R238 VDD.n149 VDD.t102 191.311
R239 VDD.t206 VDD.n149 191.311
R240 VDD.n150 VDD.t206 191.311
R241 VDD.n483 VDD.n171 187.608
R242 VDD.n483 VDD.n172 176.925
R243 VDD.n339 VDD.n332 176.925
R244 VDD.n276 VDD.t36 154.651
R245 VDD.n292 VDD.n279 153.3
R246 VDD.n324 VDD.n178 153.3
R247 VDD.n339 VDD.n323 153.3
R248 VDD.t36 VDD.n179 148.256
R249 VDD.n561 VDD.n559 140.525
R250 VDD.n517 VDD.n515 140.525
R251 VDD.n540 VDD.n531 140.525
R252 VDD.n33 VDD.n53 140.525
R253 VDD.n7 VDD.t115 140.506
R254 VDD.n637 VDD.t169 140.506
R255 VDD.n675 VDD.n674 126.507
R256 VDD.n215 VDD.n216 123.989
R257 VDD.n11 VDD.t208 116.65
R258 VDD.n478 VDD.t254 122.808
R259 VDD.n664 VDD.n111 122.62
R260 VDD.n476 VDD.n306 122.48
R261 VDD.n616 VDD.n135 119.892
R262 VDD.n636 VDD.n122 119.892
R263 VDD.t138 VDD.n216 116.32
R264 VDD.n215 VDD.t135 116.32
R265 VDD.n463 VDD.n307 115.501
R266 VDD.n471 VDD.n462 115.501
R267 VDD.t93 VDD.n5 167.411
R268 VDD.n6 VDD.t93 0.00186171
R269 VDD.n112 VDD.n110 115.501
R270 VDD.n659 VDD.n653 115.501
R271 VDD.n417 VDD.n416 115.501
R272 VDD.n414 VDD.n413 115.501
R273 VDD.n593 VDD.n591 115.501
R274 VDD.n600 VDD.n590 115.501
R275 VDD.n538 VDD.n537 112.308
R276 VDD.n526 VDD.n513 112.308
R277 VDD.n558 VDD.n557 112.308
R278 VDD.t44 VDD.t174 110.603
R279 VDD.t67 VDD.t33 110.603
R280 VDD.t45 VDD.t113 110.603
R281 VDD.t158 VDD.t167 110.603
R282 VDD.t184 VDD.t171 110.603
R283 VDD.t14 VDD.t88 110.603
R284 VDD.n312 VDD.n305 109.695
R285 VDD.n665 VDD.n109 109.695
R286 VDD.n467 VDD.n462 103.951
R287 VDD.n464 VDD.n462 103.951
R288 VDD.n464 VDD.n463 103.951
R289 VDD.n463 VDD.n305 103.951
R290 VDD.n471 VDD.n470 103.951
R291 VDD.n472 VDD.n471 103.951
R292 VDD.n472 VDD.n307 103.951
R293 VDD.n476 VDD.n307 103.951
R294 VDD.t95 VDD.n5 103.951
R295 VDD.n370 VDD.n5 103.951
R296 VDD.n656 VDD.n653 103.951
R297 VDD.n654 VDD.n653 103.951
R298 VDD.n654 VDD.n110 103.951
R299 VDD.n665 VDD.n110 103.951
R300 VDD.n659 VDD.n658 103.951
R301 VDD.n660 VDD.n659 103.951
R302 VDD.n660 VDD.n112 103.951
R303 VDD.n664 VDD.n112 103.951
R304 VDD.n104 VDD.n414 103.951
R305 VDD.n424 VDD.n414 103.951
R306 VDD.n424 VDD.n416 103.951
R307 VDD.n103 VDD.n416 103.951
R308 VDD.n436 VDD.n413 103.951
R309 VDD.n423 VDD.n413 103.951
R310 VDD.n423 VDD.n417 103.951
R311 VDD.n419 VDD.n417 103.951
R312 VDD.n102 VDD.n593 103.951
R313 VDD.n598 VDD.n593 103.951
R314 VDD.n598 VDD.n590 103.951
R315 VDD.n44 VDD.n590 103.951
R316 VDD.n597 VDD.n591 103.951
R317 VDD.n599 VDD.n591 103.951
R318 VDD.n600 VDD.n599 103.951
R319 VDD.n601 VDD.n600 103.951
R320 VDD.n371 VDD.t175 103.746
R321 VDD.t65 VDD.n394 103.746
R322 VDD.t186 VDD.n446 103.746
R323 VDD.t87 VDD.n579 103.746
R324 VDD.n20 VDD.n362 102.144
R325 VDD.n63 VDD.n359 102.144
R326 VDD.n626 VDD.n625 102.144
R327 VDD.n432 VDD.n409 102.144
R328 VDD.n42 VDD.n588 102.144
R329 VDD.n481 VDD.n175 99.0416
R330 VDD.t135 VDD.t137 98.8914
R331 VDD.t208 VDD.t210 98.8914
R332 VDD.n377 VDD.n368 98.7005
R333 VDD.n387 VDD.n386 98.7005
R334 VDD.n582 VDD.n581 98.7005
R335 VDD.n622 VDD.n133 98.7005
R336 VDD.n124 VDD.n123 98.7005
R337 VDD.n444 VDD.n443 98.7005
R338 VDD.n224 VDD.n223 96.6005
R339 VDD.n145 VDD.n144 96.6005
R340 VDD.n173 VDD.n172 95.8079
R341 VDD.n333 VDD.n332 95.8079
R342 VDD.t53 VDD.n223 92.2255
R343 VDD.n144 VDD.n143 92.2255
R344 VDD.n569 VDD.n485 90.7697
R345 VDD.n546 VDD.n527 90.7697
R346 VDD.n520 VDD.n519 90.7697
R347 VDD.n563 VDD.n504 90.7697
R348 VDD.n389 VDD.n359 89.863
R349 VDD.n441 VDD.n409 89.863
R350 VDD.n379 VDD.n362 89.7755
R351 VDD.n625 VDD.n624 89.7755
R352 VDD.n648 VDD.n117 89.7755
R353 VDD.n603 VDD.n588 89.7755
R354 VDD.n275 VDD.n187 89.4255
R355 VDD.n33 VDD.n484 89.0755
R356 VDD.n375 VDD.n369 88.5376
R357 VDD.n396 VDD.n395 88.5376
R358 VDD.n448 VDD.n447 88.5376
R359 VDD.n608 VDD.n607 88.5376
R360 VDD.n174 VDD.n173 86.4505
R361 VDD.n336 VDD.n333 86.4505
R362 VDD.n372 VDD.n361 86.4505
R363 VDD.n373 VDD.n372 86.4505
R364 VDD.n373 VDD.n371 86.4505
R365 VDD.n375 VDD.n374 86.4505
R366 VDD.n394 VDD.n354 86.4505
R367 VDD.n22 VDD.n354 86.4505
R368 VDD.n22 VDD.n353 86.4505
R369 VDD.n396 VDD.n358 86.4505
R370 VDD.n596 VDD.n595 86.4505
R371 VDD.n595 VDD.n594 86.4505
R372 VDD.n594 VDD.n579 86.4505
R373 VDD.n608 VDD.n580 86.4505
R374 VDD.n613 VDD.n129 86.4505
R375 VDD.n614 VDD.n613 86.4505
R376 VDD.n614 VDD.n7 86.4505
R377 VDD.n616 VDD.n615 86.4505
R378 VDD.n640 VDD.n639 86.4505
R379 VDD.n639 VDD.n638 86.4505
R380 VDD.n638 VDD.n637 86.4505
R381 VDD.n122 VDD.n121 86.4505
R382 VDD.n446 VDD.n403 86.4505
R383 VDD.n454 VDD.n403 86.4505
R384 VDD.n454 VDD.n402 86.4505
R385 VDD.n448 VDD.n445 86.4505
R386 VDD.n98 VDD.n670 86.4505
R387 VDD.n671 VDD.n670 86.4505
R388 VDD.t60 VDD.n31 0.499012
R389 VDD.n248 VDD.n207 83.3005
R390 VDD.n248 VDD.n203 83.3005
R391 VDD.n212 VDD.n206 83.3005
R392 VDD.n206 VDD.n204 83.3005
R393 VDD.n265 VDD.n48 83.3005
R394 VDD.n99 VDD.n192 83.3005
R395 VDD.n47 VDD.n189 83.3005
R396 VDD.n275 VDD.n189 83.3005
R397 VDD.n278 VDD.n186 83.3005
R398 VDD.n192 VDD.n186 83.3005
R399 VDD.n264 VDD.n46 83.3005
R400 VDD.n228 VDD.n225 82.3905
R401 VDD.n58 VDD.n225 18.2408
R402 VDD.n161 VDD.n137 82.3905
R403 VDD.n10 VDD.n137 82.3905
R404 VDD.n242 VDD.t138 81.3314
R405 VDD.n147 VDD.t212 81.3314
R406 VDD.n337 VDD.n312 78.7505
R407 VDD.n641 VDD.n109 78.7505
R408 VDD.n54 VDD.n56 74.7255
R409 VDD.n54 VDD.n55 74.7255
R410 VDD.n240 VDD.n217 74.7255
R411 VDD.n240 VDD.n218 74.7255
R412 VDD.n243 VDD.n213 74.7255
R413 VDD.n243 VDD.n211 74.7255
R414 VDD.n0 VDD.n200 74.7255
R415 VDD.n0 VDD.n201 74.7255
R416 VDD.n268 VDD.n260 74.7255
R417 VDD.n270 VDD.n261 74.7255
R418 VDD.n270 VDD.n260 74.7255
R419 VDD.n8 VDD.n142 74.7255
R420 VDD.n8 VDD.n146 74.7255
R421 VDD.n223 VDD.n217 72.6255
R422 VDD.n542 VDD.n530 72.6255
R423 VDD.n525 VDD.n524 72.6255
R424 VDD.n505 VDD.n491 72.6255
R425 VDD.n144 VDD.n142 72.6255
R426 VDD.n492 VDD.n28 71.5755
R427 VDD.n502 VDD.n28 71.5755
R428 VDD.n225 VDD.n224 68.6005
R429 VDD.n145 VDD.n137 68.6005
R430 VDD.n533 VDD.n532 64.3441
R431 VDD.n545 VDD.n511 64.3441
R432 VDD.n521 VDD.n508 64.3441
R433 VDD.n503 VDD.n502 64.3441
R434 VDD.n55 VDD.n194 63.1755
R435 VDD.n211 VDD.n207 63.1755
R436 VDD.n495 VDD.n164 62.8255
R437 VDD.n493 VDD.n164 62.8255
R438 VDD.n494 VDD.n493 62.8255
R439 VDD.n495 VDD.n494 62.8255
R440 VDD.n568 VDD.n484 62.8255
R441 VDD.n543 VDD.n542 62.8255
R442 VDD.n524 VDD.n516 62.8255
R443 VDD.n564 VDD.n491 62.8255
R444 VDD.n262 VDD.n261 62.6505
R445 VDD.n560 VDD.n490 62.3005
R446 VDD.n523 VDD.n522 62.3005
R447 VDD.n541 VDD.n528 62.3005
R448 VDD.n487 VDD.n486 62.3005
R449 VDD.n203 VDD.n200 62.1405
R450 VDD.n290 VDD.n280 57.0066
R451 VDD.n330 VDD.n329 57.0066
R452 VDD.n670 VDD.n31 99.4939
R453 VDD.n287 VDD.n285 55.69
R454 VDD.n192 VDD.n189 55.3005
R455 VDD.n508 VDD.n505 54.368
R456 VDD.n509 VDD.n505 54.368
R457 VDD.n525 VDD.n511 54.368
R458 VDD.n525 VDD.n512 54.368
R459 VDD.n533 VDD.n530 54.368
R460 VDD.n534 VDD.n530 54.368
R461 VDD.n327 VDD.n306 52.8479
R462 VDD.n492 VDD.n490 52.6814
R463 VDD.n522 VDD.n509 52.6814
R464 VDD.n528 VDD.n512 52.6814
R465 VDD.n534 VDD.n487 52.6814
R466 VDD.n289 VDD.n287 51.4505
R467 VDD.n290 VDD.n289 51.4505
R468 VDD.n481 VDD.n174 51.4505
R469 VDD.n327 VDD.n325 51.4505
R470 VDD.n329 VDD.n325 51.4505
R471 VDD.n337 VDD.n336 51.4505
R472 VDD.n20 VDD.n361 51.4505
R473 VDD.n379 VDD.n378 51.4505
R474 VDD.n378 VDD.n377 51.4505
R475 VDD.n63 VDD.n353 51.4505
R476 VDD.n388 VDD.n387 51.4505
R477 VDD.n389 VDD.n388 51.4505
R478 VDD.n603 VDD.n586 51.4505
R479 VDD.n586 VDD.n581 51.4505
R480 VDD.n42 VDD.n596 51.4505
R481 VDD.n626 VDD.n129 51.4505
R482 VDD.n624 VDD.n623 51.4505
R483 VDD.n623 VDD.n622 51.4505
R484 VDD.n641 VDD.n640 51.4505
R485 VDD.n648 VDD.n116 51.4505
R486 VDD.n123 VDD.n116 51.4505
R487 VDD.n432 VDD.n402 51.4505
R488 VDD.n443 VDD.n442 51.4505
R489 VDD.n442 VDD.n441 51.4505
R490 VDD.n259 VDD.n258 51.4505
R491 VDD.n64 VDD.n259 51.4505
R492 VDD.n86 VDD.n253 51.4505
R493 VDD.n65 VDD.n253 51.4505
R494 VDD.n560 VDD.n491 50.4005
R495 VDD.n524 VDD.n523 50.4005
R496 VDD.n542 VDD.n541 50.4005
R497 VDD.n486 VDD.n484 50.4005
R498 VDD.n226 VDD.n218 48.3005
R499 VDD.n148 VDD.n146 48.3005
R500 VDD.n323 VDD.n178 47.9774
R501 VDD.n232 VDD.n229 47.2505
R502 VDD.n237 VDD.n231 47.2505
R503 VDD.n289 VDD.n288 47.2505
R504 VDD.n284 VDD.n174 47.2505
R505 VDD.n325 VDD.n315 47.2505
R506 VDD.n336 VDD.n335 47.2505
R507 VDD.n374 VDD.n373 47.2505
R508 VDD.n378 VDD.n367 47.2505
R509 VDD.n358 VDD.n354 47.2505
R510 VDD.n380 VDD.n353 47.2505
R511 VDD.n388 VDD.n355 47.2505
R512 VDD.n365 VDD.n361 47.2505
R513 VDD.n586 VDD.n584 47.2505
R514 VDD.n596 VDD.n585 47.2505
R515 VDD.n594 VDD.n580 47.2505
R516 VDD.n615 VDD.n614 47.2505
R517 VDD.n623 VDD.n132 47.2505
R518 VDD.n130 VDD.n129 47.2505
R519 VDD.n638 VDD.n121 47.2505
R520 VDD.n118 VDD.n116 47.2505
R521 VDD.n640 VDD.n119 47.2505
R522 VDD.n140 VDD.n138 47.2505
R523 VDD.n156 VDD.n154 47.2505
R524 VDD.n445 VDD.n403 47.2505
R525 VDD.n428 VDD.n402 47.2505
R526 VDD.n442 VDD.n404 47.2505
R527 VDD.n259 VDD.n253 47.2505
R528 VDD.n263 VDD.n262 44.013
R529 VDD.n266 VDD.n262 44.013
R530 VDD.n224 VDD.n218 43.9255
R531 VDD.n146 VDD.n145 43.9255
R532 VDD.n347 VDD.t196 43.7148
R533 VDD.n338 VDD.t196 43.7148
R534 VDD.n182 VDD.t145 43.7148
R535 VDD.n482 VDD.t145 43.7148
R536 VDD.t9 VDD.t202 42.8576
R537 VDD.n237 VDD.n236 42.7005
R538 VDD.n16 VDD.n237 42.7005
R539 VDD.n16 VDD.n229 42.7005
R540 VDD.n238 VDD.n229 42.7005
R541 VDD.n235 VDD.n231 42.7005
R542 VDD.n233 VDD.n231 42.7005
R543 VDD.n233 VDD.n232 42.7005
R544 VDD.n232 VDD.n228 42.7005
R545 VDD.n76 VDD.n154 42.7005
R546 VDD.n9 VDD.n154 42.7005
R547 VDD.n9 VDD.n138 42.7005
R548 VDD.n10 VDD.n138 42.7005
R549 VDD.n156 VDD.n155 42.7005
R550 VDD.n157 VDD.n156 42.7005
R551 VDD.n157 VDD.n140 42.7005
R552 VDD.n161 VDD.n140 42.7005
R553 VDD.n56 VDD.n193 40.7755
R554 VDD.n213 VDD.n212 40.7755
R555 VDD.n204 VDD.n201 40.7755
R556 VDD.n328 VDD.t204 40.2862
R557 VDD.n291 VDD.t153 40.2862
R558 VDD.n187 VDD.n171 40.2505
R559 VDD.n279 VDD.n278 40.2505
R560 VDD.t98 VDD.n283 36.8576
R561 VDD.n501 VDD.n492 33.9505
R562 VDD.n502 VDD.n501 33.9505
R563 VDD.n555 VDD.n509 33.9505
R564 VDD.n555 VDD.n508 33.9505
R565 VDD.n548 VDD.n512 33.9505
R566 VDD.n548 VDD.n511 33.9505
R567 VDD.n535 VDD.n534 33.9505
R568 VDD.n535 VDD.n533 33.9505
R569 VDD.n312 VDD.n306 33.9093
R570 VDD.n195 VDD.n56 30.8005
R571 VDD.n195 VDD.n55 30.8005
R572 VDD.n245 VDD.n213 30.8005
R573 VDD.n245 VDD.n211 30.8005
R574 VDD.n249 VDD.n201 30.8005
R575 VDD.n249 VDD.n200 30.8005
R576 VDD.n272 VDD.n261 30.8005
R577 VDD.n272 VDD.n260 30.8005
R578 VDD.n480 VDD.n178 30.8005
R579 VDD.n282 VDD.n279 28.7168
R580 VDD.n282 VDD.n171 28.7168
R581 VDD.n363 VDD.n362 26.7755
R582 VDD.n625 VDD.n128 26.7755
R583 VDD.n643 VDD.n117 26.7755
R584 VDD.n588 VDD.n587 26.7755
R585 VDD.n360 VDD.n359 26.688
R586 VDD.n429 VDD.n409 26.688
R587 VDD.n278 VDD.n277 25.7255
R588 VDD.n277 VDD.n187 25.7255
R589 VDD.n496 VDD.n495 25.2005
R590 VDD.n496 VDD.n493 25.2005
R591 VDD.n143 VDD.n137 23.6255
R592 VDD.n478 VDD.t200 23.1434
R593 VDD.t147 VDD.n179 23.1434
R594 VDD.n303 VDD.n302 22.1434
R595 VDD.n198 VDD.n194 22.0505
R596 VDD.n57 VDD.n193 22.0505
R597 VDD.n264 VDD.n263 22.0505
R598 VDD.n266 VDD.n265 22.0505
R599 VDD.n265 VDD.n264 21.963
R600 VDD.t115 VDD.n135 20.6143
R601 VDD.t169 VDD.n636 20.6143
R602 VDD.n348 VDD.n312 20.2916
R603 VDD.t137 VDD.n242 17.5606
R604 VDD.n147 VDD.t210 17.5606
R605 VDD.n1 VDD.n193 16.9755
R606 VDD.n212 VDD.n208 16.9755
R607 VDD.n559 VDD.n505 16.4505
R608 VDD.n525 VDD.n515 16.4505
R609 VDD.n531 VDD.n530 16.4505
R610 VDD.n408 VDD.t195 15.7647
R611 VDD.n374 VDD.n368 15.5189
R612 VDD.n386 VDD.n358 15.5189
R613 VDD.n582 VDD.n580 15.5189
R614 VDD.n615 VDD.n133 15.5189
R615 VDD.n124 VDD.n121 15.5189
R616 VDD.n445 VDD.n444 15.5189
R617 VDD.t175 VDD.n369 15.2083
R618 VDD.n395 VDD.t65 15.2083
R619 VDD.n447 VDD.t186 15.2083
R620 VDD.n607 VDD.t87 15.2083
R621 VDD.n4 VDD.n363 14.7005
R622 VDD.n393 VDD.n360 14.7005
R623 VDD.n627 VDD.n128 14.7005
R624 VDD.n644 VDD.n643 14.7005
R625 VDD.n431 VDD.n429 14.7005
R626 VDD.n587 VDD.n40 14.7005
R627 VDD.t93 VDD.t24 14.3467
R628 VDD.n87 VDD.t31 4.48003
R629 VDD.n181 VDD.n172 13.4789
R630 VDD.n332 VDD.n331 13.4789
R631 VDD.n226 VDD.n217 13.3005
R632 VDD.n148 VDD.n142 13.3005
R633 VDD.n577 VDD.t17 13.0867
R634 VDD.n478 VDD.n477 13.0005
R635 VDD.n111 VDD.n109 12.5096
R636 VDD.n268 VDD.n262 12.0755
R637 VDD.n66 VDD.n252 10.3802
R638 VDD.n151 VDD.t207 10.035
R639 VDD.n301 VDD.n181 9.58547
R640 VDD.n331 VDD.n314 9.58547
R641 VDD.n298 VDD.n15 9.34137
R642 VDD.n321 VDD.n311 9.34137
R643 VDD.n69 VDD.t93 0.515691
R644 VDD.n4 VDD.t93 0.39102
R645 VDD.n612 VDD.n127 9.34137
R646 VDD.n646 VDD.n642 9.34137
R647 VDD.n406 VDD.n401 9.34137
R648 VDD.n477 VDD.n304 9.28621
R649 VDD.n288 VDD.n180 9.07991
R650 VDD.n334 VDD.n315 9.07991
R651 VDD.n367 VDD.n366 9.07991
R652 VDD.n376 VDD.n368 9.07991
R653 VDD.n386 VDD.n356 9.07991
R654 VDD.n381 VDD.n355 9.07991
R655 VDD.n39 VDD.n584 9.07991
R656 VDD.n606 VDD.n582 9.07991
R657 VDD.n132 VDD.n131 9.07991
R658 VDD.n621 VDD.n133 9.07991
R659 VDD.n647 VDD.n118 9.07991
R660 VDD.n635 VDD.n124 9.07991
R661 VDD.n444 VDD.n405 9.07991
R662 VDD.n427 VDD.n404 9.07991
R663 VDD.n285 VDD.n284 8.44682
R664 VDD.n335 VDD.n313 8.44682
R665 VDD.n365 VDD.n363 8.44682
R666 VDD.n380 VDD.n360 8.44682
R667 VDD.n587 VDD.n585 8.44682
R668 VDD.n130 VDD.n128 8.44682
R669 VDD.n643 VDD.n119 8.44682
R670 VDD.n429 VDD.n428 8.44682
R671 VDD.n391 VDD.n390 8.43717
R672 VDD.n30 VDD.t103 6.77319
R673 VDD.n288 VDD.n183 6.09976
R674 VDD.n346 VDD.n315 6.09976
R675 VDD.n29 VDD.n367 6.09976
R676 VDD.n399 VDD.n355 6.09976
R677 VDD.n584 VDD.n583 6.09976
R678 VDD.n136 VDD.n132 6.09976
R679 VDD.n125 VDD.n118 6.09976
R680 VDD.n453 VDD.n404 6.09976
R681 VDD.n283 VDD.t151 6.0005
R682 VDD.n34 VDD.n50 5.95175
R683 VDD.n61 VDD.n204 5.8205
R684 VDD.n503 VDD.n490 5.65982
R685 VDD.n522 VDD.n521 5.65982
R686 VDD.n545 VDD.n528 5.65982
R687 VDD.n532 VDD.n487 5.65982
R688 VDD.n458 VDD.n457 5.14104
R689 VDD.n1 VDD.n194 4.988
R690 VDD.n208 VDD.n207 4.988
R691 VDD.t22 VDD.t6 4.96013
R692 VDD.n574 VDD.n162 4.79862
R693 VDD.n667 VDD.n43 4.72572
R694 VDD.n391 VDD.n382 4.56268
R695 VDD.n15 VDD.t3 4.49684
R696 VDD.n25 VDD.t80 4.47606
R697 VDD.n50 VDD.t35 4.47606
R698 VDD.n90 VDD.t75 4.48003
R699 VDD.n94 VDD.t28 4.48003
R700 VDD.n97 VDD.t121 4.48003
R701 VDD.n26 VDD.t142 4.4205
R702 VDD.n280 VDD.n181 4.22775
R703 VDD.n331 VDD.n330 4.22775
R704 VDD.n610 VDD.n38 3.79062
R705 VDD.n328 VDD.n324 3.60407
R706 VDD.n292 VDD.n291 3.60407
R707 VDD.n117 VDD.n111 3.52677
R708 VDD.t204 VDD.t9 3.42907
R709 VDD.t153 VDD.t98 3.42907
R710 VDD.n457 VDD.n456 3.3755
R711 VDD.n251 VDD.n162 3.18618
R712 VDD.n668 VDD.n667 3.1675
R713 VDD.n611 VDD.n106 3.13983
R714 VDD.n392 VDD.n391 3.02674
R715 VDD.n11 VDD.t211 3.01851
R716 VDD.n301 VDD.n183 2.98065
R717 VDD.n346 VDD.n314 2.98065
R718 VDD.n2 VDD.n29 0.255387
R719 VDD.n399 VDD.n356 2.98065
R720 VDD.n606 VDD.n583 2.98065
R721 VDD.n621 VDD.n136 2.98065
R722 VDD.n635 VDD.n125 2.98065
R723 VDD.n453 VDD.n405 2.98065
R724 VDD.n385 VDD.n384 2.93679
R725 VDD.n313 VDD.n306 2.84261
R726 VDD.n59 VDD.n592 1.2611
R727 VDD.n23 VDD.t93 0.710624
R728 VDD.n466 VDD.n461 2.63398
R729 VDD.n474 VDD.n460 2.63398
R730 VDD.n655 VDD.n652 2.63398
R731 VDD.n662 VDD.n108 2.63398
R732 VDD.n421 VDD.n415 2.63398
R733 VDD.n426 VDD.n412 2.63398
R734 VDD.n347 VDD.t200 2.57193
R735 VDD.n182 VDD.t147 2.57193
R736 VDD.n255 VDD.t181 2.50762
R737 VDD.n341 VDD.t201 2.37275
R738 VDD.n294 VDD.t148 2.37275
R739 VDD.n273 VDD.t71 2.3699
R740 VDD.n469 VDD.n468 2.34772
R741 VDD.n657 VDD.t164 2.34772
R742 VDD.n70 VDD.t93 1.09934
R743 VDD.n67 VDD.n364 2.30137
R744 VDD.n390 VDD.n385 2.30137
R745 VDD.n602 VDD.n589 2.30137
R746 VDD.n134 VDD.n126 2.30137
R747 VDD.n649 VDD.n115 2.30137
R748 VDD.n440 VDD.n407 2.30137
R749 VDD.n3 VDD.n364 2.25833
R750 VDD.n589 VDD.n578 2.25833
R751 VDD.n618 VDD.n134 2.25833
R752 VDD.n633 VDD.n115 2.25833
R753 VDD.n450 VDD.n407 2.25833
R754 VDD.n319 VDD.t215 2.238
R755 VDD.n50 VDD.t11 2.238
R756 VDD.n267 VDD.t119 2.238
R757 VDD.n72 VDD.t21 2.2105
R758 VDD.n91 VDD.t43 2.2105
R759 VDD.n506 VDD.t82 2.2105
R760 VDD.n544 VDD.t140 2.2105
R761 VDD.n514 VDD.t19 2.2105
R762 VDD.n35 VDD.t84 2.2105
R763 VDD.n529 VDD.t144 2.2105
R764 VDD.t212 VDD.n11 117.32
R765 VDD.n318 VDD.t217 2.00485
R766 VDD.n15 VDD.t221 2.00485
R767 VDD.n15 VDD.t225 2.00485
R768 VDD.n15 VDD.t229 2.00485
R769 VDD.n15 VDD.t233 2.00485
R770 VDD.n15 VDD.t237 2.00485
R771 VDD.n15 VDD.t241 2.00485
R772 VDD.n15 VDD.t245 2.00485
R773 VDD.n15 VDD.t249 2.00485
R774 VDD.n15 VDD.t253 2.00485
R775 VDD.n15 VDD.t257 2.00485
R776 VDD.n400 VDD.n43 1.99895
R777 VDD.t128 VDD.n610 1.90423
R778 VDD.n457 VDD.n400 1.83628
R779 VDD.n167 VDD.n166 1.76067
R780 VDD.n74 VDD.n572 1.75978
R781 VDD.n209 VDD.n202 1.71823
R782 VDD.n61 VDD.n203 1.7105
R783 VDD.n610 VDD.n609 1.688
R784 VDD.n28 VDD.n164 1.61729
R785 VDD.n420 VDD.n38 1.61677
R786 VDD.n285 VDD.n175 1.59208
R787 VDD.n348 VDD.n313 1.59208
R788 VDD.n198 VDD.t6 1.5755
R789 VDD.n266 VDD.t34 1.5755
R790 VDD.n50 VDD.n266 1.5755
R791 VDD.n263 VDD.t34 1.5755
R792 VDD.n494 VDD.n25 1.5755
R793 VDD.n498 VDD.n164 1.5755
R794 VDD.n497 VDD.n496 1.5755
R795 VDD.n496 VDD.n26 1.5755
R796 VDD.n569 VDD.n568 1.5755
R797 VDD.n568 VDD.n96 1.5755
R798 VDD.n543 VDD.n527 1.5755
R799 VDD.n95 VDD.n543 1.5755
R800 VDD.n519 VDD.n516 1.5755
R801 VDD.n516 VDD.n92 1.5755
R802 VDD.n564 VDD.n563 1.5755
R803 VDD.n88 VDD.n564 1.5755
R804 VDD.t47 VDD.n51 0.542037
R805 VDD.n439 VDD.n438 1.53754
R806 VDD.n57 VDD.n199 1.52159
R807 VDD.n199 VDD.n198 1.52159
R808 VDD.n611 VDD.t128 1.51872
R809 VDD.n11 VDD.t13 1.49211
R810 VDD.n11 VDD.t1 1.49211
R811 VDD.n11 VDD.t127 1.49211
R812 VDD.n191 VDD.n190 1.47253
R813 VDD.n49 VDD.n191 1.47253
R814 VDD.n440 VDD.n439 1.37979
R815 VDD.n672 VDD.n60 0.714976
R816 VDD.n214 VDD.n219 1.30462
R817 VDD.n286 VDD.n184 1.27568
R818 VDD.n326 VDD.n316 1.27568
R819 VDD.n341 VDD.n340 1.26277
R820 VDD.n663 VDD.n651 1.2627
R821 VDD.n475 VDD.n308 1.24391
R822 VDD.n576 VDD.n66 1.2344
R823 VDD.n629 VDD.n126 1.22612
R824 VDD.n83 VDD.n93 1.21608
R825 VDD.n80 VDD.n89 1.21608
R826 VDD.n34 VDD.n169 1.21527
R827 VDD.n60 VDD.t61 0.505892
R828 VDD.n398 VDD.n397 1.12607
R829 VDD.t93 VDD.t64 1.11918
R830 VDD.n66 VDD.t178 1.11918
R831 VDD.n66 VDD.t194 1.11918
R832 VDD.t47 VDD.t86 1.11918
R833 VDD.n650 VDD.n649 1.10985
R834 VDD.n11 VDD.n611 1.10974
R835 VDD.n234 VDD.n52 0.614759
R836 VDD.t53 VDD.n230 1.10789
R837 VDD.n11 VDD.n68 0.440135
R838 VDD.n159 VDD.n11 1.10789
R839 VDD.n66 VDD.n64 0.8318
R840 VDD.n220 VDD.n221 1.10593
R841 VDD.n152 VDD.n141 1.10593
R842 VDD.n309 VDD.t197 1.1055
R843 VDD.t93 VDD.t173 1.1055
R844 VDD.n433 VDD.t189 1.1055
R845 VDD.n15 VDD.t150 1.1055
R846 VDD.n281 VDD.t37 1.1055
R847 VDD.n479 VDD.n478 1.09699
R848 VDD.n169 VDD.n163 1.09198
R849 VDD.n320 VDD.n319 1.06657
R850 VDD.t53 VDD.n52 0.45414
R851 VDD.n561 VDD.n560 1.0505
R852 VDD.n523 VDD.n517 1.0505
R853 VDD.n541 VDD.n540 1.0505
R854 VDD.n486 VDD.n53 1.0505
R855 VDD.n77 VDD.n71 1.04709
R856 VDD.n80 VDD.n489 1.03746
R857 VDD.n83 VDD.n488 1.03746
R858 VDD.n36 VDD.n53 0.616702
R859 VDD.n263 VDD.n50 1.81451
R860 VDD.t6 VDD.n202 1.02292
R861 VDD.n68 VDD.n155 0.871749
R862 VDD.n220 VDD.n239 0.977643
R863 VDD.n153 VDD.n152 0.977643
R864 VDD.n293 VDD.n185 0.963719
R865 VDD.n317 VDD.n176 0.963719
R866 VDD.n219 VDD.n210 0.954896
R867 VDD.n50 VDD.n46 0.875932
R868 VDD.n50 VDD.n49 0.952364
R869 VDD.t131 VDD.n208 0.95193
R870 VDD.n418 VDD.n38 0.942756
R871 VDD.n23 VDD.n392 1.13837
R872 VDD.n392 VDD.n357 0.932916
R873 VDD.t217 VDD.t219 0.9105
R874 VDD.t221 VDD.t223 0.9105
R875 VDD.t225 VDD.t227 0.9105
R876 VDD.t229 VDD.t231 0.9105
R877 VDD.t233 VDD.t235 0.9105
R878 VDD.t237 VDD.t239 0.9105
R879 VDD.t241 VDD.t243 0.9105
R880 VDD.t245 VDD.t247 0.9105
R881 VDD.t249 VDD.t251 0.9105
R882 VDD.t253 VDD.t255 0.9105
R883 VDD.t257 VDD.t259 0.9105
R884 VDD.t6 VDD.n0 0.9005
R885 VDD.n1 VDD.n197 0.9005
R886 VDD.n196 VDD.n195 0.9005
R887 VDD.n250 VDD.n249 0.9005
R888 VDD.n61 VDD.n62 0.9005
R889 VDD.n208 VDD.n205 0.9005
R890 VDD.n245 VDD.n244 0.9005
R891 VDD.n246 VDD.n245 0.9005
R892 VDD.n243 VDD.t156 0.9005
R893 VDD.n241 VDD.n240 0.9005
R894 VDD.n240 VDD.t134 0.9005
R895 VDD.n272 VDD.n271 0.9005
R896 VDD.n269 VDD.n268 0.9005
R897 VDD.n268 VDD.n267 0.9005
R898 VDD.n270 VDD.n50 0.9005
R899 VDD.n319 VDD.n177 0.9005
R900 VDD.n13 VDD.n480 0.9005
R901 VDD.n501 VDD.n500 0.9005
R902 VDD.n501 VDD.n165 0.9005
R903 VDD.n499 VDD.n28 0.9005
R904 VDD.n532 VDD.n485 0.9005
R905 VDD.n532 VDD.n35 0.9005
R906 VDD.n536 VDD.n535 0.9005
R907 VDD.n535 VDD.n32 0.9005
R908 VDD.n537 VDD.n530 0.9005
R909 VDD.n530 VDD.n529 0.9005
R910 VDD.n546 VDD.n545 0.9005
R911 VDD.n545 VDD.n544 0.9005
R912 VDD.n548 VDD.n547 0.9005
R913 VDD.n549 VDD.n548 0.9005
R914 VDD.n526 VDD.n525 0.9005
R915 VDD.n525 VDD.n514 0.9005
R916 VDD.n521 VDD.n520 0.9005
R917 VDD.n521 VDD.n91 0.9005
R918 VDD.n556 VDD.n555 0.9005
R919 VDD.n555 VDD.n554 0.9005
R920 VDD.n557 VDD.n505 0.9005
R921 VDD.n506 VDD.n505 0.9005
R922 VDD.n504 VDD.n503 0.9005
R923 VDD.n503 VDD.n72 0.9005
R924 VDD.n8 VDD.n150 0.9005
R925 VDD.n11 VDD.n8 0.9005
R926 VDD.n59 VDD.t47 0.562929
R927 VDD.n252 VDD.t22 0.871319
R928 VDD.t202 VDD.n304 0.857643
R929 VDD.n302 VDD.t151 0.857643
R930 VDD.n609 VDD.n577 0.856272
R931 VDD.t61 VDD.n30 0.852804
R932 VDD.n254 VDD.n66 0.834377
R933 VDD.n384 VDD.n383 0.811654
R934 VDD.n320 VDD.n176 0.804296
R935 VDD.n469 VDD.n461 0.775283
R936 VDD.n473 VDD.n461 0.775283
R937 VDD.n474 VDD.n473 0.775283
R938 VDD.n475 VDD.n474 0.775283
R939 VDD.n23 VDD.t95 1.22643
R940 VDD.n70 VDD.n370 0.570328
R941 VDD.n59 VDD.n597 0.418821
R942 VDD.n592 VDD.n51 1.26562
R943 VDD.n601 VDD.n51 0.413046
R944 VDD.n657 VDD.n652 0.775283
R945 VDD.n661 VDD.n652 0.775283
R946 VDD.n662 VDD.n661 0.775283
R947 VDD.n663 VDD.n662 0.775283
R948 VDD.n437 VDD.n412 0.775283
R949 VDD.n422 VDD.n412 0.775283
R950 VDD.n422 VDD.n421 0.775283
R951 VDD.n421 VDD.n420 0.775283
R952 VDD.n82 VDD.n81 0.555478
R953 VDD.n79 VDD.n78 0.555478
R954 VDD.n674 VDD.t61 0.762695
R955 VDD.n397 VDD.t93 0.79268
R956 VDD.n438 VDD.n437 0.760283
R957 VDD.n190 VDD.n185 0.741856
R958 VDD.n188 VDD.n50 0.733137
R959 VDD.n195 VDD.t6 1.28578
R960 VDD.n249 VDD.t6 1.3061
R961 VDD.n247 VDD.n246 0.71463
R962 VDD.n246 VDD.t6 0.71463
R963 VDD.n272 VDD.n50 1.12337
R964 VDD.n565 VDD.n165 0.71463
R965 VDD.n24 VDD.n165 0.71463
R966 VDD.n554 VDD.n79 1.15919
R967 VDD.n554 VDD.n553 0.71463
R968 VDD.n549 VDD.n82 1.15919
R969 VDD.n550 VDD.n549 0.71463
R970 VDD.n85 VDD.n32 0.848177
R971 VDD.n38 VDD.n32 0.71463
R972 VDD.n209 VDD.n247 0.710377
R973 VDD.n286 VDD.n14 0.703201
R974 VDD.t192 VDD.n228 0.7005
R975 VDD.n228 VDD.n222 0.7005
R976 VDD.n233 VDD.t52 0.7005
R977 VDD.n234 VDD.n233 0.7005
R978 VDD.n236 VDD.t53 0.7005
R979 VDD.n16 VDD.t52 0.7005
R980 VDD.t53 VDD.n16 0.7005
R981 VDD.t192 VDD.n238 0.7005
R982 VDD.n238 VDD.n58 0.54144
R983 VDD.t12 VDD.n161 0.7005
R984 VDD.n161 VDD.n160 0.7005
R985 VDD.n157 VDD.t0 0.7005
R986 VDD.n158 VDD.n157 0.7005
R987 VDD.n76 VDD.n11 0.7005
R988 VDD.n9 VDD.t0 0.7005
R989 VDD.n11 VDD.n9 0.7005
R990 VDD.n10 VDD.t12 0.7005
R991 VDD.n11 VDD.n10 0.7005
R992 VDD.n85 VDD.n84 0.563661
R993 VDD.n236 VDD.t99 0.693689
R994 VDD.t126 VDD.n76 0.693689
R995 VDD.n630 VDD.n629 0.680292
R996 VDD.t47 VDD.n41 0.679399
R997 VDD.t134 VDD.n220 0.678601
R998 VDD.n3 VDD.n19 0.673514
R999 VDD.n41 VDD.n578 0.673514
R1000 VDD.n618 VDD.n617 0.673514
R1001 VDD.n633 VDD.n632 0.673514
R1002 VDD.n450 VDD.n449 0.673514
R1003 VDD.n84 VDD.n83 0.672578
R1004 VDD.n81 VDD.n80 0.672578
R1005 VDD.n78 VDD.n77 0.662898
R1006 VDD.n449 VDD.n408 0.637173
R1007 VDD.n274 VDD.n49 0.620942
R1008 VDD.n326 VDD.n310 0.617064
R1009 VDD.n89 VDD.n79 0.095921
R1010 VDD.n93 VDD.n82 0.095921
R1011 VDD.n296 VDD.n184 0.613151
R1012 VDD.n343 VDD.n316 0.613151
R1013 VDD.n281 VDD.n50 0.600306
R1014 VDD.n258 VDD.n66 1.01522
R1015 VDD.n565 VDD.n28 0.581559
R1016 VDD.n15 VDD.n13 0.578697
R1017 VDD.t53 VDD.n17 0.573227
R1018 VDD.n227 VDD.n226 0.573227
R1019 VDD.n226 VDD.n221 0.573227
R1020 VDD.n277 VDD.n276 0.573227
R1021 VDD.n277 VDD.n188 0.573227
R1022 VDD.n283 VDD.n282 0.573227
R1023 VDD.n282 VDD.n281 0.573227
R1024 VDD.n182 VDD.n175 0.573227
R1025 VDD.n297 VDD.n175 0.573227
R1026 VDD.n302 VDD.n180 0.573227
R1027 VDD.n298 VDD.n180 0.573227
R1028 VDD.n302 VDD.n301 0.573227
R1029 VDD.n301 VDD.n300 0.573227
R1030 VDD.n291 VDD.n287 0.573227
R1031 VDD.n287 VDD.n286 0.573227
R1032 VDD.n291 VDD.n290 0.573227
R1033 VDD.n290 VDD.n184 0.573227
R1034 VDD.n482 VDD.n481 0.573227
R1035 VDD.n481 VDD.n15 0.573227
R1036 VDD.n314 VDD.n304 0.573227
R1037 VDD.n344 VDD.n314 0.573227
R1038 VDD.n334 VDD.n304 0.573227
R1039 VDD.n334 VDD.n311 0.573227
R1040 VDD.n348 VDD.n347 0.573227
R1041 VDD.n349 VDD.n348 0.573227
R1042 VDD.n328 VDD.n327 0.573227
R1043 VDD.n327 VDD.n326 0.573227
R1044 VDD.n329 VDD.n328 0.573227
R1045 VDD.n329 VDD.n316 0.573227
R1046 VDD.n338 VDD.n337 0.573227
R1047 VDD.n337 VDD.n309 0.573227
R1048 VDD.n63 VDD.n21 0.00125435
R1049 VDD.t93 VDD.n21 0.573219
R1050 VDD.n20 VDD.t172 0.573227
R1051 VDD.t93 VDD.n20 0.573227
R1052 VDD.t44 VDD.n376 0.573227
R1053 VDD.n376 VDD.n2 0.440396
R1054 VDD.n366 VDD.t26 0.573227
R1055 VDD.n366 VDD.n4 0.573227
R1056 VDD.n377 VDD.t44 0.573227
R1057 VDD.n377 VDD.n364 0.573227
R1058 VDD.n379 VDD.t26 0.573227
R1059 VDD.n67 VDD.n379 0.573227
R1060 VDD.n381 VDD.t39 0.573227
R1061 VDD.n382 VDD.n381 0.573227
R1062 VDD.n356 VDD.t33 0.573227
R1063 VDD.n384 VDD.n356 0.573227
R1064 VDD.n389 VDD.t39 0.573227
R1065 VDD.n390 VDD.n389 0.573227
R1066 VDD.n387 VDD.t33 0.573227
R1067 VDD.n387 VDD.n385 0.573227
R1068 VDD.t63 VDD.n393 0.573227
R1069 VDD.t14 VDD.n606 0.573227
R1070 VDD.n606 VDD.n605 0.573227
R1071 VDD.n39 VDD.t132 0.573227
R1072 VDD.t47 VDD.n39 0.573227
R1073 VDD.n40 VDD.t85 0.573227
R1074 VDD.t14 VDD.n581 0.573227
R1075 VDD.n589 VDD.n581 0.573227
R1076 VDD.t132 VDD.n603 0.573227
R1077 VDD.n603 VDD.n602 0.573227
R1078 VDD.n42 VDD.t85 0.573227
R1079 VDD.t47 VDD.n42 0.573227
R1080 VDD.n38 VDD.n33 0.573227
R1081 VDD.n570 VDD.n53 0.573227
R1082 VDD.n538 VDD.n531 0.573227
R1083 VDD.n531 VDD.n37 0.573227
R1084 VDD.n540 VDD.n539 0.573227
R1085 VDD.n540 VDD.n488 0.573227
R1086 VDD.n515 VDD.n513 0.573227
R1087 VDD.n515 VDD.n510 0.573227
R1088 VDD.n518 VDD.n517 0.573227
R1089 VDD.n517 VDD.n489 0.573227
R1090 VDD.n559 VDD.n558 0.573227
R1091 VDD.n559 VDD.n507 0.573227
R1092 VDD.n562 VDD.n561 0.573227
R1093 VDD.n561 VDD.n71 0.573227
R1094 VDD.n143 VDD.n139 0.573227
R1095 VDD.n143 VDD.n11 0.573227
R1096 VDD.n149 VDD.n148 0.573227
R1097 VDD.n148 VDD.n141 0.573227
R1098 VDD.t45 VDD.n621 0.573227
R1099 VDD.n621 VDD.n620 0.573227
R1100 VDD.n131 VDD.t157 0.573227
R1101 VDD.n131 VDD.n127 0.573227
R1102 VDD.n627 VDD.t111 0.573227
R1103 VDD.n628 VDD.n627 0.573227
R1104 VDD.n622 VDD.t45 0.573227
R1105 VDD.n622 VDD.n134 0.573227
R1106 VDD.n624 VDD.t157 0.573227
R1107 VDD.n624 VDD.n126 0.573227
R1108 VDD.t111 VDD.n626 0.573227
R1109 VDD.n626 VDD.t112 0.573227
R1110 VDD.t158 VDD.n635 0.573227
R1111 VDD.n635 VDD.n634 0.573227
R1112 VDD.t25 VDD.n647 0.573227
R1113 VDD.n647 VDD.n646 0.573227
R1114 VDD.n644 VDD.t165 0.573227
R1115 VDD.n645 VDD.n644 0.573227
R1116 VDD.t158 VDD.n123 0.573227
R1117 VDD.n123 VDD.n115 0.573227
R1118 VDD.n648 VDD.t25 0.573227
R1119 VDD.n649 VDD.n648 0.573227
R1120 VDD.n641 VDD.t165 0.573227
R1121 VDD.t166 VDD.n641 0.573227
R1122 VDD.n441 VDD.t2 0.573227
R1123 VDD.n441 VDD.n440 0.573227
R1124 VDD.n443 VDD.t171 0.573227
R1125 VDD.n443 VDD.n407 0.573227
R1126 VDD.t188 VDD.n431 0.573227
R1127 VDD.n431 VDD.n430 0.573227
R1128 VDD.n427 VDD.t2 0.573227
R1129 VDD.n427 VDD.n406 0.573227
R1130 VDD.n405 VDD.t171 0.573227
R1131 VDD.n451 VDD.n405 0.573227
R1132 VDD.n432 VDD.t188 0.573227
R1133 VDD.n433 VDD.n432 0.573227
R1134 VDD.n66 VDD.n65 0.573227
R1135 VDD.n86 VDD.n66 0.573227
R1136 VDD.n294 VDD.n170 0.570265
R1137 VDD.t177 VDD.n86 0.569391
R1138 VDD.n64 VDD.t193 0.569391
R1139 VDD.n247 VDD.n210 0.568729
R1140 VDD.n342 VDD.n341 0.568352
R1141 VDD.n295 VDD.n294 0.568352
R1142 VDD.n566 VDD.n565 0.567803
R1143 VDD.n393 VDD.n69 0.59234
R1144 VDD.n567 VDD.n36 1.21782
R1145 VDD.n13 VDD.n176 0.55728
R1146 VDD.n77 VDD.n566 0.555193
R1147 VDD.n573 VDD.n163 0.55085
R1148 VDD.n617 VDD.n11 0.550184
R1149 VDD.n632 VDD.n631 0.550184
R1150 VDD.n383 VDD.n382 0.546269
R1151 VDD.t93 VDD.t66 0.544514
R1152 VDD.n322 VDD.t198 0.533882
R1153 VDD.t93 VDD.t68 0.533882
R1154 VDD.n11 VDD.t209 0.533882
R1155 VDD.n11 VDD.t116 0.533882
R1156 VDD.n455 VDD.t185 0.533882
R1157 VDD.t47 VDD.t89 0.533882
R1158 VDD.n274 VDD.t73 0.533882
R1159 VDD.n12 VDD.t149 0.533882
R1160 VDD.n50 VDD.t70 0.533882
R1161 VDD.n50 VDD.t16 0.533882
R1162 VDD.n672 VDD.t78 0.533882
R1163 VDD.t61 VDD.t77 0.533882
R1164 VDD.n673 VDD.t62 0.533882
R1165 VDD.n564 VDD.n490 0.5255
R1166 VDD.n522 VDD.n516 0.5255
R1167 VDD.n543 VDD.n528 0.5255
R1168 VDD.n568 VDD.n487 0.5255
R1169 VDD.n672 VDD.n30 0.524688
R1170 VDD.n273 VDD.n50 0.517198
R1171 VDD.n340 VDD.n322 0.501097
R1172 VDD.n673 VDD.n60 0.191087
R1173 VDD.n295 VDD.n293 0.491732
R1174 VDD.n342 VDD.n317 0.491732
R1175 VDD.n398 VDD.n357 0.488095
R1176 VDD.n667 VDD.n666 0.482643
R1177 VDD.n573 VDD.n25 0.482643
R1178 VDD.n669 VDD.n668 0.475656
R1179 VDD.n296 VDD.n295 0.475263
R1180 VDD.n343 VDD.n342 0.475263
R1181 VDD.n27 VDD.n25 0.0151414
R1182 VDD.n190 VDD.n188 0.454314
R1183 VDD.n630 VDD.t112 0.445542
R1184 VDD.n152 VDD.n151 0.443577
R1185 VDD.n577 VDD.n576 0.437448
R1186 VDD.n674 VDD 0.436211
R1187 VDD.n235 VDD.n52 0.877195
R1188 VDD.n234 VDD.n230 0.431088
R1189 VDD.n230 VDD.n222 0.431088
R1190 VDD.n158 VDD.n68 0.61868
R1191 VDD.n159 VDD.n158 0.431088
R1192 VDD.n160 VDD.n159 0.431088
R1193 VDD.t93 VDD.t97 0.430119
R1194 VDD.t93 VDD.t94 0.430119
R1195 VDD.n418 VDD.t110 0.430119
R1196 VDD.n425 VDD.t108 0.430119
R1197 VDD.n435 VDD.t106 0.430119
R1198 VDD.t47 VDD.t51 0.430119
R1199 VDD.t47 VDD.t49 0.430119
R1200 VDD.n459 VDD.t59 0.430119
R1201 VDD.n465 VDD.t57 0.430119
R1202 VDD.n468 VDD.t55 0.430119
R1203 VDD.n141 VDD.n11 0.424576
R1204 VDD.n239 VDD.n222 0.410794
R1205 VDD.n160 VDD.n153 0.410794
R1206 VDD.n239 VDD.t53 0.406984
R1207 VDD.n668 VDD.n106 0.4005
R1208 VDD.n574 VDD.n573 0.396725
R1209 VDD.n676 VDD.n675 0.3755
R1210 VDD.n162 VDD.n11 0.3755
R1211 VDD.n677 VDD.n676 0.3755
R1212 VDD.n27 VDD.n26 0.225498
R1213 VDD.n28 VDD.n27 0.0769919
R1214 VDD.n352 VDD.n351 0.363916
R1215 VDD.n113 VDD.n107 0.36337
R1216 VDD.n455 VDD.t187 0.36012
R1217 VDD.n101 VDD 0.385625
R1218 VDD.n256 VDD.n255 0.347096
R1219 VDD.n651 VDD.n650 0.343143
R1220 VDD.n69 VDD.n357 0.381375
R1221 VDD.n400 VDD.t93 0.338
R1222 VDD.t69 VDD.n99 0.332683
R1223 VDD.n46 VDD.t15 0.332558
R1224 VDD.t90 VDD.n206 0.332079
R1225 VDD.n206 VDD.n202 0.332079
R1226 VDD.t90 VDD.n248 0.332079
R1227 VDD.n248 VDD.t6 0.332079
R1228 VDD.t136 VDD.n215 0.332079
R1229 VDD.n219 VDD.n216 0.332079
R1230 VDD.n50 VDD.n48 0.332079
R1231 VDD.n50 VDD.n47 0.332079
R1232 VDD.t38 VDD.n275 0.332079
R1233 VDD.t38 VDD.n186 0.332079
R1234 VDD.n191 VDD.n186 0.332079
R1235 VDD.n183 VDD.n182 0.332079
R1236 VDD.n299 VDD.n183 0.332079
R1237 VDD.n482 VDD.n173 0.332079
R1238 VDD.n12 VDD.n173 0.332079
R1239 VDD.n347 VDD.n346 0.332079
R1240 VDD.n346 VDD.n345 0.332079
R1241 VDD.n338 VDD.n333 0.332079
R1242 VDD.n333 VDD.n322 0.332079
R1243 VDD.n22 VDD.t67 0.332079
R1244 VDD.t93 VDD.n22 0.332079
R1245 VDD.n371 VDD.t93 0.332079
R1246 VDD.n372 VDD.t174 0.332079
R1247 VDD.n372 VDD.t93 0.332079
R1248 VDD.n19 VDD.n375 0.332079
R1249 VDD.n29 VDD.t174 0.332079
R1250 VDD.n4 VDD.n2 0.0498883
R1251 VDD.n394 VDD.t93 0.332079
R1252 VDD.n397 VDD.n396 0.332079
R1253 VDD.t67 VDD.n399 0.332079
R1254 VDD.n399 VDD.n398 0.332079
R1255 VDD.n583 VDD.t88 0.332079
R1256 VDD.n604 VDD.n583 0.332079
R1257 VDD.n579 VDD.t47 0.332079
R1258 VDD.n595 VDD.t88 0.332079
R1259 VDD.n595 VDD.t47 0.332079
R1260 VDD.n41 VDD.n608 0.332079
R1261 VDD.n617 VDD.n616 0.332079
R1262 VDD.n136 VDD.t113 0.332079
R1263 VDD.n619 VDD.n136 0.332079
R1264 VDD.n613 VDD.t113 0.332079
R1265 VDD.n613 VDD.t114 0.332079
R1266 VDD.n11 VDD.n7 0.332079
R1267 VDD.n632 VDD.n122 0.332079
R1268 VDD.n125 VDD.t167 0.332079
R1269 VDD.n125 VDD.n120 0.332079
R1270 VDD.n639 VDD.t167 0.332079
R1271 VDD.n639 VDD.t168 0.332079
R1272 VDD.n637 VDD.t170 0.332079
R1273 VDD.t184 VDD.n453 0.332079
R1274 VDD.n453 VDD.n452 0.332079
R1275 VDD.n449 VDD.n448 0.332079
R1276 VDD.n446 VDD.t187 0.332079
R1277 VDD.n454 VDD.t184 0.332079
R1278 VDD.n455 VDD.n454 0.332079
R1279 VDD.n99 VDD.n274 0.332079
R1280 VDD.n98 VDD.n673 0.332079
R1281 VDD.n672 VDD.n671 0.332079
R1282 VDD.n47 VDD.t69 0.331788
R1283 VDD.n671 VDD.t61 0.331623
R1284 VDD.t60 VDD.n98 0.331623
R1285 VDD.t15 VDD.n48 0.331538
R1286 VDD.n18 VDD.n221 0.323326
R1287 VDD.n300 VDD.n296 0.318474
R1288 VDD.n344 VDD.n343 0.318474
R1289 VDD.n281 VDD.n185 0.317656
R1290 VDD.t6 VDD.t131 0.313875
R1291 VDD.n340 VDD.n320 0.312292
R1292 VDD.t53 VDD.n18 0.299784
R1293 VDD.t170 VDD.t168 0.296359
R1294 VDD.n257 VDD.n254 0.288087
R1295 VDD.n257 VDD.n256 0.288087
R1296 VDD.n310 VDD.n308 0.279121
R1297 VDD.n12 VDD.n170 0.277634
R1298 VDD.n256 VDD.t180 0.267191
R1299 VDD.n254 VDD.t183 0.267191
R1300 VDD.n340 VDD.t199 0.267191
R1301 VDD.n317 VDD.t205 0.267191
R1302 VDD.n45 VDD.t146 0.267191
R1303 VDD.n293 VDD.t154 0.267191
R1304 VDD.n436 VDD.t105 0.263787
R1305 VDD.t109 VDD.n103 0.263787
R1306 VDD.n656 VDD.t163 0.263787
R1307 VDD.n597 VDD.t46 0.263787
R1308 VDD.n601 VDD.t50 0.263787
R1309 VDD.n370 VDD.t96 0.263787
R1310 VDD.n467 VDD.t54 0.263787
R1311 VDD.n470 VDD.t54 0.263075
R1312 VDD.n658 VDD.t163 0.263075
R1313 VDD.t105 VDD.n104 0.263075
R1314 VDD.n419 VDD.t109 0.263075
R1315 VDD.n44 VDD.t50 0.263075
R1316 VDD.t46 VDD.n102 0.263075
R1317 VDD.n468 VDD.n467 0.263
R1318 VDD.n464 VDD.t56 0.263
R1319 VDD.n465 VDD.n464 0.263
R1320 VDD.t58 VDD.n305 0.263
R1321 VDD.n459 VDD.n305 0.263
R1322 VDD.n470 VDD.n469 0.263
R1323 VDD.n472 VDD.t56 0.263
R1324 VDD.n473 VDD.n472 0.263
R1325 VDD.t58 VDD.n476 0.263
R1326 VDD.n476 VDD.n475 0.263
R1327 VDD.t48 VDD.n598 0.263
R1328 VDD.n598 VDD.t47 0.263
R1329 VDD.n599 VDD.t48 0.263
R1330 VDD.n599 VDD.n592 0.263
R1331 VDD.t164 VDD.n656 0.263
R1332 VDD.n654 VDD.t159 0.263
R1333 VDD.t160 VDD.n654 0.263
R1334 VDD.n665 VDD.t161 0.263
R1335 VDD.t162 VDD.n665 0.263
R1336 VDD.t161 VDD.n664 0.263
R1337 VDD.n664 VDD.n663 0.263
R1338 VDD.n660 VDD.t159 0.263
R1339 VDD.n661 VDD.n660 0.263
R1340 VDD.n658 VDD.n657 0.263
R1341 VDD.n420 VDD.n419 0.263
R1342 VDD.t107 VDD.n423 0.263
R1343 VDD.n423 VDD.n422 0.263
R1344 VDD.n437 VDD.n436 0.263
R1345 VDD.n103 VDD.n418 0.263
R1346 VDD.n424 VDD.t107 0.263
R1347 VDD.n425 VDD.n424 0.263
R1348 VDD.n104 VDD.n435 0.263
R1349 VDD.t47 VDD.n44 0.263
R1350 VDD.n102 VDD.t47 0.263
R1351 VDD.t6 VDD.n57 1.7334
R1352 VDD.n251 VDD.n106 0.2565
R1353 VDD.t7 VDD.t93 16.1727
R1354 VDD.n435 VDD.n434 0.252744
R1355 VDD.t136 VDD.n214 0.246298
R1356 VDD.n319 VDD.n318 0.245938
R1357 VDD.n609 VDD.t47 0.245535
R1358 VDD.n252 VDD.n251 0.24126
R1359 VDD.n151 VDD.n11 0.235524
R1360 VDD.n299 VDD.n298 0.232097
R1361 VDD.n345 VDD.n311 0.232097
R1362 VDD.n604 VDD.t47 0.232097
R1363 VDD.n619 VDD.n127 0.232097
R1364 VDD.n646 VDD.n120 0.232097
R1365 VDD.n452 VDD.n406 0.232097
R1366 VDD.t6 VDD.t136 0.231955
R1367 VDD.t211 VDD.t213 0.228
R1368 VDD.t71 VDD.t72 0.228
R1369 VDD.n418 VDD.n415 0.214272
R1370 VDD.n435 VDD.n426 0.214272
R1371 VDD.n426 VDD.n425 0.214272
R1372 VDD.n425 VDD.n415 0.214272
R1373 VDD.n383 VDD.n357 0.213788
R1374 VDD.n50 VDD.n66 6.7999
R1375 VDD.n350 VDD.n310 0.194848
R1376 VDD.t93 VDD.n67 1.26757
R1377 VDD.n602 VDD.t47 1.26757
R1378 VDD.n650 VDD.n114 0.188652
R1379 VDD.n274 VDD.n273 0.184047
R1380 VDD.n439 VDD.n410 0.181152
R1381 VDD.n267 VDD.n50 0.273452
R1382 VDD.n675 VDD.n669 0.179795
R1383 VDD.n676 VDD.n100 0.179795
R1384 VDD.n293 VDD.n292 0.1755
R1385 VDD.n483 VDD.n482 0.1755
R1386 VDD.n45 VDD.n483 0.1755
R1387 VDD.n339 VDD.n338 0.1755
R1388 VDD.n340 VDD.n339 0.1755
R1389 VDD.n324 VDD.n317 0.1755
R1390 VDD.n408 VDD.t187 0.174947
R1391 VDD.n567 VDD.n85 0.564976
R1392 VDD.n352 VDD.n309 0.164663
R1393 VDD.t166 VDD.n107 0.164663
R1394 VDD.t125 VDD.t93 0.541955
R1395 VDD.n38 VDD.n34 0.160925
R1396 VDD.n434 VDD.n411 0.160897
R1397 VDD.n45 VDD.n170 0.157539
R1398 VDD.n75 VDD.n72 0.151764
R1399 VDD.n552 VDD.n91 0.151764
R1400 VDD.n544 VDD.n168 0.151764
R1401 VDD.n38 VDD.n35 0.151764
R1402 VDD.n434 VDD.n433 0.150857
R1403 VDD.n456 VDD.n401 0.149744
R1404 VDD.n15 VDD.n12 0.148429
R1405 VDD.n322 VDD.n321 0.148429
R1406 VDD.t114 VDD.n612 0.148429
R1407 VDD.n642 VDD.t168 0.148429
R1408 VDD.n575 VDD.n574 0.147239
R1409 VDD.n631 VDD.t170 0.144213
R1410 VDD.n303 VDD.n179 0.143357
R1411 VDD.n468 VDD.n466 0.140482
R1412 VDD.n466 VDD.n465 0.140482
R1413 VDD.n465 VDD.n460 0.140482
R1414 VDD.n460 VDD.n459 0.140482
R1415 VDD.t164 VDD.n655 0.140482
R1416 VDD.n655 VDD.t160 0.140482
R1417 VDD.t160 VDD.n108 0.140482
R1418 VDD.t162 VDD.n108 0.140482
R1419 VDD.n298 VDD.n297 0.140212
R1420 VDD.n349 VDD.n311 0.140212
R1421 VDD.t47 VDD.n40 0.585484
R1422 VDD.n628 VDD.n127 0.140212
R1423 VDD.n646 VDD.n645 0.140212
R1424 VDD.n430 VDD.n406 0.140212
R1425 VDD.n605 VDD.n578 0.139034
R1426 VDD.n620 VDD.n618 0.139034
R1427 VDD.n634 VDD.n633 0.139034
R1428 VDD.n451 VDD.n450 0.139034
R1429 VDD.n75 VDD.n71 0.132104
R1430 VDD.n552 VDD.n489 0.132104
R1431 VDD.n488 VDD.n168 0.132104
R1432 VDD.n38 VDD.n36 0.0841755
R1433 VDD.n552 VDD.n551 0.131639
R1434 VDD.n11 VDD.t101 1.14115
R1435 VDD.n75 VDD.n73 0.126738
R1436 VDD.n153 VDD.n11 0.459857
R1437 VDD.t134 VDD.n214 0.119279
R1438 VDD.t176 VDD.t93 0.626161
R1439 VDD.n15 VDD.n14 0.117553
R1440 VDD.n438 VDD.n411 0.114762
R1441 VDD.t181 VDD.t182 0.11425
R1442 VDD.t201 VDD.t203 0.11425
R1443 VDD.t148 VDD.t152 0.11425
R1444 VDD.n433 VDD.n401 0.112385
R1445 VDD.t131 VDD.n209 0.112001
R1446 VDD.n351 VDD.n350 0.10508
R1447 VDD.n114 VDD.n113 0.104219
R1448 VDD.n571 VDD.n38 0.0933116
R1449 VDD.n18 VDD.n214 0.0918025
R1450 VDD.n321 VDD.n309 0.0917363
R1451 VDD.n612 VDD.t112 0.0917363
R1452 VDD.n642 VDD.t166 0.0917363
R1453 VDD.n566 VDD.n87 0.118861
R1454 VDD.n297 VDD.n14 0.0895825
R1455 VDD.n550 VDD.n168 0.0851813
R1456 VDD.n553 VDD.n552 0.0851813
R1457 VDD.n24 VDD.n75 0.0851813
R1458 VDD.n631 VDD.n630 0.0846481
R1459 VDD.n351 VDD.n308 0.0820513
R1460 VDD.n507 VDD.n73 0.0814598
R1461 VDD.n551 VDD.n510 0.0814598
R1462 VDD.n575 VDD.n25 0.0809813
R1463 VDD.n666 VDD.t162 0.0777566
R1464 VDD.n284 VDD.n180 0.0777059
R1465 VDD.n335 VDD.n334 0.0777059
R1466 VDD.n366 VDD.n365 0.0777059
R1467 VDD.n381 VDD.n380 0.0777059
R1468 VDD.n39 VDD.n585 0.0777059
R1469 VDD.n131 VDD.n130 0.0777059
R1470 VDD.n647 VDD.n119 0.0777059
R1471 VDD.n428 VDD.n427 0.0777059
R1472 VDD.n459 VDD.n458 0.0776429
R1473 VDD.n651 VDD.n113 0.0775684
R1474 VDD.n411 VDD.n410 0.0756447
R1475 VDD VDD.n677 0.0717322
R1476 VDD.t6 VDD.n1 0.913198
R1477 VDD.n677 VDD.n105 0.0685332
R1478 VDD.n551 VDD.n550 0.0604652
R1479 VDD.n553 VDD.n73 0.0604652
R1480 VDD.t93 VDD.n19 0.634979
R1481 VDD.n629 VDD.n628 0.0533076
R1482 VDD.n507 VDD.n506 0.0508571
R1483 VDD.n514 VDD.n510 0.0508571
R1484 VDD.n529 VDD.n37 0.0508571
R1485 VDD.n300 VDD.n299 0.0459712
R1486 VDD.n345 VDD.n344 0.0459712
R1487 VDD.n605 VDD.n604 0.0459712
R1488 VDD.n620 VDD.n619 0.0459712
R1489 VDD.n634 VDD.n120 0.0459712
R1490 VDD.n452 VDD.n451 0.0459712
R1491 VDD.n669 VDD.n100 0.0427902
R1492 VDD.n101 VDD.n100 0.0420058
R1493 VDD.n105 VDD 0.0419457
R1494 VDD.n572 VDD.n167 0.0408737
R1495 VDD.n572 VDD.n571 0.0399737
R1496 VDD.n169 VDD.n167 0.0399737
R1497 VDD.n571 VDD.n168 0.0388277
R1498 VDD.n576 VDD.n575 0.0377192
R1499 VDD.n458 VDD.n352 0.0369096
R1500 VDD.n666 VDD.n107 0.0367958
R1501 VDD.n88 VDD.n87 0.001068
R1502 VDD.n92 VDD.n90 0.001068
R1503 VDD.n95 VDD.n94 0.001068
R1504 VDD.n97 VDD.n96 0.001068
R1505 VDD.t179 VDD.n257 0.0339565
R1506 VDD.n101 VDD.n105 0.0332728
R1507 VDD.n74 VDD.n166 0.03175
R1508 VDD.n166 VDD.n163 0.03175
R1509 VDD.n88 VDD.n72 0.031474
R1510 VDD.n92 VDD.n91 0.031474
R1511 VDD.n544 VDD.n95 0.031474
R1512 VDD.n96 VDD.n35 0.031474
R1513 VDD.n456 VDD.n455 0.031066
R1514 VDD.t156 VDD.n210 0.03043
R1515 VDD.n199 VDD.t8 0.0282073
R1516 VDD.n97 VDD.n567 0.256806
R1517 VDD.n94 VDD.n93 3.71136
R1518 VDD.n90 VDD.n89 3.71136
R1519 VDD.n155 VDD.t126 0.697845
R1520 VDD.n235 VDD.t99 0.697845
R1521 VDD.t3 VDD.n38 0.612004
R1522 VDD.n65 VDD.t193 0.572059
R1523 VDD.n258 VDD.t177 0.572059
R1524 VDD.n529 VDD.n84 0.137442
R1525 VDD.n514 VDD.n81 0.137442
R1526 VDD.n506 VDD.n78 0.137442
R1527 VDD.n75 VDD.n74 0.0366515
R1528 VDD.n350 VDD.n349 0.0264162
R1529 VDD.n645 VDD.n114 0.0264162
R1530 VDD.n430 VDD.n410 0.0264162
R1531 VDD.t41 VDD.n28 2.23947
R1532 VDD.n70 VDD.t95 1.66715
R1533 VDD.t47 VDD.n43 1.15081
R1534 VDD.n4 VDD.n3 1.12826
R1535 VDD.t53 VDD.n58 1.11393
R1536 VDD.t6 VDD.n54 1.11318
R1537 VDD.t114 VDD.n11 1.10805
R1538 VDD.n275 VDD.n50 1.07828
R1539 VDD.n318 VDD.n15 1.07471
R1540 VDD.n50 VDD.n45 1.06595
R1541 VDD.t156 VDD.t6 1.06414
R1542 VDD.t96 VDD.n6 1.04351
R1543 VDD.n255 VDD.n66 1.04088
R1544 VDD.t6 VDD.n61 1.01739
R1545 VDD.n38 VDD.n37 1.0109
R1546 VDD.n28 VDD.n24 1.00189
R1547 VSS.n696 VSS.n360 1.57617e+07
R1548 VSS.n966 VSS.n965 2.58375e+06
R1549 VSS.n965 VSS.n428 2.5805e+06
R1550 VSS.n740 VSS.n739 1.20592e+06
R1551 VSS.n697 VSS.n696 1.02561e+06
R1552 VSS.n539 VSS.n538 680875
R1553 VSS.n539 VSS.n428 680875
R1554 VSS.t155 VSS.n820 405320
R1555 VSS.n743 VSS.n742 342428
R1556 VSS.n823 VSS.n627 341984
R1557 VSS.n865 VSS.n591 316377
R1558 VSS.n741 VSS.n709 313267
R1559 VSS.t258 VSS.n864 268568
R1560 VSS.n740 VSS.n726 134878
R1561 VSS.n1336 VSS.n141 79338.4
R1562 VSS.n1110 VSS.n199 78383.3
R1563 VSS.n855 VSS.n427 78363.6
R1564 VSS.n1288 VSS.n197 72894.2
R1565 VSS.n779 VSS.n650 62729
R1566 VSS.n739 VSS.n649 58754.9
R1567 VSS.n1110 VSS.n428 55932.5
R1568 VSS.n258 VSS.t3 51670.5
R1569 VSS.n1244 VSS.n217 49500.2
R1570 VSS.n1319 VSS.n1318 49500
R1571 VSS.n1288 VSS.n1287 48061.8
R1572 VSS.n779 VSS.n697 45499
R1573 VSS.n1289 VSS.n196 40251
R1574 VSS.n1231 VSS.n1230 38069.6
R1575 VSS.n297 VSS.n296 38069.6
R1576 VSS.n864 VSS.n593 33615.8
R1577 VSS.n1288 VSS.n198 29135.3
R1578 VSS.n796 VSS.t200 27290.4
R1579 VSS.n1319 VSS.n169 26229.1
R1580 VSS.n829 VSS.n591 26071
R1581 VSS.n1244 VSS.n199 25791.7
R1582 VSS.n1289 VSS.n1288 25732.2
R1583 VSS.n1264 VSS.n197 25732.2
R1584 VSS.n741 VSS.n740 25721.2
R1585 VSS.n822 VSS.t226 23043.6
R1586 VSS.n1144 VSS.t190 22696.4
R1587 VSS.n1144 VSS.n26 22459.6
R1588 VSS.n779 VSS.n360 21656.8
R1589 VSS.n261 VSS.n197 21399.3
R1590 VSS.n821 VSS.n631 20533.3
R1591 VSS.n1230 VSS.n198 19984.3
R1592 VSS.n822 VSS.n361 18741.6
R1593 VSS.n1231 VSS.n1229 18086.3
R1594 VSS.n298 VSS.n297 18086.3
R1595 VSS.t143 VSS.n823 18070.7
R1596 VSS.n739 VSS.n738 16988.7
R1597 VSS.n1264 VSS.n210 16668.5
R1598 VSS.t200 VSS.n795 16130.5
R1599 VSS.n1289 VSS.t3 15564.4
R1600 VSS.n1264 VSS.n1263 15564.4
R1601 VSS.n1264 VSS.n119 12971.6
R1602 VSS.n292 VSS.n258 12635.8
R1603 VSS.n1233 VSS.n1232 12635.8
R1604 VSS.t126 VSS.n771 12315
R1605 VSS.n809 VSS.n808 11707.8
R1606 VSS.n1266 VSS.t3 11317.6
R1607 VSS.n1232 VSS.t205 10711.6
R1608 VSS.t126 VSS.n643 10530.6
R1609 VSS.n1285 VSS.t161 10385.9
R1610 VSS.t9 VSS.n703 10060.7
R1611 VSS.t77 VSS.t224 9941.18
R1612 VSS.n857 VSS.n856 9275.87
R1613 VSS.n742 VSS.n697 8595.52
R1614 VSS.n1287 VSS.n199 8492.42
R1615 VSS.n269 VSS.n265 8324.65
R1616 VSS.n1301 VSS.n170 8237.87
R1617 VSS.n1263 VSS.t205 7924.66
R1618 VSS.n823 VSS.n822 7846.17
R1619 VSS.n796 VSS.n632 7774.51
R1620 VSS.n1265 VSS.n1264 7603.85
R1621 VSS.n820 VSS.n632 6858.46
R1622 VSS.n1286 VSS.n1285 6500
R1623 VSS.n927 VSS.t75 6264.02
R1624 VSS.n1173 VSS.t112 6024.9
R1625 VSS.n1252 VSS.t51 5902.57
R1626 VSS.n1142 VSS.t226 5781.68
R1627 VSS.n1110 VSS.t4 5735.98
R1628 VSS.n1143 VSS.n169 5570.54
R1629 VSS.t247 VSS.n192 5561.46
R1630 VSS.n1033 VSS.n1032 5414.59
R1631 VSS.n473 VSS.n454 5410.44
R1632 VSS.n192 VSS.n170 5303.2
R1633 VSS.n741 VSS.n725 5217.75
R1634 VSS.n1267 VSS.n208 5116.4
R1635 VSS.t9 VSS.n767 5018.38
R1636 VSS.n1142 VSS.n361 4996.06
R1637 VSS.n1287 VSS.n1286 4845.56
R1638 VSS.n488 VSS.n447 4703.69
R1639 VSS.t161 VSS.n200 4699.24
R1640 VSS.n1031 VSS.n1003 4685.11
R1641 VSS.n1081 VSS.n448 4683.35
R1642 VSS.n289 VSS.t3 4587.37
R1643 VSS.t258 VSS.n592 4379.15
R1644 VSS.n866 VSS.n865 4335.14
R1645 VSS.n821 VSS.n598 4319.38
R1646 VSS.n1336 VSS.t189 4238.03
R1647 VSS.n795 VSS.n643 4237.75
R1648 VSS.n771 VSS.n703 4237.75
R1649 VSS.n767 VSS.n709 4237.75
R1650 VSS.n427 VSS.t214 4236.22
R1651 VSS.n1335 VSS.n142 4152.78
R1652 VSS.n315 VSS.n142 4152.78
R1653 VSS.n1334 VSS.n143 4152.78
R1654 VSS.n315 VSS.n143 4152.78
R1655 VSS.n295 VSS.t3 4152.78
R1656 VSS.n296 VSS.n295 4152.78
R1657 VSS.n1080 VSS.n454 4152.78
R1658 VSS.n1081 VSS.n1080 4152.78
R1659 VSS.n1034 VSS.n1033 4152.78
R1660 VSS.n1034 VSS.n1003 4152.78
R1661 VSS.n221 VSS.n198 4152.78
R1662 VSS.n1252 VSS.n221 4152.78
R1663 VSS.n1230 VSS.n219 4152.78
R1664 VSS.n1253 VSS.n219 4152.78
R1665 VSS.n427 VSS.n390 4152.78
R1666 VSS.n402 VSS.n390 4152.78
R1667 VSS.n427 VSS.n389 4152.78
R1668 VSS.n402 VSS.n389 4152.78
R1669 VSS.n1145 VSS.n1144 4131.78
R1670 VSS.t51 VSS.n199 3698.07
R1671 VSS.t0 VSS.n1306 3540.24
R1672 VSS.n1253 VSS.t52 3488.97
R1673 VSS.n1112 VSS.n1111 3360.25
R1674 VSS.n856 VSS.n598 3323.56
R1675 VSS.n261 VSS.t3 3250.3
R1676 VSS.n26 VSS.t55 3044.03
R1677 VSS.n1263 VSS.t77 2789.98
R1678 VSS.n928 VSS.n528 2780.6
R1679 VSS.n855 VSS.n854 2762.28
R1680 VSS.n856 VSS.n855 2746.33
R1681 VSS.n1112 VSS.n427 2664.63
R1682 VSS.t190 VSS.n1142 2664.63
R1683 VSS.n1062 VSS.t33 2515.9
R1684 VSS.n1143 VSS.n141 2434.5
R1685 VSS.n988 VSS.n975 2405.99
R1686 VSS.n1087 VSS.t7 2403.25
R1687 VSS.n1254 VSS.t224 2383.73
R1688 VSS.n473 VSS.n448 2366.56
R1689 VSS.n1032 VSS.n1031 2366.56
R1690 VSS.n989 VSS.n988 2351.84
R1691 VSS.t7 VSS.n1085 2351.84
R1692 VSS.n928 VSS.n927 2275.36
R1693 VSS.n474 VSS.n473 2179.12
R1694 VSS.n1032 VSS.n1004 2174.97
R1695 VSS.n821 VSS.n135 2160.12
R1696 VSS.n1318 VSS.n170 2000
R1697 VSS.n927 VSS.n926 1926.7
R1698 VSS.n1061 VSS.n475 1901.02
R1699 VSS.n1087 VSS.n1086 1841.76
R1700 VSS.n1142 VSS.n1141 1839.31
R1701 VSS.n296 VSS.n197 1835.29
R1702 VSS.n475 VSS.n474 1755.75
R1703 VSS.n1004 VSS.n444 1755.75
R1704 VSS.n809 VSS.n360 1735.91
R1705 VSS.n1302 VSS.n178 1597.17
R1706 VSS.n1290 VSS.n1289 1433.78
R1707 VSS.n991 VSS.t180 1395.21
R1708 VSS.n1130 VSS.t55 1293.71
R1709 VSS.n927 VSS.t61 1264.88
R1710 VSS.t7 VSS.n444 1244.1
R1711 VSS.n988 VSS.n475 1241.36
R1712 VSS.n192 VSS.n141 1233.49
R1713 VSS.n18 VSS.n26 235.069
R1714 VSS.t52 VSS.n1252 1194.85
R1715 VSS.n742 VSS.n741 1179.47
R1716 VSS.n1044 VSS.t103 1145.59
R1717 VSS.n865 VSS.t258 1123.12
R1718 VSS.t180 VSS.n487 1116.54
R1719 VSS.n736 VSS.n735 1076.83
R1720 VSS.n834 VSS.n833 1076.83
R1721 VSS.t4 VSS.t43 1070.41
R1722 VSS.t221 VSS.t247 1070.41
R1723 VSS.n135 VSS.t155 1040.26
R1724 VSS.t100 VSS.n1336 1022.06
R1725 VSS.n812 VSS.n356 1017.43
R1726 VSS.n1049 VSS.n487 988.644
R1727 VSS.n867 VSS.n571 960.953
R1728 VSS.n1301 VSS.t122 953.143
R1729 VSS.n1306 VSS.t124 953.143
R1730 VSS.n1111 VSS.t173 922.864
R1731 VSS.n584 VSS.t104 921.016
R1732 VSS.n975 VSS.t104 920.742
R1733 VSS.n1083 VSS.n448 919.317
R1734 VSS.n1031 VSS.n1030 917.566
R1735 VSS.n820 VSS.n819 916.633
R1736 VSS.n1144 VSS.n360 913.574
R1737 VSS.t12 VSS.n828 905.301
R1738 VSS.n829 VSS.t12 904.722
R1739 VSS.n1135 VSS.n368 882.389
R1740 VSS.t122 VSS.t124 874.312
R1741 VSS.n816 VSS.n639 830.083
R1742 VSS.n1048 VSS.n990 801.995
R1743 VSS.n1173 VSS.n160 793.669
R1744 VSS.n926 VSS.t64 764.707
R1745 VSS.t103 VSS.n444 755.428
R1746 VSS.n832 VSS.n831 753.572
R1747 VSS.n1084 VSS.n1083 740.707
R1748 VSS.n1030 VSS.n990 740.707
R1749 VSS.t265 VSS.n329 738.308
R1750 VSS.t157 VSS.n387 738.308
R1751 VSS.t265 VSS.t189 705.736
R1752 VSS.t214 VSS.t157 705.736
R1753 VSS.n989 VSS.n488 635.364
R1754 VSS.n1085 VSS.n447 635.364
R1755 VSS.n1146 VSS.n359 634.668
R1756 VSS.n26 VSS.n350 634.668
R1757 VSS.n931 VSS.n517 609.375
R1758 VSS.n811 VSS.n801 608.807
R1759 VSS.n810 VSS.n803 608.807
R1760 VSS.n478 VSS.t31 588.941
R1761 VSS.n1050 VSS.t182 588.941
R1762 VSS.n1146 VSS.n356 588
R1763 VSS.n359 VSS.n358 588
R1764 VSS.n358 VSS.n357 588
R1765 VSS.n1151 VSS.n350 588
R1766 VSS.n1151 VSS.n352 588
R1767 VSS.n810 VSS.t56 584.5
R1768 VSS.n812 VSS.n811 584.5
R1769 VSS.n269 VSS.n171 583.25
R1770 VSS.n835 VSS.n834 561.75
R1771 VSS.t68 VSS.t66 549.633
R1772 VSS.n785 VSS.n641 531.188
R1773 VSS.n736 VSS.n719 511.584
R1774 VSS.n731 VSS.n730 511.584
R1775 VSS.n731 VSS.n727 511.584
R1776 VSS.n735 VSS.n727 511.584
R1777 VSS.n723 VSS.n718 511.584
R1778 VSS.n720 VSS.n718 511.584
R1779 VSS.n750 VSS.n720 511.584
R1780 VSS.n750 VSS.n719 511.584
R1781 VSS.n729 VSS.n724 511.584
R1782 VSS.n730 VSS.n729 511.584
R1783 VSS.n1268 VSS.n1267 494.342
R1784 VSS.n851 VSS.t84 489.043
R1785 VSS.n472 VSS.t169 483.298
R1786 VSS.t33 VSS.t31 472.791
R1787 VSS.t182 VSS.n1049 471.041
R1788 VSS.n1123 VSS.n380 462.288
R1789 VSS.n1145 VSS.n351 456.606
R1790 VSS.n1152 VSS.n351 456.606
R1791 VSS.n26 VSS.n1152 456.606
R1792 VSS.n262 VSS.n261 452.106
R1793 VSS.n1133 VSS.n368 414.361
R1794 VSS.n1135 VSS.n1134 414.361
R1795 VSS.n628 VSS.t252 399.765
R1796 VSS.n631 VSS.t255 399.493
R1797 VSS.n931 VSS.t68 394.301
R1798 VSS.n1268 VSS.n169 375.003
R1799 VSS.n1113 VSS.t14 371.214
R1800 VSS.t251 VSS.t143 369.318
R1801 VSS.t254 VSS.t255 366.452
R1802 VSS.t252 VSS.t254 366.452
R1803 VSS.n851 VSS.t162 366.127
R1804 VSS.n808 VSS.n804 363.974
R1805 VSS.n1094 VSS.n110 344.67
R1806 VSS.n1103 VSS.n110 344.67
R1807 VSS.t219 VSS.n593 343.074
R1808 VSS.n857 VSS.t219 343.074
R1809 VSS.t6 VSS.n1143 342.714
R1810 VSS.n852 VSS.t106 338.291
R1811 VSS.n854 VSS.t106 338.291
R1812 VSS.n1265 VSS.n209 333.171
R1813 VSS.n832 VSS.n592 332.777
R1814 VSS.t81 VSS.t5 328.558
R1815 VSS.n1084 VSS.t169 318.697
R1816 VSS.n676 VSS.n675 316.971
R1817 VSS.n1266 VSS.n1265 315.481
R1818 VSS.n694 VSS.n656 308
R1819 VSS.n799 VSS.n798 304.514
R1820 VSS.n960 VSS.t208 299.62
R1821 VSS.n904 VSS.t82 299.62
R1822 VSS.n1292 VSS.n191 299.057
R1823 VSS.n1098 VSS.n1097 299.057
R1824 VSS.n942 VSS.n519 299.057
R1825 VSS.n871 VSS.n870 299.057
R1826 VSS.n56 VSS.n145 298.084
R1827 VSS.n881 VSS.n495 291.18
R1828 VSS.n1332 VSS.n146 284.084
R1829 VSS.n1044 VSS.n487 278.098
R1830 VSS.n1141 VSS.t235 277.933
R1831 VSS.n572 VSS.n554 274.557
R1832 VSS.n576 VSS.n572 274.557
R1833 VSS.t33 VSS.n1061 273.947
R1834 VSS.n1085 VSS.n1084 270.223
R1835 VSS.n990 VSS.n989 270.223
R1836 VSS.n1123 VSS.n381 270.084
R1837 VSS.n1144 VSS.t6 267.757
R1838 VSS.n833 VSS.n619 260.454
R1839 VSS.n206 VSS.n188 258.029
R1840 VSS.n1295 VSS.n188 258.029
R1841 VSS.n445 VSS.t86 254.756
R1842 VSS.n1068 VSS.n462 254.756
R1843 VSS.n538 VSS.n528 247.244
R1844 VSS.n807 VSS.n374 244.767
R1845 VSS.t132 VSS.t86 243.517
R1846 VSS.t186 VSS.n1068 243.517
R1847 VSS.n41 VSS.n283 243.05
R1848 VSS.n1267 VSS.n1266 242.952
R1849 VSS.t23 VSS.n866 238.129
R1850 VSS.n1164 VSS.n339 236.833
R1851 VSS.n1102 VSS.n1101 234.695
R1852 VSS.n654 VSS.n146 233.917
R1853 VSS.n798 VSS.n641 233
R1854 VSS.n689 VSS.n688 231.988
R1855 VSS.n1104 VSS.n1103 230.404
R1856 VSS.n257 VSS.n175 226.571
R1857 VSS.n914 VSS.n553 224.779
R1858 VSS.n1133 VSS.n1132 224.389
R1859 VSS.n804 VSS.n364 221.57
R1860 VSS.n873 VSS.n872 220.889
R1861 VSS.n1102 VSS.n436 214.923
R1862 VSS.t152 VSS.n698 211.582
R1863 VSS.n576 VSS.n553 210.195
R1864 VSS.n1296 VSS.n187 207.862
R1865 VSS.n1273 VSS.n207 204.362
R1866 VSS.n954 VSS.t210 203.767
R1867 VSS.n964 VSS.t28 203.767
R1868 VSS.n908 VSS.t117 203.767
R1869 VSS.n666 VSS.n651 203.583
R1870 VSS.n831 VSS.t159 202.56
R1871 VSS.n863 VSS.t159 202.56
R1872 VSS.n779 VSS.t211 202.387
R1873 VSS.t54 VSS.n336 200.083
R1874 VSS.t92 VSS.n987 200.083
R1875 VSS.n1022 VSS.t154 200.083
R1876 VSS.n421 VSS.t212 200.083
R1877 VSS.n297 VSS.n258 199.001
R1878 VSS.n1232 VSS.n1231 199.001
R1879 VSS.n337 VSS.n329 195.435
R1880 VSS.n1112 VSS.n387 195.435
R1881 VSS.n1191 VSS.n328 195.222
R1882 VSS.n1245 VSS.n202 195.222
R1883 VSS.n1019 VSS.n440 195.222
R1884 VSS.n461 VSS.n459 195.222
R1885 VSS.n423 VSS.n392 195.222
R1886 VSS.n1296 VSS.n1295 194.056
R1887 VSS.n688 VSS.n664 193.667
R1888 VSS.n1184 VSS.n1175 186.279
R1889 VSS.n1234 VSS.n1233 186.279
R1890 VSS.n1028 VSS.n1026 186.279
R1891 VSS.n982 VSS.n452 186.279
R1892 VSS.n290 VSS.n289 186.279
R1893 VSS.n293 VSS.n292 186.279
R1894 VSS.n292 VSS.n259 186.279
R1895 VSS.n64 VSS.n386 186.279
R1896 VSS.n1007 VSS.n485 185.012
R1897 VSS.n236 VSS.n213 185.001
R1898 VSS.n479 VSS.n449 185.001
R1899 VSS.n897 VSS.n890 183.268
R1900 VSS.n1096 VSS.n1095 183.07
R1901 VSS.n1308 VSS.n178 182.244
R1902 VSS.t66 VSS.t64 179.228
R1903 VSS.n1131 VSS.t235 178.672
R1904 VSS.n1186 VSS.n1185 178.112
R1905 VSS.n224 VSS.n201 178.112
R1906 VSS.n1027 VSS.n439 178.112
R1907 VSS.n1071 VSS.n1070 178.112
R1908 VSS.n264 VSS.n263 178.112
R1909 VSS.n406 VSS.n391 178.112
R1910 VSS.t202 VSS.n792 177.964
R1911 VSS.n777 VSS.n698 177.416
R1912 VSS.n161 VSS.n55 176.362
R1913 VSS.n936 VSS.n520 176.167
R1914 VSS.n537 VSS.n536 176.035
R1915 VSS.n1332 VSS.n145 173.833
R1916 VSS.n162 VSS.n55 172.862
R1917 VSS.n1101 VSS.n109 172.764
R1918 VSS.n91 VSS.t173 172.334
R1919 VSS.t184 VSS.n91 172.334
R1920 VSS.n1094 VSS.t184 172.334
R1921 VSS.t100 VSS.t112 170.363
R1922 VSS.n654 VSS.n653 170.333
R1923 VSS.n661 VSS.n651 170.333
R1924 VSS.n1026 VSS.n1025 169.587
R1925 VSS.n1175 VSS.n312 169.587
R1926 VSS.n1233 VSS.n218 169.587
R1927 VSS.n983 VSS.n982 169.587
R1928 VSS.n64 VSS.n385 169.587
R1929 VSS.t234 VSS.n939 169.404
R1930 VSS.n759 VSS.n758 169.32
R1931 VSS.n1203 VSS.n315 165.107
R1932 VSS.n1080 VSS.n1079 165.107
R1933 VSS.n1035 VSS.n1034 165.107
R1934 VSS.n403 VSS.n402 165.107
R1935 VSS.n947 VSS.t225 160.361
R1936 VSS.n939 VSS.t156 160.361
R1937 VSS.n954 VSS.t218 160.361
R1938 VSS.t63 VSS.n964 160.361
R1939 VSS.t111 VSS.n496 160.361
R1940 VSS.n897 VSS.t111 160.361
R1941 VSS.t133 VSS.n908 160.361
R1942 VSS.n909 VSS.t133 160.361
R1943 VSS.n909 VSS.t41 160.361
R1944 VSS.n911 VSS.t41 160.361
R1945 VSS.n574 VSS.t206 160.361
R1946 VSS.t115 VSS.n574 160.361
R1947 VSS.t240 VSS.n441 159.846
R1948 VSS.n972 VSS.t138 159.846
R1949 VSS.n1317 VSS.n171 158.638
R1950 VSS.n81 VSS.n809 156.011
R1951 VSS.n1305 VSS.n178 155.507
R1952 VSS.n925 VSS.n529 154.389
R1953 VSS.n1086 VSS.n443 154.389
R1954 VSS.n584 VSS.n490 154.389
R1955 VSS.n27 VSS.n594 153.222
R1956 VSS.t216 VSS.t148 152.95
R1957 VSS.n1185 VSS.n1184 152.445
R1958 VSS.n1234 VSS.n224 152.445
R1959 VSS.n1028 VSS.n1027 152.445
R1960 VSS.n1071 VSS.n452 152.445
R1961 VSS.n263 VSS.n259 152.445
R1962 VSS.n406 VSS.n386 152.445
R1963 VSS.n1168 VSS.n334 151.57
R1964 VSS.n987 VSS.n981 147.945
R1965 VSS.n336 VSS.n311 147.879
R1966 VSS.n1256 VSS.n217 147.879
R1967 VSS.n1022 VSS.n1018 147.879
R1968 VSS.n421 VSS.n395 147.879
R1969 VSS.n1168 VSS.n1167 147.487
R1970 VSS.n965 VSS.n496 145.288
R1971 VSS.n1315 VSS.n1314 144.15
R1972 VSS.n1293 VSS.n1292 143.5
R1973 VSS.n1099 VSS.n1098 143.5
R1974 VSS.n531 VSS.n519 143.5
R1975 VSS.n870 VSS.n578 143.5
R1976 VSS.n99 VSS.n515 141.803
R1977 VSS.n293 VSS.n291 141.362
R1978 VSS.n549 VSS.n548 140.466
R1979 VSS.n369 VSS.n363 138.056
R1980 VSS.n1132 VSS.n370 138.056
R1981 VSS.t53 VSS.t96 136.867
R1982 VSS.t168 VSS.t246 133.919
R1983 VSS.n947 VSS.n517 132.629
R1984 VSS.n912 VSS.n911 132.629
R1985 VSS.n4 VSS.n434 131.833
R1986 VSS.n969 VSS.n494 131.833
R1987 VSS.n527 VSS.n526 131.833
R1988 VSS.n630 VSS.n628 129.994
R1989 VSS.n647 VSS.n649 129.994
R1990 VSS.n1204 VSS.n314 129.624
R1991 VSS.n976 VSS.n455 129.624
R1992 VSS.n1002 VSS.n446 129.624
R1993 VSS.n401 VSS.n388 129.624
R1994 VSS.n797 VSS.n642 128.535
R1995 VSS.n822 VSS.n821 127.657
R1996 VSS.n1290 VSS.n195 126.972
R1997 VSS.n944 VSS.n518 126.876
R1998 VSS.n579 VSS.n551 126.876
R1999 VSS.n1324 VSS.n162 126.195
R2000 VSS.n936 VSS.n523 126.105
R2001 VSS.n534 VSS.n165 126.097
R2002 VSS.n1263 VSS.t75 125.46
R2003 VSS.n815 VSS.t168 125.138
R2004 VSS.n328 VSS.n323 124.251
R2005 VSS.n1284 VSS.n202 124.251
R2006 VSS.n3 VSS.n440 124.251
R2007 VSS.n1069 VSS.n459 124.251
R2008 VSS.n426 VSS.n392 124.251
R2009 VSS.n883 VSS.n10 124.056
R2010 VSS.n1159 VSS.n1158 123.862
R2011 VSS.n794 VSS.n73 123.862
R2012 VSS.t266 VSS.t54 123.106
R2013 VSS.t88 VSS.t92 123.106
R2014 VSS.t154 VSS.t87 123.106
R2015 VSS.t212 VSS.t158 123.106
R2016 VSS.n56 VSS.n159 122.695
R2017 VSS.n1324 VSS.n161 122.695
R2018 VSS.n653 VSS.n334 122.695
R2019 VSS.n941 VSS.n940 122.501
R2020 VSS.n940 VSS.n521 122.501
R2021 VSS.t229 VSS.n18 89.8611
R2022 VSS.n545 VSS.n544 121.778
R2023 VSS.n1339 VSS.n136 121.373
R2024 VSS.n743 VSS.n650 120.945
R2025 VSS.n298 VSS.n196 120.945
R2026 VSS.n1229 VSS.n119 120.945
R2027 VSS.n1029 VSS.n1005 120.945
R2028 VSS.n1082 VSS.n450 120.945
R2029 VSS.t57 VSS.t115 119.367
R2030 VSS.n283 VSS.n265 118.9
R2031 VSS.n652 VSS.n145 118.213
R2032 VSS.n819 VSS.n633 117.793
R2033 VSS.n1334 VSS.n1333 117.505
R2034 VSS.n1049 VSS.n1048 117.323
R2035 VSS.n1204 VSS.n1203 116.59
R2036 VSS.n1079 VSS.n455 116.59
R2037 VSS.n1035 VSS.n1002 116.59
R2038 VSS.n403 VSS.n401 116.59
R2039 VSS.n757 VSS.n704 116.57
R2040 VSS.n762 VSS.n710 116.57
R2041 VSS.n1317 VSS.n168 116.558
R2042 VSS.n1171 VSS.n1170 116.487
R2043 VSS.n545 VSS.t35 116.352
R2044 VSS.t33 VSS.n472 115.572
R2045 VSS.n1191 VSS.n327 115.501
R2046 VSS.n336 VSS.n327 115.501
R2047 VSS.n1190 VSS.n328 115.501
R2048 VSS.n1245 VSS.n1243 115.501
R2049 VSS.n1243 VSS.n217 115.501
R2050 VSS.n1251 VSS.n202 115.501
R2051 VSS.n1040 VSS.n440 115.501
R2052 VSS.n1019 VSS.n998 115.501
R2053 VSS.n1022 VSS.n998 115.501
R2054 VSS.n987 VSS.n978 115.501
R2055 VSS.n978 VSS.n461 115.501
R2056 VSS.n1067 VSS.n459 115.501
R2057 VSS.n423 VSS.n422 115.501
R2058 VSS.n422 VSS.n421 115.501
R2059 VSS.n413 VSS.n392 115.501
R2060 VSS.n798 VSS.n797 115.138
R2061 VSS.t237 VSS.t239 114.891
R2062 VSS.t136 VSS.t140 114.891
R2063 VSS.n1320 VSS.n168 112.912
R2064 VSS.n534 VSS.n523 112.195
R2065 VSS.n533 VSS.n518 112.001
R2066 VSS.n869 VSS.n579 112.001
R2067 VSS.n1291 VSS.n1290 111.903
R2068 VSS.n90 VSS.n430 111.903
R2069 VSS.n208 VSS.t3 111.867
R2070 VSS.n548 VSS.n539 109.721
R2071 VSS.n626 VSS.n625 107.334
R2072 VSS.n782 VSS.n642 107.334
R2073 VSS.n627 VSS.n626 105.389
R2074 VSS.n884 VSS.n561 105.267
R2075 VSS.n895 VSS.n892 105.267
R2076 VSS.n540 VSS.n503 105.267
R2077 VSS.n1309 VSS.n177 103.572
R2078 VSS.t206 VSS.n565 102.487
R2079 VSS.n768 VSS.n708 100.722
R2080 VSS.n663 VSS.n656 99.3616
R2081 VSS.n1131 VSS.n1130 99.2624
R2082 VSS.n761 VSS.n751 98.6558
R2083 VSS.n791 VSS.n780 98.4296
R2084 VSS.n828 VSS.n622 96.2116
R2085 VSS.n28 VSS.n622 96.2116
R2086 VSS.n1337 VSS.n139 96.0561
R2087 VSS.n134 VSS.n139 96.0561
R2088 VSS.n140 VSS.n132 96.0561
R2089 VSS.n133 VSS.n140 96.0561
R2090 VSS.n1307 VSS.n179 96.0561
R2091 VSS.n929 VSS.n43 96.0561
R2092 VSS.n974 VSS.n489 96.0561
R2093 VSS.n1140 VSS.n364 95.0838
R2094 VSS.n1129 VSS.n374 95.0838
R2095 VSS.n783 VSS.n782 94.5977
R2096 VSS.n280 VSS.n175 92.7505
R2097 VSS.n843 VSS.n842 92.7505
R2098 VSS.n752 VSS.n699 92.5561
R2099 VSS.n753 VSS.n752 92.5561
R2100 VSS.n925 VSS.n526 92.5561
R2101 VSS.n1086 VSS.n434 92.5561
R2102 VSS.n2 VSS.n442 92.5561
R2103 VSS.n584 VSS.n494 92.5561
R2104 VSS.n694 VSS.n657 92.5561
R2105 VSS.n668 VSS.n339 92.5561
R2106 VSS.n1164 VSS.n340 92.5561
R2107 VSS.n772 VSS.n702 92.5561
R2108 VSS.n772 VSS.n701 92.5561
R2109 VSS.n864 VSS.n863 92.2376
R2110 VSS.n1312 VSS.n175 91.3292
R2111 VSS.n537 VSS.n510 90.429
R2112 VSS.n265 VSS.n260 90.1005
R2113 VSS.n1294 VSS.n189 89.8338
R2114 VSS.n1100 VSS.n437 89.8338
R2115 VSS.n577 VSS.n575 89.8338
R2116 VSS.n921 VSS.n920 88.5513
R2117 VSS.n1006 VSS.n993 88.5513
R2118 VSS.n477 VSS.n476 88.5513
R2119 VSS.n807 VSS.n18 111.534
R2120 VSS.n256 VSS.n177 87.7591
R2121 VSS.n825 VSS.n623 85.9449
R2122 VSS.n825 VSS.n624 85.9449
R2123 VSS.n791 VSS.n781 85.9449
R2124 VSS.t2 VSS.n759 85.8951
R2125 VSS.n937 VSS.n515 84.2996
R2126 VSS.n1104 VSS.n435 83.67
R2127 VSS.n968 VSS.n967 83.67
R2128 VSS.n626 VSS.n624 83.6116
R2129 VSS.n782 VSS.n781 83.6116
R2130 VSS.n1171 VSS.n332 82.8809
R2131 VSS.t239 VSS.n435 82.4213
R2132 VSS.n967 VSS.t140 82.4213
R2133 VSS.n625 VSS.n622 82.2505
R2134 VSS.n541 VSS.n509 81.8616
R2135 VSS.n899 VSS.n498 81.8616
R2136 VSS.n563 VSS.n557 81.8616
R2137 VSS.n859 VSS.n858 81.6239
R2138 VSS.n853 VSS.n616 81.6238
R2139 VSS.n265 VSS.n168 81.4356
R2140 VSS.n1167 VSS.n159 81.3755
R2141 VSS.n852 VSS.n851 80.5457
R2142 VSS.n1308 VSS.n1307 80.2088
R2143 VSS.n1188 VSS.n327 79.7227
R2144 VSS.n1243 VSS.n1242 79.7227
R2145 VSS.n1038 VSS.n998 79.7227
R2146 VSS.n978 VSS.n977 79.7227
R2147 VSS.n422 VSS.n394 79.7227
R2148 VSS.n1186 VSS.n323 77.5838
R2149 VSS.n1284 VSS.n201 77.5838
R2150 VSS.n3 VSS.n439 77.5838
R2151 VSS.n1070 VSS.n1069 77.5838
R2152 VSS.n41 VSS.n264 77.5838
R2153 VSS.n426 VSS.n391 77.5838
R2154 VSS.n945 VSS.n210 76.5633
R2155 VSS.n1310 VSS.n1309 76.3199
R2156 VSS.n1170 VSS.n1169 76.2663
R2157 VSS.n844 VSS.n843 76.1815
R2158 VSS.t202 VSS.n779 74.9182
R2159 VSS.n562 VSS.n561 74.7644
R2160 VSS.n895 VSS.n497 74.7644
R2161 VSS.n540 VSS.n508 74.7644
R2162 VSS.n814 VSS.n813 73.8205
R2163 VSS.n786 VSS.t246 73.1344
R2164 VSS.n682 VSS.n680 73.1116
R2165 VSS.t245 VSS.t244 72.9972
R2166 VSS.n938 VSS.n937 72.7227
R2167 VSS.n546 VSS.n541 72.7227
R2168 VSS.n899 VSS.n898 72.7227
R2169 VSS.n910 VSS.n557 72.7227
R2170 VSS.n875 VSS.n566 72.7227
R2171 VSS.n875 VSS.n567 72.7227
R2172 VSS.n879 VSS.n567 72.7227
R2173 VSS.n879 VSS.n566 72.7227
R2174 VSS.n1336 VSS.n1335 72.7152
R2175 VSS.n611 VSS.n606 72.2631
R2176 VSS.n1262 VSS.n213 72.2631
R2177 VSS.n479 VSS.n478 72.2631
R2178 VSS.n679 VSS.n676 72.2631
R2179 VSS.n1050 VSS.n485 72.1995
R2180 VSS.n958 VSS.n503 69.9439
R2181 VSS.n886 VSS.n884 69.7537
R2182 VSS.n951 VSS.n511 69.7537
R2183 VSS.n902 VSS.n892 69.7537
R2184 VSS.n529 VSS.n43 68.8806
R2185 VSS.n2 VSS.n443 68.8806
R2186 VSS.n974 VSS.n490 68.8806
R2187 VSS.n1161 VSS.n344 68.6394
R2188 VSS.n140 VSS.n139 68.4449
R2189 VSS.n778 VSS.t176 68.332
R2190 VSS.n754 VSS.t128 68.332
R2191 VSS.t130 VSS.n760 68.332
R2192 VSS.n1181 VSS.n1180 68.2505
R2193 VSS.n1178 VSS.n1177 68.2505
R2194 VSS.n1197 VSS.n321 68.2505
R2195 VSS.n123 VSS.n1199 68.2505
R2196 VSS.n1210 VSS.n302 68.2505
R2197 VSS.n1209 VSS.n303 68.2505
R2198 VSS.n1075 VSS.n451 68.2505
R2199 VSS.n1074 VSS.n457 68.2505
R2200 VSS.n1227 VSS.n233 68.2505
R2201 VSS.n1226 VSS.n244 68.2505
R2202 VSS.n1237 VSS.n229 68.2505
R2203 VSS.n1238 VSS.n228 68.2505
R2204 VSS.n241 VSS.n226 68.2505
R2205 VSS.n240 VSS.n237 68.2505
R2206 VSS.n1012 VSS.n1011 68.2505
R2207 VSS.t8 VSS.n8 0.589596
R2208 VSS.n1043 VSS.n994 68.2505
R2209 VSS.n101 VSS.n979 68.2505
R2210 VSS.n62 VSS.n33 0.589596
R2211 VSS.n1015 VSS.n1014 68.2505
R2212 VSS.n103 VSS.n1013 68.2505
R2213 VSS.n1217 VSS.n1216 68.2505
R2214 VSS.n254 VSS.n255 68.2505
R2215 VSS.n248 VSS.n250 68.2505
R2216 VSS.n1222 VSS.n1221 68.2505
R2217 VSS.n285 VSS.n284 68.2505
R2218 VSS.n60 VSS.t62 0.589596
R2219 VSS.n125 VSS.n1064 68.2505
R2220 VSS.n467 VSS.n468 68.2505
R2221 VSS.n54 VSS.n25 1.60196
R2222 VSS.n415 VSS.n407 68.2505
R2223 VSS.n418 VSS.n417 68.2505
R2224 VSS.n411 VSS.n408 68.2505
R2225 VSS.n410 VSS.n384 68.2505
R2226 VSS.t225 VSS.n946 67.5204
R2227 VSS.t7 VSS.n445 67.4357
R2228 VSS.n988 VSS.n462 67.4357
R2229 VSS.n1302 VSS.n1300 66.6949
R2230 VSS.n4 VSS.n433 66.6949
R2231 VSS.n970 VSS.n969 66.6949
R2232 VSS.n527 VSS.n524 66.6949
R2233 VSS.n843 VSS.n836 66.4455
R2234 VSS.t20 VSS.n273 65.475
R2235 VSS.n1181 VSS.n1176 64.2445
R2236 VSS.t98 VSS.n1178 64.2445
R2237 VSS.n1199 VSS.n1198 64.2445
R2238 VSS.n321 VSS.t174 64.2445
R2239 VSS.n304 VSS.n303 64.2445
R2240 VSS.t171 VSS.n302 64.2445
R2241 VSS.n458 VSS.n457 64.2445
R2242 VSS.t29 VSS.n451 64.2445
R2243 VSS.n245 VSS.n244 64.2445
R2244 VSS.t222 VSS.n233 64.2445
R2245 VSS.t89 VSS.n1011 64.2445
R2246 VSS.n40 VSS.n39 0.589596
R2247 VSS.n8 VSS.n994 64.2543
R2248 VSS.n101 VSS.n62 1.08761
R2249 VSS.t24 VSS.n979 64.2445
R2250 VSS.n1016 VSS.n1013 64.2445
R2251 VSS.t79 VSS.n1014 64.2445
R2252 VSS.n238 VSS.n237 64.2445
R2253 VSS.t256 VSS.n226 64.2445
R2254 VSS.n1238 VSS.n230 64.2445
R2255 VSS.t227 VSS.n1237 64.2445
R2256 VSS.n1221 VSS.n249 64.2445
R2257 VSS.n250 VSS.t36 64.2445
R2258 VSS.n1216 VSS.t73 64.2445
R2259 VSS.n255 VSS.n252 64.2445
R2260 VSS.n60 VSS.n284 64.2543
R2261 VSS.n1064 VSS.t150 64.2445
R2262 VSS.n468 VSS.n466 64.2445
R2263 VSS.n417 VSS.n416 64.2445
R2264 VSS.n407 VSS.t93 64.2445
R2265 VSS.n409 VSS.n384 64.2445
R2266 VSS.t196 VSS.n408 64.2445
R2267 VSS.n780 VSS.n642 64.2074
R2268 VSS.n373 VSS.n370 64.0699
R2269 VSS.n1325 VSS.t191 64.0043
R2270 VSS.n257 VSS.n256 63.9727
R2271 VSS.n920 VSS.n236 63.9727
R2272 VSS.n1007 VSS.n1006 63.9727
R2273 VSS.n476 VSS.n449 63.9727
R2274 VSS.n867 VSS.t23 63.9033
R2275 VSS.n604 VSS.n603 63.0977
R2276 VSS.n850 VSS.n618 63.0977
R2277 VSS.n1095 VSS.n437 62.3199
R2278 VSS.n839 VSS.n618 61.718
R2279 VSS.n603 VSS.n599 61.718
R2280 VSS.n605 VSS.n604 61.4936
R2281 VSS.n850 VSS.n836 61.4936
R2282 VSS.n1254 VSS.n1253 59.7431
R2283 VSS.n543 VSS.n501 59.6833
R2284 VSS.n738 VSS.n598 59.5555
R2285 VSS.n369 VSS.n362 59.4033
R2286 VSS.n607 VSS.n600 58.3338
R2287 VSS.n271 VSS.n176 58.3338
R2288 VSS.n922 VSS.n212 58.3338
R2289 VSS.n1046 VSS.n486 58.3338
R2290 VSS.n1059 VSS.n471 58.3338
R2291 VSS.n620 VSS.n595 58.3338
R2292 VSS.n621 VSS.n596 58.3338
R2293 VSS.n845 VSS.n838 58.3338
R2294 VSS.n375 VSS.n365 58.3338
R2295 VSS.n667 VSS.n154 58.3338
R2296 VSS.n681 VSS.n149 58.3338
R2297 VSS.n641 VSS.n640 58.3338
R2298 VSS.n9 VSS.t8 0.697744
R2299 VSS.n493 VSS.n492 57.9449
R2300 VSS.n973 VSS.n492 57.9449
R2301 VSS.n932 VSS.n525 57.9449
R2302 VSS.n92 VSS.n525 57.9449
R2303 VSS.n276 VSS.n184 57.9449
R2304 VSS.n277 VSS.n276 57.9449
R2305 VSS.n880 VSS.n565 57.8747
R2306 VSS.n547 VSS.n541 57.1672
R2307 VSS.n900 VSS.n899 57.1672
R2308 VSS.n560 VSS.n557 57.1672
R2309 VSS.n615 VSS.n599 56.8341
R2310 VSS.n921 VSS.n919 56.8341
R2311 VSS.n993 VSS.n992 56.8341
R2312 VSS.n477 VSS.n470 56.8341
R2313 VSS.n839 VSS.n597 56.8341
R2314 VSS.n937 VSS.n516 54.9236
R2315 VSS.n727 VSS.n719 53.6672
R2316 VSS.n730 VSS.n720 53.6672
R2317 VSS.n724 VSS.n723 53.6672
R2318 VSS.n207 VSS.n191 53.6672
R2319 VSS.n207 VSS.n206 53.6672
R2320 VSS.n1294 VSS.n1293 53.6672
R2321 VSS.n1295 VSS.n1294 53.6672
R2322 VSS.n824 VSS.n623 53.6672
R2323 VSS.n1100 VSS.n1099 53.6672
R2324 VSS.n1101 VSS.n1100 53.6672
R2325 VSS.n1097 VSS.n1096 53.6672
R2326 VSS.n1134 VSS.n1133 53.6672
R2327 VSS.n811 VSS.n810 53.6672
R2328 VSS.n533 VSS.n519 53.6672
R2329 VSS.n941 VSS.n520 53.6672
R2330 VSS.n942 VSS.n941 53.6672
R2331 VSS.n577 VSS.n576 53.6672
R2332 VSS.n578 VSS.n577 53.6672
R2333 VSS.n872 VSS.n554 53.6672
R2334 VSS.n872 VSS.n871 53.6672
R2335 VSS.n788 VSS.n780 53.6672
R2336 VSS.n313 VSS.n311 53.1767
R2337 VSS.n1257 VSS.n1256 53.1767
R2338 VSS.n1018 VSS.n1017 53.1767
R2339 VSS.n107 VSS.n395 53.1767
R2340 VSS.n981 VSS.n980 53.1111
R2341 VSS.n1096 VSS.n436 52.3777
R2342 VSS.n770 VSS.n704 51.7227
R2343 VSS.n766 VSS.n710 51.7227
R2344 VSS.n625 VSS.n623 51.7227
R2345 VSS.n886 VSS.n883 51.7227
R2346 VSS.n952 VSS.n951 51.7227
R2347 VSS.n958 VSS.n502 51.7227
R2348 VSS.n902 VSS.n891 51.7227
R2349 VSS.n794 VSS.n644 51.7227
R2350 VSS.n757 VSS.n755 51.6255
R2351 VSS.n762 VSS.n717 51.6255
R2352 VSS.t42 VSS.n888 1.00072
R2353 VSS.n961 VSS.t42 1.00006
R2354 VSS.n948 VSS.t42 1.00026
R2355 VSS.n70 VSS.t42 1.02007
R2356 VSS.n776 VSS.n73 51.6255
R2357 VSS.n800 VSS.n799 51.4017
R2358 VSS.n121 VSS.n526 50.9449
R2359 VSS.n1091 VSS.n434 50.9449
R2360 VSS.n53 VSS.n494 50.9449
R2361 VSS.n539 VSS.t218 50.6405
R2362 VSS.n344 VSS.n338 50.3616
R2363 VSS.n672 VSS.n344 50.3616
R2364 VSS.n533 VSS.n532 50.1672
R2365 VSS.n532 VSS.n531 50.1672
R2366 VSS.n20 VSS.n783 49.5838
R2367 VSS.n684 VSS.n666 49.143
R2368 VSS.n610 VSS.n606 48.8582
R2369 VSS.n213 VSS.n211 48.8582
R2370 VSS.n1058 VSS.n479 48.8582
R2371 VSS.n676 VSS.n151 48.8582
R2372 VSS.n1047 VSS.n485 48.8472
R2373 VSS.n913 VSS.n555 48.8319
R2374 VSS.t191 VSS.n160 48.7756
R2375 VSS.n550 VSS.n530 48.7088
R2376 VSS.n868 VSS.n580 48.7088
R2377 VSS.n605 VSS.n381 48.2713
R2378 VSS.n836 VSS.n835 48.2713
R2379 VSS.n347 VSS.n344 47.9311
R2380 VSS.n717 VSS.n716 47.6394
R2381 VSS.n610 VSS.n607 47.4449
R2382 VSS.n609 VSS.n607 47.4449
R2383 VSS.n611 VSS.n600 47.4449
R2384 VSS.n614 VSS.n600 47.4449
R2385 VSS.n1310 VSS.n176 47.4449
R2386 VSS.n1312 VSS.n176 47.4449
R2387 VSS.n271 VSS.n268 47.4449
R2388 VSS.n280 VSS.n271 47.4449
R2389 VSS.n922 VSS.n211 47.4449
R2390 VSS.n923 VSS.n922 47.4449
R2391 VSS.n1262 VSS.n212 47.4449
R2392 VSS.n918 VSS.n212 47.4449
R2393 VSS.n991 VSS.n486 47.4449
R2394 VSS.n1050 VSS.n486 47.4449
R2395 VSS.n1046 VSS.n1045 47.4449
R2396 VSS.n1047 VSS.n1046 47.4449
R2397 VSS.n478 VSS.n471 47.4449
R2398 VSS.n1062 VSS.n471 47.4449
R2399 VSS.n1059 VSS.n1058 47.4449
R2400 VSS.n1060 VSS.n1059 47.4449
R2401 VSS.n596 VSS.n594 47.4449
R2402 VSS.n862 VSS.n596 47.4449
R2403 VSS.n862 VSS.n595 47.4449
R2404 VSS.n828 VSS.n595 47.4449
R2405 VSS.n621 VSS.n27 47.4449
R2406 VSS.n830 VSS.n621 47.4449
R2407 VSS.n830 VSS.n620 47.4449
R2408 VSS.n28 VSS.n620 47.4449
R2409 VSS.n845 VSS.n844 47.4449
R2410 VSS.n846 VSS.n845 47.4449
R2411 VSS.n842 VSS.n838 47.4449
R2412 VSS.n840 VSS.n838 47.4449
R2413 VSS.n365 VSS.n362 47.4449
R2414 VSS.n1140 VSS.n365 47.4449
R2415 VSS.n375 VSS.n373 47.4449
R2416 VSS.n1129 VSS.n375 47.4449
R2417 VSS.n674 VSS.n667 47.4449
R2418 VSS.n684 VSS.n667 47.4449
R2419 VSS.n154 VSS.n150 47.4449
R2420 VSS.n152 VSS.n154 47.4449
R2421 VSS.n151 VSS.n149 47.4449
R2422 VSS.n1328 VSS.n149 47.4449
R2423 VSS.n681 VSS.n679 47.4449
R2424 VSS.n682 VSS.n681 47.4449
R2425 VSS.n800 VSS.n640 47.4449
R2426 VSS.n20 VSS.n640 47.4449
R2427 VSS.n603 VSS.n380 46.6672
R2428 VSS.n619 VSS.n618 46.6672
R2429 VSS.n357 VSS.n356 46.6672
R2430 VSS.n357 VSS.n352 46.6672
R2431 VSS.n359 VSS.n350 46.6672
R2432 VSS.n352 VSS.n72 81.6794
R2433 VSS.n1170 VSS.n162 46.6672
R2434 VSS.n755 VSS.n753 46.5894
R2435 VSS.n268 VSS.n177 46.3755
R2436 VSS.n615 VSS.n614 46.1362
R2437 VSS.n919 VSS.n918 46.1362
R2438 VSS.n992 VSS.n991 46.1362
R2439 VSS.n1062 VSS.n470 46.1362
R2440 VSS.n846 VSS.n597 46.1362
R2441 VSS.n382 VSS.n381 45.4305
R2442 VSS.n835 VSS.n617 45.4305
R2443 VSS.n619 VSS.n617 45.4305
R2444 VSS.n689 VSS.n663 44.7227
R2445 VSS.n661 VSS.n657 44.7227
R2446 VSS.t35 VSS.t39 44.009
R2447 VSS.n674 VSS.n333 43.9449
R2448 VSS.n333 VSS.n150 43.9449
R2449 VSS.n1270 VSS.n171 42.8691
R2450 VSS.n1202 VSS.n316 42.5838
R2451 VSS.n234 VSS.n220 42.5838
R2452 VSS.n1036 VSS.n1000 42.5838
R2453 VSS.n1078 VSS.n453 42.5838
R2454 VSS.n404 VSS.n400 42.5838
R2455 VSS.n152 VSS.n153 42.2023
R2456 VSS.n968 VSS.n966 41.8353
R2457 VSS.n609 VSS.n599 41.8061
R2458 VSS.n923 VSS.n921 41.8061
R2459 VSS.n1045 VSS.n993 41.8061
R2460 VSS.n1060 VSS.n477 41.8061
R2461 VSS.n840 VSS.n839 41.8061
R2462 VSS.n1328 VSS.n148 41.8061
R2463 VSS.n516 VSS.n511 41.6116
R2464 VSS.n652 VSS.n159 41.3199
R2465 VSS.n776 VSS.n699 41.1255
R2466 VSS.n1282 VSS.n205 41.0742
R2467 VSS.n1273 VSS.n189 41.0283
R2468 VSS.n874 VSS.t57 40.9948
R2469 VSS.n799 VSS.n21 40.2715
R2470 VSS.n1088 VSS.n442 40.2505
R2471 VSS.n337 VSS.n314 39.1048
R2472 VSS.n988 VSS.n976 39.1048
R2473 VSS.t7 VSS.n446 39.1048
R2474 VSS.n1112 VSS.n388 39.1048
R2475 VSS.n81 VSS.t38 37.871
R2476 VSS.n813 VSS.t38 37.871
R2477 VSS.t16 VSS.n814 37.871
R2478 VSS.n751 VSS.t91 37.871
R2479 VSS.n725 VSS.t91 37.871
R2480 VSS.n337 VSS.t266 37.6565
R2481 VSS.n988 VSS.t88 37.6565
R2482 VSS.t7 VSS.t87 37.6565
R2483 VSS.n1112 VSS.t158 37.6565
R2484 VSS.n1190 VSS.n1189 37.4797
R2485 VSS.n1251 VSS.n222 37.4797
R2486 VSS.n1040 VSS.n1039 37.4797
R2487 VSS.n1067 VSS.n463 37.4797
R2488 VSS.n414 VSS.n413 37.4797
R2489 VSS.t237 VSS.t240 37.4645
R2490 VSS.t138 VSS.t136 37.4645
R2491 VSS.n859 VSS.n597 37.3691
R2492 VSS.n616 VSS.n615 37.3691
R2493 VSS.t56 VSS.n72 0.00820117
R2494 VSS.n185 VSS.n179 36.7505
R2495 VSS.n491 VSS.n489 36.7505
R2496 VSS.n930 VSS.n929 36.7505
R2497 VSS.t244 VSS.n786 36.4989
R2498 VSS.n787 VSS.t245 36.4989
R2499 VSS.n787 VSS.t199 36.4989
R2500 VSS.n792 VSS.t199 36.4989
R2501 VSS.n77 VSS.n859 36.4168
R2502 VSS.n114 VSS.n616 36.4168
R2503 VSS.n680 VSS.n148 35.348
R2504 VSS.n690 VSS.n689 35.18
R2505 VSS.n690 VSS.n661 35.18
R2506 VSS.n1122 VSS.n382 35.0005
R2507 VSS.n1291 VSS.n194 34.6116
R2508 VSS.n1108 VSS.n430 34.6116
R2509 VSS.n550 VSS.n533 34.6116
R2510 VSS.n869 VSS.n868 34.6116
R2511 VSS.n1184 VSS.n1183 33.8338
R2512 VSS.n1183 VSS.n316 33.8338
R2513 VSS.n1189 VSS.n1187 33.8338
R2514 VSS.n1185 VSS.n330 33.8338
R2515 VSS.n330 VSS.n317 33.8338
R2516 VSS.n1235 VSS.n1234 33.8338
R2517 VSS.n1235 VSS.n234 33.8338
R2518 VSS.n222 VSS.n200 33.8338
R2519 VSS.n1240 VSS.n224 33.8338
R2520 VSS.n1241 VSS.n1240 33.8338
R2521 VSS.n34 VSS.n1028 33.8338
R2522 VSS.n34 VSS.n1000 33.8338
R2523 VSS.n1027 VSS.n999 33.8338
R2524 VSS.n1037 VSS.n999 33.8338
R2525 VSS.n1039 VSS.n997 33.8338
R2526 VSS.n463 VSS.n85 33.8338
R2527 VSS.n1072 VSS.n456 33.8338
R2528 VSS.n1072 VSS.n1071 33.8338
R2529 VSS.n30 VSS.n453 33.8338
R2530 VSS.n30 VSS.n452 33.8338
R2531 VSS.n290 VSS.n262 33.8338
R2532 VSS.n263 VSS.n262 33.8338
R2533 VSS.n294 VSS.n293 33.8338
R2534 VSS.n294 VSS.n259 33.8338
R2535 VSS.n399 VSS.n386 33.8338
R2536 VSS.n400 VSS.n399 33.8338
R2537 VSS.n22 VSS.n414 33.8338
R2538 VSS.n23 VSS.n406 33.8338
R2539 VSS.n23 VSS.n405 33.8338
R2540 VSS.n743 VSS.n724 33.6394
R2541 VSS.n723 VSS.n650 33.6394
R2542 VSS.n1223 VSS.n232 32.6185
R2543 VSS.n1300 VSS.n1299 30.7227
R2544 VSS.n1299 VSS.n185 30.7227
R2545 VSS.n1090 VSS.n433 30.7227
R2546 VSS.n1090 VSS.n1088 30.7227
R2547 VSS.n971 VSS.n491 30.7227
R2548 VSS.n971 VSS.n970 30.7227
R2549 VSS.n71 VSS.n930 30.7227
R2550 VSS.n71 VSS.n524 30.7227
R2551 VSS.n606 VSS.n605 29.7584
R2552 VSS.n535 VSS.t118 29.5405
R2553 VSS.t166 VSS.t16 29.0894
R2554 VSS.t204 VSS.n1173 28.7361
R2555 VSS.n1188 VSS.n317 28.7297
R2556 VSS.n1242 VSS.n1241 28.7297
R2557 VSS.n1038 VSS.n1037 28.7297
R2558 VSS.n977 VSS.n456 28.7297
R2559 VSS.n405 VSS.n394 28.7297
R2560 VSS.n267 VSS.n260 28.6005
R2561 VSS.n907 VSS.n562 28.5838
R2562 VSS.n963 VSS.n497 28.5838
R2563 VSS.n955 VSS.n508 28.5838
R2564 VSS.n663 VSS.n662 28.5838
R2565 VSS.n662 VSS.n657 28.5838
R2566 VSS.n256 VSS.n196 28.4866
R2567 VSS.n298 VSS.n257 28.4866
R2568 VSS.n920 VSS.n119 28.4866
R2569 VSS.n1229 VSS.n236 28.4866
R2570 VSS.n1006 VSS.n1005 28.4866
R2571 VSS.n1029 VSS.n1007 28.4866
R2572 VSS.n476 VSS.n450 28.4866
R2573 VSS.n1082 VSS.n449 28.4866
R2574 VSS.n1189 VSS.n1188 28.438
R2575 VSS.n1242 VSS.n222 28.438
R2576 VSS.n1039 VSS.n1038 28.438
R2577 VSS.n977 VSS.n463 28.438
R2578 VSS.n414 VSS.n394 28.438
R2579 VSS.n573 VSS.n567 28.0005
R2580 VSS.n573 VSS.n566 28.0005
R2581 VSS.t156 VSS.n517 27.7319
R2582 VSS.n1333 VSS.n144 27.616
R2583 VSS.n277 VSS.n185 27.2227
R2584 VSS.n61 VSS.n433 27.2227
R2585 VSS.n1089 VSS.n1088 27.2227
R2586 VSS.n970 VSS.n493 27.2227
R2587 VSS.n973 VSS.n491 27.2227
R2588 VSS.n932 VSS.n524 27.2227
R2589 VSS.n930 VSS.n92 27.2227
R2590 VSS.n1300 VSS.n184 27.2227
R2591 VSS.n560 VSS.n561 27.1255
R2592 VSS.n900 VSS.n895 27.1255
R2593 VSS.n547 VSS.n540 27.1255
R2594 VSS.t258 VSS.t148 26.7501
R2595 VSS.n716 VSS.n707 25.8616
R2596 VSS.n668 VSS.n340 25.8616
R2597 VSS.n702 VSS.n699 25.8616
R2598 VSS.n905 VSS.n563 25.7644
R2599 VSS.n961 VSS.n498 25.7644
R2600 VSS.n63 VSS.n509 25.7644
R2601 VSS.n279 VSS.t20 25.7463
R2602 VSS.n874 VSS.n571 25.3205
R2603 VSS.n737 VSS.n726 25.3012
R2604 VSS.n768 VSS.n707 24.5005
R2605 VSS.n716 VSS.n708 24.5005
R2606 VSS.n873 VSS.n575 24.5005
R2607 VSS.n340 VSS.n338 24.5005
R2608 VSS.n672 VSS.n668 24.5005
R2609 VSS.n1335 VSS.n1334 24.2182
R2610 VSS.n653 VSS.n652 23.706
R2611 VSS.n664 VSS.n161 23.3338
R2612 VSS.n627 VSS.n622 23.1394
R2613 VSS.n952 VSS.n508 22.8477
R2614 VSS.n502 VSS.n497 22.8477
R2615 VSS.n891 VSS.n562 22.8477
R2616 VSS.n770 VSS.n701 22.7505
R2617 VSS.n766 VSS.n707 22.7505
R2618 VSS.n984 VSS.n981 22.5762
R2619 VSS.n1205 VSS.n311 22.5691
R2620 VSS.n1256 VSS.n1255 22.5691
R2621 VSS.n1024 VSS.n1018 22.5691
R2622 VSS.n396 VSS.n395 22.5691
R2623 VSS.n702 VSS.n644 21.9727
R2624 VSS.n1134 VSS.n363 21.0005
R2625 VSS.n675 VSS.n148 20.5537
R2626 VSS.n1268 VSS.t120 20.5052
R2627 VSS.n282 VSS.n266 20.5052
R2628 VSS.t164 VSS.t14 20.0217
R2629 VSS.t84 VSS.t146 20.0217
R2630 VSS.n549 VSS.t39 19.8948
R2631 VSS.n738 VSS.n737 19.8928
R2632 VSS.n1311 VSS.t18 19.1072
R2633 VSS.n896 VSS.n888 19.0561
R2634 VSS.n542 VSS.n16 19.0561
R2635 VSS.n948 VSS.n513 19.0561
R2636 VSS.n70 VSS.n556 19.0561
R2637 VSS.n1311 VSS.n170 18.7965
R2638 VSS.n953 VSS.n510 18.0862
R2639 VSS.n960 VSS.n500 18.0862
R2640 VSS.n904 VSS.n889 18.0862
R2641 VSS.n882 VSS.n881 18.0862
R2642 VSS.n1298 VSS.t18 18.0198
R2643 VSS.n1113 VSS.n1112 17.7242
R2644 VSS.n664 VSS.n332 17.6456
R2645 VSS.n950 VSS.n949 17.4833
R2646 VSS.n959 VSS.n501 17.4833
R2647 VSS.n903 VSS.n890 17.4833
R2648 VSS.n885 VSS.n555 17.4833
R2649 VSS.t53 VSS.t162 16.0831
R2650 VSS.n1309 VSS.n1308 15.2971
R2651 VSS.n823 VSS.n591 15.1353
R2652 VSS.n210 VSS.n209 15.0719
R2653 VSS.n965 VSS.t63 15.0719
R2654 VSS.n919 VSS.n529 14.9197
R2655 VSS.n992 VSS.n443 14.9197
R2656 VSS.n490 VSS.n470 14.9197
R2657 VSS.n824 VSS.n624 14.7783
R2658 VSS.n788 VSS.n781 14.7783
R2659 VSS.n281 VSS.n270 14.6024
R2660 VSS.n1202 VSS.n317 14.5838
R2661 VSS.n1241 VSS.n220 14.5838
R2662 VSS.n1037 VSS.n1036 14.5838
R2663 VSS.n1078 VSS.n456 14.5838
R2664 VSS.n405 VSS.n404 14.5838
R2665 VSS.n1091 VSS.n442 14.3894
R2666 VSS.t132 VSS.n1092 14.3617
R2667 VSS.t186 VSS.n460 14.3617
R2668 VSS.n243 VSS.n205 13.478
R2669 VSS.n802 VSS.n635 13.003
R2670 VSS.n949 VSS.t242 12.6605
R2671 VSS.n1205 VSS.n312 12.1533
R2672 VSS.n1255 VSS.n218 12.1533
R2673 VSS.n1025 VSS.n1024 12.1533
R2674 VSS.n984 VSS.n983 12.1533
R2675 VSS.n396 VSS.n385 12.1533
R2676 VSS.n1098 VSS.n430 12.1514
R2677 VSS.n437 VSS.n430 12.1514
R2678 VSS.n266 VSS.t19 11.9616
R2679 VSS.n354 VSS.n353 11.8335
R2680 VSS.n1150 VSS.n80 11.8335
R2681 VSS.n1148 VSS.n353 11.7885
R2682 VSS.n1150 VSS.n1149 11.7885
R2683 VSS.n291 VSS.n290 11.0838
R2684 VSS.n1305 VSS.n179 10.8894
R2685 VSS.n929 VSS.n121 10.8894
R2686 VSS.n53 VSS.n489 10.8894
R2687 VSS.n370 VSS.n369 10.5999
R2688 VSS.n1122 VSS.n380 10.4305
R2689 VSS.n282 VSS.n281 10.4082
R2690 VSS.n753 VSS.n701 10.3449
R2691 VSS.n907 VSS.n563 9.13939
R2692 VSS.n963 VSS.n498 9.13939
R2693 VSS.n955 VSS.n509 9.13939
R2694 VSS.n938 VSS.n513 9.13939
R2695 VSS.n546 VSS.n542 9.13939
R2696 VSS.n898 VSS.n896 9.13939
R2697 VSS.n910 VSS.n556 9.13939
R2698 VSS.n1169 VSS.n333 8.79754
R2699 VSS.n815 VSS.t166 8.78206
R2700 VSS.n884 VSS.n556 8.55606
R2701 VSS.n896 VSS.n892 8.55606
R2702 VSS.n542 VSS.n503 8.55606
R2703 VSS.n513 VSS.n511 8.55606
R2704 VSS.t26 VSS.n495 8.44049
R2705 VSS.t5 VSS.n880 8.44049
R2706 VSS.n1279 VSS.n1278 8.26599
R2707 VSS.n1297 VSS.t95 7.76744
R2708 VSS.n1272 VSS.n1271 7.76744
R2709 VSS.t164 VSS.t96 7.22126
R2710 VSS.t146 VSS.t216 7.22126
R2711 VSS.n712 VSS.n711 7.13286
R2712 VSS.n675 VSS.n146 7.08484
R2713 VSS.t8 VSS.n438 6.99948
R2714 VSS.n332 VSS.n153 6.81994
R2715 VSS.n206 VSS.n187 6.80606
R2716 VSS.n914 VSS.n554 6.80606
R2717 VSS.n520 VSS.n165 6.70883
R2718 VSS.t58 VSS.t95 6.68007
R2719 VSS.n680 VSS.n146 6.57881
R2720 VSS.n1148 VSS.n1147 6.52797
R2721 VSS.n195 VSS.n191 6.51439
R2722 VSS.n1293 VSS.n190 6.51439
R2723 VSS.n1099 VSS.n429 6.51439
R2724 VSS.n1097 VSS.n89 6.51439
R2725 VSS.n531 VSS.n530 6.51439
R2726 VSS.n944 VSS.n942 6.51439
R2727 VSS.n580 VSS.n578 6.51439
R2728 VSS.n871 VSS.n551 6.51439
R2729 VSS.t248 VSS.n1322 6.50804
R2730 VSS.n1092 VSS.n441 6.2445
R2731 VSS.n972 VSS.n460 6.2445
R2732 VSS.n802 VSS.n93 6.22929
R2733 VSS.n1280 VSS.n1279 6.2105
R2734 VSS.n1281 VSS.n1280 6.2105
R2735 VSS.n95 VSS.n635 6.13361
R2736 VSS.n1147 VSS.n355 5.95929
R2737 VSS.n666 VSS.n153 5.4649
R2738 VSS.n1126 VSS.n97 5.45693
R2739 VSS.n1282 VSS.n1281 5.38925
R2740 VSS.n1281 VSS.n187 5.36289
R2741 VSS.t42 VSS.n914 5.36289
R2742 VSS.n79 VSS.n165 5.36093
R2743 VSS.n1107 VSS.n429 5.35702
R2744 VSS.n1277 VSS.n190 5.35702
R2745 VSS.n1279 VSS.n195 5.35702
R2746 VSS.n944 VSS.n79 5.35702
R2747 VSS.n583 VSS.n580 5.35702
R2748 VSS.t42 VSS.n530 5.35702
R2749 VSS.t42 VSS.n551 5.35702
R2750 VSS.n89 VSS.n5 5.35702
R2751 VSS.n683 VSS.t21 5.29277
R2752 VSS.n84 VSS.n97 5.21753
R2753 VSS.n1155 VSS.n1153 5.21105
R2754 VSS.n914 VSS.n913 5.2005
R2755 VSS.n912 VSS.n551 5.2005
R2756 VSS.n866 VSS.n580 5.2005
R2757 VSS.n946 VSS.n165 5.2005
R2758 VSS.n945 VSS.n944 5.2005
R2759 VSS.n544 VSS.n530 5.2005
R2760 VSS.n1286 VSS.n195 5.2005
R2761 VSS.n1285 VSS.n187 5.2005
R2762 VSS.n1292 VSS.n1291 5.11161
R2763 VSS.n1291 VSS.n189 5.11161
R2764 VSS.t268 VSS.n1213 5.09387
R2765 VSS.n438 VSS.n110 5.05637
R2766 VSS.n1250 VSS.n204 5.01115
R2767 VSS.n91 VSS.n89 4.98824
R2768 VSS.n6 VSS.t8 0.172245
R2769 VSS.t211 VSS.n778 4.6657
R2770 VSS.n754 VSS.t152 4.6657
R2771 VSS.n760 VSS.t2 4.6657
R2772 VSS.n1109 VSS.n429 4.63554
R2773 VSS.n193 VSS.n190 4.63554
R2774 VSS.n82 VSS.t267 4.86282
R2775 VSS.n17 VSS.n1128 4.7384
R2776 VSS.t176 VSS.n777 4.52849
R2777 VSS.n758 VSS.t128 4.52849
R2778 VSS.n761 VSS.t130 4.52849
R2779 VSS.t60 VSS.n173 4.5142
R2780 VSS.n1259 VSS.t78 4.5142
R2781 VSS.n274 VSS.n113 4.50592
R2782 VSS.t42 VSS.n552 4.47115
R2783 VSS.n589 VSS.n553 4.37149
R2784 VSS.n345 VSS.t144 4.3241
R2785 VSS.t215 VSS.n144 4.2633
R2786 VSS.n1325 VSS.t215 4.2633
R2787 VSS.n243 VSS.n232 4.163
R2788 VSS.n1280 VSS.n1274 4.13854
R2789 VSS.n1296 VSS.n182 4.05496
R2790 VSS.n1174 VSS.n1172 3.99333
R2791 VSS.n374 VSS.n364 3.9891
R2792 VSS.n1259 VSS.n215 3.93574
R2793 VSS.n637 VSS.n355 3.83984
R2794 VSS.t48 VSS.n331 3.7807
R2795 VSS.n1271 VSS.n1268 3.72863
R2796 VSS.n1093 VSS.t8 3.71007
R2797 VSS.n785 VSS.n783 3.7099
R2798 VSS.n734 VSS.n711 3.70362
R2799 VSS.n1105 VSS.n109 3.64321
R2800 VSS.n536 VSS.n535 3.61764
R2801 VSS.n523 VSS.n521 3.60498
R2802 VSS.n538 VSS.n537 3.58374
R2803 VSS.n270 VSS.t120 3.57329
R2804 VSS.n869 VSS.n575 3.52605
R2805 VSS.n870 VSS.n869 3.52605
R2806 VSS.n275 VSS.n174 3.3645
R2807 VSS.n543 VSS.n428 3.2505
R2808 VSS.t59 VSS.n279 3.17398
R2809 VSS.n376 VSS.n13 3.0983
R2810 VSS.n950 VSS.t118 3.01478
R2811 VSS.t210 VSS.n953 3.01478
R2812 VSS.t208 VSS.n959 3.01478
R2813 VSS.n500 VSS.t28 3.01478
R2814 VSS.t82 VSS.n903 3.01478
R2815 VSS.n889 VSS.t117 3.01478
R2816 VSS.n885 VSS.t26 3.01478
R2817 VSS.n882 VSS.t81 3.01478
R2818 VSS.t46 VSS.t71 2.9774
R2819 VSS.t19 VSS.t3 2.95194
R2820 VSS.t42 VSS.n943 2.88831
R2821 VSS.n613 VSS.n601 2.84528
R2822 VSS.t220 VSS.n847 2.84528
R2823 VSS.n1124 VSS.n65 2.83698
R2824 VSS.n1340 VSS 2.80436
R2825 VSS.n278 VSS.n186 2.78854
R2826 VSS.n817 VSS.t17 2.7273
R2827 VSS.n798 VSS.n633 2.65567
R2828 VSS.n1119 VSS.n35 2.65348
R2829 VSS.n65 VSS.n1119 2.6429
R2830 VSS.n438 VSS.n436 2.6255
R2831 VSS.n1205 VSS.n1204 2.6005
R2832 VSS.n1206 VSS.n1205 2.6005
R2833 VSS.n984 VSS.n455 2.6005
R2834 VSS.n33 VSS.n984 2.6005
R2835 VSS.n270 VSS.n269 2.6005
R2836 VSS.n269 VSS.n172 2.6005
R2837 VSS.n1255 VSS.n1254 2.6005
R2838 VSS.n1255 VSS.n216 2.6005
R2839 VSS.n1024 VSS.n1002 2.6005
R2840 VSS.n1024 VSS.n39 2.6005
R2841 VSS.n401 VSS.n396 2.6005
R2842 VSS.n117 VSS.n396 2.6005
R2843 VSS.n589 VSS.n588 2.58849
R2844 VSS.n1149 VSS.n26 2.53645
R2845 VSS.t253 VSS.n629 2.51758
R2846 VSS.t167 VSS.n817 2.51215
R2847 VSS.t110 VSS.t48 2.50488
R2848 VSS.n534 VSS.t42 2.50043
R2849 VSS.n15 VSS.n518 2.49651
R2850 VSS.n582 VSS.n579 2.49651
R2851 VSS.n1290 VSS.t243 2.49456
R2852 VSS.t185 VSS.n90 2.49456
R2853 VSS.n522 VSS.n79 2.49115
R2854 VSS.n1125 VSS.n1124 2.38301
R2855 VSS.n1250 VSS.n1249 2.32485
R2856 VSS.n1249 VSS.n1248 2.32485
R2857 VSS.n244 VSS.n235 2.29134
R2858 VSS.n1216 VSS.n253 2.29134
R2859 VSS.n1193 VSS.n325 2.27985
R2860 VSS.n78 VSS.n166 2.27985
R2861 VSS.n1066 VSS.n12 2.27985
R2862 VSS.n425 VSS.n393 2.27985
R2863 VSS.n1314 VSS.n173 2.23079
R2864 VSS.t11 VSS.t108 2.15049
R2865 VSS.n287 VSS.n166 2.1468
R2866 VSS.n376 VSS.n1127 2.12135
R2867 VSS.n6 VSS.n1040 1.64995
R2868 VSS.n303 VSS.n300 2.1005
R2869 VSS.n1182 VSS.n1181 2.1005
R2870 VSS.n1182 VSS.n302 2.1005
R2871 VSS.n1199 VSS.n320 2.1005
R2872 VSS.n321 VSS.n319 2.1005
R2873 VSS.n1178 VSS.n319 2.1005
R2874 VSS.n65 VSS.n384 2.1005
R2875 VSS.n994 VSS.n0 2.1005
R2876 VSS.n33 VSS.n451 2.1005
R2877 VSS.n1073 VSS.n457 2.1005
R2878 VSS.n1064 VSS.n52 2.1005
R2879 VSS.n468 VSS.n47 2.1005
R2880 VSS.n250 VSS.t62 2.1005
R2881 VSS.n288 VSS.n284 2.1005
R2882 VSS.t178 VSS.n60 1.05376
R2883 VSS.n1237 VSS.n1236 2.1005
R2884 VSS.n1236 VSS.n233 2.1005
R2885 VSS.n1239 VSS.n1238 2.1005
R2886 VSS.n1239 VSS.n226 2.1005
R2887 VSS.n237 VSS.n203 2.1005
R2888 VSS.n1011 VSS.n1010 2.1005
R2889 VSS.n39 VSS.n1013 2.1005
R2890 VSS.n1014 VSS.n481 2.1005
R2891 VSS.n979 VSS.n482 2.1005
R2892 VSS.n255 VSS.n247 2.1005
R2893 VSS.n1221 VSS.n247 2.1005
R2894 VSS.n408 VSS.n397 2.1005
R2895 VSS.n417 VSS.n25 2.1005
R2896 VSS.n54 VSS.t134 0.00176191
R2897 VSS.n407 VSS.n397 2.1005
R2898 VSS.n1326 VSS.n156 2.05758
R2899 VSS.n1272 VSS.t58 2.01991
R2900 VSS.n924 VSS.t62 1.97647
R2901 VSS.n181 VSS.t1 1.97545
R2902 VSS.t44 VSS.t11 1.96148
R2903 VSS VSS.n1340 1.95625
R2904 VSS.n1313 VSS.n174 1.9525
R2905 VSS.n1248 VSS.n215 1.9492
R2906 VSS.n464 VSS.n12 1.94851
R2907 VSS.n157 VSS.n156 1.94542
R2908 VSS.n1214 VSS.n35 1.94247
R2909 VSS.n1193 VSS.n1192 1.93906
R2910 VSS.n425 VSS.n424 1.93906
R2911 VSS.n613 VSS.n612 1.91007
R2912 VSS.n1051 VSS.n484 1.91007
R2913 VSS.t60 VSS.t59 1.91007
R2914 VSS.t76 VSS.t78 1.91007
R2915 VSS.n1261 VSS.n118 1.91007
R2916 VSS.n1063 VSS.n469 1.91007
R2917 VSS.n847 VSS.n837 1.91007
R2918 VSS.n696 VSS.n695 1.86697
R2919 VSS.n1106 VSS.n431 1.8592
R2920 VSS.n1276 VSS.n1275 1.8592
R2921 VSS.n581 VSS.n590 1.8592
R2922 VSS.t22 VSS.n341 1.85413
R2923 VSS.n1229 VSS.n1228 1.81114
R2924 VSS.n544 VSS.n543 1.80907
R2925 VSS.n913 VSS.n912 1.80907
R2926 VSS.t177 VSS.n773 1.7649
R2927 VSS.n849 VSS.n379 1.75716
R2928 VSS.n7 VSS.t8 0.0948909
R2929 VSS.n585 VSS.t105 1.75819
R2930 VSS.n1260 VSS.n214 1.72777
R2931 VSS.n326 VSS.n124 1.65572
R2932 VSS.n127 VSS.n465 1.65572
R2933 VSS.n100 VSS.n167 1.65572
R2934 VSS.n1249 VSS.n1247 1.65572
R2935 VSS.n1021 VSS.n996 1.65572
R2936 VSS.n131 VSS.n129 1.65572
R2937 VSS.t21 VSS.t44 1.65434
R2938 VSS.n996 VSS.n995 1.64934
R2939 VSS.n1322 VSS.n13 1.61082
R2940 VSS.n693 VSS.n349 1.61039
R2941 VSS.n985 VSS.n483 1.59806
R2942 VSS.n38 VSS.n480 1.59762
R2943 VSS.n747 VSS.n746 1.59522
R2944 VSS.n748 VSS.n747 1.59522
R2945 VSS.n749 VSS.n748 1.59522
R2946 VSS.n749 VSS.n713 1.59522
R2947 VSS.n728 VSS.n722 1.59522
R2948 VSS.n728 VSS.n721 1.59522
R2949 VSS.n732 VSS.n721 1.59522
R2950 VSS.n733 VSS.n732 1.59522
R2951 VSS.n734 VSS.n733 1.59522
R2952 VSS.n9 VSS.n1090 0.361374
R2953 VSS.t149 VSS.t217 1.55444
R2954 VSS.t163 VSS.t97 1.55444
R2955 VSS.n629 VSS.t250 1.55294
R2956 VSS.t198 VSS.n87 1.55294
R2957 VSS.t97 VSS.n608 1.53868
R2958 VSS.n848 VSS.t217 1.53868
R2959 VSS.t62 VSS.n118 1.52463
R2960 VSS.t105 VSS.n1063 1.60358
R2961 VSS.n484 VSS.t8 1.52267
R2962 VSS.n98 VSS.n87 1.52003
R2963 VSS.n1127 VSS.n1126 1.48653
R2964 VSS.n693 VSS.n692 1.47253
R2965 VSS.n310 VSS.n309 1.46668
R2966 VSS.n419 VSS.n65 1.47465
R2967 VSS.n1108 VSS.t185 1.46531
R2968 VSS.t243 VSS.n194 1.46531
R2969 VSS.n15 VSS.n550 1.46531
R2970 VSS.n868 VSS.n582 1.46531
R2971 VSS.n432 VSS.n5 1.45629
R2972 VSS.n96 VSS.n243 1.44446
R2973 VSS.n276 VSS.t20 1.43723
R2974 VSS.t113 VSS.t114 1.43668
R2975 VSS.n138 VSS.n1338 1.42876
R2976 VSS.t49 VSS.t204 1.41807
R2977 VSS.n1136 VSS.n367 1.39496
R2978 VSS.t248 VSS.n164 1.38303
R2979 VSS.n274 VSS.n243 1.37869
R2980 VSS.n1214 VSS.t268 1.36985
R2981 VSS.n274 VSS.n196 1.35198
R2982 VSS.n1008 VSS.n1 1.31344
R2983 VSS.n50 VSS.n126 1.31212
R2984 VSS.n759 VSS.n708 1.3005
R2985 VSS.n708 VSS.t10 1.3005
R2986 VSS.n768 VSS.t9 1.3005
R2987 VSS.n76 VSS.n768 1.3005
R2988 VSS.n1165 VSS.n338 1.3005
R2989 VSS.t70 VSS.n338 1.3005
R2990 VSS.n673 VSS.n672 1.3005
R2991 VSS.n672 VSS.n671 1.3005
R2992 VSS.n880 VSS.n879 1.3005
R2993 VSS.n879 VSS.n878 1.3005
R2994 VSS.n574 VSS.n573 1.3005
R2995 VSS.n573 VSS.t207 1.3005
R2996 VSS.n875 VSS.n874 1.3005
R2997 VSS.t116 VSS.n875 1.3005
R2998 VSS.n939 VSS.n938 1.3005
R2999 VSS.n938 VSS.t42 1.3005
R3000 VSS.n546 VSS.n545 1.3005
R3001 VSS.t40 VSS.n546 1.3005
R3002 VSS.n898 VSS.n897 1.3005
R3003 VSS.n898 VSS.t42 1.3005
R3004 VSS.n911 VSS.n910 1.3005
R3005 VSS.n910 VSS.t42 1.3005
R3006 VSS.n278 VSS.n277 1.29841
R3007 VSS.n1093 VSS.n431 1.28007
R3008 VSS.n78 VSS.n1321 1.26439
R3009 VSS.n1323 VSS.t248 1.26149
R3010 VSS.n1323 VSS.t192 1.26149
R3011 VSS.n345 VSS.t109 1.25269
R3012 VSS.n58 VSS.n158 1.24523
R3013 VSS.n1139 VSS.n59 0.75461
R3014 VSS.t13 VSS.n69 1.22528
R3015 VSS.t167 VSS.n784 1.22528
R3016 VSS.t62 VSS.n100 1.21354
R3017 VSS.n946 VSS.n945 1.20621
R3018 VSS.t234 VSS.t242 1.20621
R3019 VSS.t13 VSS.n858 0.927619
R3020 VSS.t42 VSS.n48 0.138156
R3021 VSS.n137 VSS.t101 1.18502
R3022 VSS.t105 VSS.t170 0.384738
R3023 VSS.n853 VSS.t107 1.17273
R3024 VSS.n1246 VSS.n204 1.17129
R3025 VSS.n1020 VSS.t8 1.1692
R3026 VSS.n1187 VSS.n1186 1.16717
R3027 VSS.n201 VSS.n200 1.16717
R3028 VSS.n997 VSS.n439 1.16717
R3029 VSS.n1070 VSS.n85 1.16717
R3030 VSS.n289 VSS.n264 1.16717
R3031 VSS.n22 VSS.n391 1.16717
R3032 VSS.n25 VSS.n425 1.16276
R3033 VSS.n1331 VSS.t262 1.15906
R3034 VSS.n687 VSS.t47 1.15906
R3035 VSS.n186 VSS.n183 1.15485
R3036 VSS.n1261 VSS.n1260 1.14577
R3037 VSS.n608 VSS.t15 1.12959
R3038 VSS.t85 VSS.n848 1.12959
R3039 VSS.n1156 VSS.n1155 1.1255
R3040 VSS.n1174 VSS.t49 1.11093
R3041 VSS.n826 VSS.n83 1.10593
R3042 VSS.n789 VSS.n67 1.10593
R3043 VSS.n112 VSS.n298 1.10231
R3044 VSS.n943 VSS.n514 1.08737
R3045 VSS.n230 VSS.t227 1.07971
R3046 VSS.n245 VSS.t222 1.07971
R3047 VSS.n304 VSS.t171 1.07971
R3048 VSS.n1198 VSS.t174 1.07971
R3049 VSS.t98 VSS.n1176 1.07971
R3050 VSS.n458 VSS.t29 1.07971
R3051 VSS.n8 VSS.t259 1.05376
R3052 VSS.t79 VSS.n1016 1.07971
R3053 VSS.n62 VSS.t24 0.0103017
R3054 VSS.t150 VSS.n466 1.07971
R3055 VSS.n416 VSS.t93 1.07971
R3056 VSS.n409 VSS.t196 1.07971
R3057 VSS.t73 VSS.n252 1.07971
R3058 VSS.n249 VSS.t36 1.07971
R3059 VSS.n238 VSS.t256 1.07971
R3060 VSS.n383 VSS.t15 1.07852
R3061 VSS.n849 VSS.t85 1.07852
R3062 VSS.n115 VSS.n826 1.06949
R3063 VSS.n19 VSS.n67 1.06949
R3064 VSS.n1314 VSS.n1313 1.0665
R3065 VSS.n1192 VSS.n326 1.05911
R3066 VSS.n335 VSS.n326 1.05911
R3067 VSS.n335 VSS.n310 1.05911
R3068 VSS.n986 VSS.n985 1.05911
R3069 VSS.n986 VSS.n465 1.05911
R3070 VSS.n465 VSS.n464 1.05911
R3071 VSS.n1316 VSS.n1315 1.05911
R3072 VSS.n1316 VSS.n167 1.05911
R3073 VSS.n1321 VSS.n167 1.05911
R3074 VSS.n1247 VSS.n1246 1.05911
R3075 VSS.n1247 VSS.n223 1.05911
R3076 VSS.n223 VSS.n214 1.05911
R3077 VSS.n1021 VSS.n1020 1.05911
R3078 VSS.n1023 VSS.n1021 1.05911
R3079 VSS.n38 VSS.n1023 1.05911
R3080 VSS.n424 VSS.n129 1.05911
R3081 VSS.n420 VSS.n129 1.05911
R3082 VSS.n420 VSS.n419 1.05911
R3083 VSS.n1339 VSS.t102 1.0476
R3084 VSS.n773 VSS.n700 1.0449
R3085 VSS.n777 VSS.n776 1.0405
R3086 VSS.n776 VSS.n775 1.0405
R3087 VSS.n778 VSS.n73 1.0405
R3088 VSS.n74 VSS.n73 1.0405
R3089 VSS.n644 VSS.n643 1.0405
R3090 VSS.n645 VSS.n644 1.0405
R3091 VSS.n795 VSS.n794 1.0405
R3092 VSS.n794 VSS.n793 1.0405
R3093 VSS.n758 VSS.n757 1.0405
R3094 VSS.n757 VSS.t129 1.0405
R3095 VSS.n755 VSS.n754 1.0405
R3096 VSS.n75 VSS.n755 1.0405
R3097 VSS.n704 VSS.n703 1.0405
R3098 VSS.n705 VSS.n704 1.0405
R3099 VSS.n771 VSS.n770 1.0405
R3100 VSS.n770 VSS.n769 1.0405
R3101 VSS.n762 VSS.n761 1.0405
R3102 VSS.n763 VSS.n762 1.0405
R3103 VSS.n760 VSS.n717 1.0405
R3104 VSS.n717 VSS.n715 1.0405
R3105 VSS.n710 VSS.n709 1.0405
R3106 VSS.n764 VSS.n710 1.0405
R3107 VSS.n767 VSS.n766 1.0405
R3108 VSS.n766 VSS.n765 1.0405
R3109 VSS.n745 VSS.n650 1.0405
R3110 VSS.n744 VSS.n743 1.0405
R3111 VSS.n1162 VSS.n1161 1.0405
R3112 VSS.n1159 VSS.n343 1.0405
R3113 VSS.n348 VSS.n347 1.0405
R3114 VSS.n1158 VSS.n1157 1.0405
R3115 VSS.n63 VSS.n510 1.0405
R3116 VSS.n949 VSS.n948 1.0405
R3117 VSS.n951 VSS.n950 1.0405
R3118 VSS.n951 VSS.n512 1.0405
R3119 VSS.n953 VSS.n952 1.0405
R3120 VSS.n952 VSS.n507 1.0405
R3121 VSS.n961 VSS.n960 1.0405
R3122 VSS.n501 VSS.n16 1.0405
R3123 VSS.n959 VSS.n958 1.0405
R3124 VSS.n958 VSS.n957 1.0405
R3125 VSS.n502 VSS.n500 1.0405
R3126 VSS.n504 VSS.n502 1.0405
R3127 VSS.n905 VSS.n904 1.0405
R3128 VSS.t42 VSS.n905 1.00072
R3129 VSS.n890 VSS.n888 1.0405
R3130 VSS.n903 VSS.n902 1.0405
R3131 VSS.n902 VSS.n901 1.0405
R3132 VSS.n891 VSS.n889 1.0405
R3133 VSS.n893 VSS.n891 1.0405
R3134 VSS.n881 VSS.n10 1.0405
R3135 VSS.t42 VSS.n10 1.00034
R3136 VSS.n70 VSS.n555 1.0405
R3137 VSS.n886 VSS.n885 1.0405
R3138 VSS.n558 VSS.n886 1.0405
R3139 VSS.n883 VSS.n882 1.0405
R3140 VSS.n883 VSS.n564 1.0405
R3141 VSS.n1089 VSS.n441 1.0405
R3142 VSS.n1089 VSS.t8 1.00556
R3143 VSS.n61 VSS.n435 1.0405
R3144 VSS.t8 VSS.n61 1.00496
R3145 VSS.n9 VSS.t237 0.44894
R3146 VSS.n1083 VSS.n1082 1.0405
R3147 VSS.n1082 VSS.n33 1.0405
R3148 VSS.n474 VSS.n450 1.0405
R3149 VSS.n31 VSS.n450 1.0405
R3150 VSS.n973 VSS.n972 1.0405
R3151 VSS.t105 VSS.n973 1.0405
R3152 VSS.n277 VSS.t120 1.0405
R3153 VSS.n1299 VSS.n1298 1.0405
R3154 VSS.n1299 VSS.n186 1.0405
R3155 VSS.n276 VSS.n266 1.0405
R3156 VSS.t120 VSS.n184 1.0405
R3157 VSS.n273 VSS.n184 1.0405
R3158 VSS.n926 VSS.n92 1.0405
R3159 VSS.t62 VSS.n92 1.0405
R3160 VSS.t62 VSS.n119 1.0405
R3161 VSS.t66 VSS.n525 1.0405
R3162 VSS.n525 VSS.n42 1.0405
R3163 VSS.n932 VSS.n931 1.0405
R3164 VSS.n933 VSS.n932 1.0405
R3165 VSS.t66 VSS.n71 1.0405
R3166 VSS.t136 VSS.n492 1.0405
R3167 VSS.n49 VSS.n492 1.0405
R3168 VSS.n967 VSS.n493 1.0405
R3169 VSS.n917 VSS.n493 1.0405
R3170 VSS.t136 VSS.n971 1.0405
R3171 VSS.n971 VSS.n51 1.0405
R3172 VSS.n1030 VSS.n1029 1.0405
R3173 VSS.n1029 VSS.n39 1.0405
R3174 VSS.n1005 VSS.n1004 1.0405
R3175 VSS.n36 VSS.n1005 1.0405
R3176 VSS.n15 VSS.n14 0.364906
R3177 VSS.t119 VSS.t42 0.0874264
R3178 VSS.n570 VSS.n568 1.03043
R3179 VSS.t187 VSS.t188 1.02629
R3180 VSS.t165 VSS.t163 1.02629
R3181 VSS.t32 VSS.t34 1.02629
R3182 VSS.t181 VSS.t183 1.02629
R3183 VSS.t147 VSS.t149 1.02629
R3184 VSS.t194 VSS.t193 1.02629
R3185 VSS.n583 VSS.t195 1.0156
R3186 VSS.n355 VSS.n354 1.01325
R3187 VSS.n347 VSS.n346 1.00079
R3188 VSS.n1158 VSS.n346 1.00079
R3189 VSS.n1161 VSS.n1160 1.00072
R3190 VSS.n1160 VSS.n1159 1.00072
R3191 VSS.n164 VSS.n163 0.999175
R3192 VSS.n1206 VSS.n310 0.9905
R3193 VSS.n985 VSS.n33 0.9905
R3194 VSS.n1315 VSS.n172 0.9905
R3195 VSS.n216 VSS.n214 0.9905
R3196 VSS.n39 VSS.n38 0.9905
R3197 VSS.n419 VSS.n117 0.9905
R3198 VSS.n95 VSS.n93 0.9905
R3199 VSS.n354 VSS.n80 0.9905
R3200 VSS.t56 VSS.n80 0.9905
R3201 VSS.n733 VSS.n713 0.9905
R3202 VSS.n748 VSS.n721 0.9905
R3203 VSS.n746 VSS.n722 0.9905
R3204 VSS.n691 VSS.t45 0.963719
R3205 VSS.n157 VSS.t261 0.963719
R3206 VSS.n669 VSS.n341 0.954896
R3207 VSS.t46 VSS.t109 0.945549
R3208 VSS.n66 VSS.n383 1.04615
R3209 VSS.t248 VSS.n58 0.92086
R3210 VSS.n612 VSS.n602 0.910283
R3211 VSS.n1052 VSS.n1051 0.910283
R3212 VSS.n1057 VSS.n469 0.910283
R3213 VSS.n841 VSS.n837 0.910283
R3214 VSS.n242 VSS.n241 0.906844
R3215 VSS.n1138 VSS.n1137 0.883687
R3216 VSS.n1169 VSS.n1168 0.878216
R3217 VSS.n1224 VSS.n1223 0.87556
R3218 VSS.n113 VSS.n111 0.87556
R3219 VSS.n685 VSS.n155 0.870203
R3220 VSS.n678 VSS.n147 0.870203
R3221 VSS.n1175 VSS.n1174 0.867167
R3222 VSS.n1175 VSS.n300 0.867167
R3223 VSS.n1187 VSS.n329 0.867167
R3224 VSS.n1187 VSS.n320 0.867167
R3225 VSS.n1183 VSS.n143 0.867167
R3226 VSS.n1183 VSS.n1182 0.867167
R3227 VSS.n330 VSS.n142 0.867167
R3228 VSS.n330 VSS.n319 0.867167
R3229 VSS.n64 VSS.n1113 0.867167
R3230 VSS.n65 VSS.n64 0.867167
R3231 VSS.n22 VSS.n387 0.867167
R3232 VSS.n25 VSS.n22 0.867167
R3233 VSS.n997 VSS.n445 0.867167
R3234 VSS.n997 VSS.t8 0.867167
R3235 VSS.n30 VSS.n1081 0.867167
R3236 VSS.n33 VSS.n30 0.867167
R3237 VSS.n1072 VSS.n454 0.867167
R3238 VSS.n1073 VSS.n1072 0.867167
R3239 VSS.n462 VSS.n85 0.867167
R3240 VSS.n47 VSS.n85 0.867167
R3241 VSS.n262 VSS.t62 0.867167
R3242 VSS.n292 VSS.n253 0.867167
R3243 VSS.n295 VSS.n294 0.867167
R3244 VSS.n294 VSS.n247 0.867167
R3245 VSS.n289 VSS.n288 0.867167
R3246 VSS.n203 VSS.n200 0.867167
R3247 VSS.n1233 VSS.n235 0.867167
R3248 VSS.n1235 VSS.n219 0.867167
R3249 VSS.n1236 VSS.n1235 0.867167
R3250 VSS.n1240 VSS.n221 0.867167
R3251 VSS.n1240 VSS.n1239 0.867167
R3252 VSS.n1026 VSS.n447 0.867167
R3253 VSS.n1026 VSS.n481 0.867167
R3254 VSS.n982 VSS.n488 0.867167
R3255 VSS.n982 VSS.n482 0.867167
R3256 VSS.n1033 VSS.n999 0.867167
R3257 VSS.n1010 VSS.n999 0.867167
R3258 VSS.n34 VSS.n1003 0.867167
R3259 VSS.n39 VSS.n34 0.867167
R3260 VSS.n399 VSS.n390 0.867167
R3261 VSS.n399 VSS.n397 0.867167
R3262 VSS.n23 VSS.n389 0.867167
R3263 VSS.n25 VSS.n23 0.867167
R3264 VSS.n1194 VSS.n1193 0.865091
R3265 VSS.n745 VSS.n744 0.863336
R3266 VSS.n1275 VSS.n1274 0.851587
R3267 VSS.n251 VSS.n173 0.848345
R3268 VSS.t229 VSS.t230 0.842184
R3269 VSS.n861 VSS.n860 0.837071
R3270 VSS.n818 VSS.n634 0.837071
R3271 VSS.n99 VSS.n516 0.808192
R3272 VSS.n588 VSS.n586 0.787682
R3273 VSS.n1304 VSS.n1303 0.784334
R3274 VSS.n325 VSS.n324 0.782971
R3275 VSS.n1066 VSS.n1065 0.782971
R3276 VSS.n128 VSS.n393 0.782971
R3277 VSS.t108 VSS.n337 0.780165
R3278 VSS.n120 VSS.n122 0.778287
R3279 VSS.t230 VSS.n806 0.777665
R3280 VSS.n916 VSS.n51 0.772032
R3281 VSS.n44 VSS.n71 1.29499
R3282 VSS.n39 VSS.n36 0.770442
R3283 VSS.n33 VSS.n31 0.7701
R3284 VSS.n792 VSS.n791 0.743357
R3285 VSS.n791 VSS.n790 0.743357
R3286 VSS.n868 VSS.n867 0.743357
R3287 VSS.n550 VSS.n549 0.743357
R3288 VSS.n825 VSS.t251 0.743357
R3289 VSS.n86 VSS.n825 0.743357
R3290 VSS.n692 VSS.n691 0.741856
R3291 VSS.n94 VSS.n636 0.739455
R3292 VSS.n695 VSS.n655 0.732913
R3293 VSS.t105 VSS.n48 0.403418
R3294 VSS.n316 VSS.n312 0.729667
R3295 VSS.n234 VSS.n218 0.729667
R3296 VSS.n1025 VSS.n1000 0.729667
R3297 VSS.n983 VSS.n453 0.729667
R3298 VSS.n400 VSS.n385 0.729667
R3299 VSS.n660 VSS.n658 0.727
R3300 VSS.n432 VSS.n1107 0.725703
R3301 VSS.n1283 VSS.n1282 0.723312
R3302 VSS.n127 VSS.n126 0.691544
R3303 VSS.t42 VSS.n14 0.0830738
R3304 VSS.n194 VSS.n193 0.663078
R3305 VSS.n1109 VSS.n1108 0.663078
R3306 VSS.n1120 VSS.n66 0.759155
R3307 VSS.n88 VSS.n379 0.659983
R3308 VSS.n608 VSS.n601 0.655935
R3309 VSS.n848 VSS.t220 0.655935
R3310 VSS.n1153 VSS.n17 0.686686
R3311 VSS.n1278 VSS.n1277 0.646316
R3312 VSS.n1105 VSS.t8 0.645768
R3313 VSS.t72 VSS.n660 0.626954
R3314 VSS.n1111 VSS.n1110 0.6249
R3315 VSS.n966 VSS.n495 0.6249
R3316 VSS.n1298 VSS.n1297 0.621856
R3317 VSS.n367 VSS.n366 0.62021
R3318 VSS.n1137 VSS.n1136 0.62021
R3319 VSS.n793 VSS.n98 0.608489
R3320 VSS.n590 VSS.n589 0.599054
R3321 VSS.n590 VSS.n583 0.599054
R3322 VSS.n1213 VSS.n299 0.596851
R3323 VSS.n1114 VSS 0.596334
R3324 VSS.n1303 VSS.n182 0.596019
R3325 VSS.n637 VSS.t17 0.593966
R3326 VSS.n1086 VSS.n7 0.775727
R3327 VSS.n1304 VSS.n181 0.587532
R3328 VSS.n586 VSS.n585 0.586952
R3329 VSS.n924 VSS.n120 0.586952
R3330 VSS.n122 VSS.t42 0.584073
R3331 VSS.t167 VSS.n21 0.580473
R3332 VSS.n797 VSS.n796 0.578278
R3333 VSS.n797 VSS.n68 0.578278
R3334 VSS.n633 VSS.n632 0.578278
R3335 VSS.n634 VSS.n633 0.578278
R3336 VSS.n819 VSS.n818 0.578278
R3337 VSS.t166 VSS.n21 0.578278
R3338 VSS.t168 VSS.n800 0.578278
R3339 VSS.n800 VSS.t167 0.578278
R3340 VSS.n20 VSS.t246 0.578278
R3341 VSS.t167 VSS.n20 0.578278
R3342 VSS.n683 VSS.n679 0.578278
R3343 VSS.n679 VSS.n678 0.578278
R3344 VSS.n683 VSS.n682 0.578278
R3345 VSS.n682 VSS.n147 0.578278
R3346 VSS.t46 VSS.n151 0.578278
R3347 VSS.n151 VSS.t193 0.578278
R3348 VSS.n1328 VSS.t46 0.578278
R3349 VSS.t194 VSS.n1328 0.578278
R3350 VSS.t46 VSS.n150 0.578278
R3351 VSS.t188 VSS.n150 0.578278
R3352 VSS.t46 VSS.n152 0.578278
R3353 VSS.n152 VSS.t187 0.578278
R3354 VSS.n684 VSS.n683 0.578278
R3355 VSS.n685 VSS.n684 0.578278
R3356 VSS.n683 VSS.n674 0.578278
R3357 VSS.n674 VSS.n155 0.578278
R3358 VSS.n831 VSS.n27 0.578278
R3359 VSS.t13 VSS.n27 0.578278
R3360 VSS.n831 VSS.n830 0.578278
R3361 VSS.n830 VSS.t13 0.578278
R3362 VSS.n863 VSS.n862 0.578278
R3363 VSS.n862 VSS.n861 0.578278
R3364 VSS.n863 VSS.n594 0.578278
R3365 VSS.n860 VSS.n594 0.578278
R3366 VSS.n1130 VSS.n373 0.578278
R3367 VSS.n373 VSS.t229 0.578278
R3368 VSS.n1130 VSS.n1129 0.578278
R3369 VSS.n1129 VSS.t229 0.578278
R3370 VSS.n1141 VSS.n1140 0.578278
R3371 VSS.n1141 VSS.n362 0.578278
R3372 VSS.n1139 VSS.n362 0.578278
R3373 VSS.n609 VSS.t162 0.578278
R3374 VSS.t163 VSS.n609 0.578278
R3375 VSS.t164 VSS.n610 0.578278
R3376 VSS.n610 VSS.t165 0.578278
R3377 VSS.n614 VSS.t162 0.578278
R3378 VSS.n614 VSS.n613 0.578278
R3379 VSS.n611 VSS.t164 0.578278
R3380 VSS.n612 VSS.n611 0.578278
R3381 VSS.n840 VSS.t148 0.578278
R3382 VSS.t149 VSS.n840 0.578278
R3383 VSS.n842 VSS.t146 0.578278
R3384 VSS.n842 VSS.t147 0.578278
R3385 VSS.n846 VSS.t148 0.578278
R3386 VSS.n847 VSS.n846 0.578278
R3387 VSS.n844 VSS.t146 0.578278
R3388 VSS.n844 VSS.n837 0.578278
R3389 VSS.n1051 VSS.n1050 0.578278
R3390 VSS.n991 VSS.n484 0.578278
R3391 VSS.n1312 VSS.n1311 0.578278
R3392 VSS.n1313 VSS.n1312 0.578278
R3393 VSS.n1311 VSS.n1310 0.578278
R3394 VSS.n1310 VSS.n174 0.578278
R3395 VSS.n281 VSS.n280 0.578278
R3396 VSS.n280 VSS.t60 0.578278
R3397 VSS.n281 VSS.n268 0.578278
R3398 VSS.t59 VSS.n268 0.578278
R3399 VSS.n923 VSS.t75 0.578278
R3400 VSS.t76 VSS.n923 0.578278
R3401 VSS.t77 VSS.n211 0.578278
R3402 VSS.t78 VSS.n211 0.578278
R3403 VSS.n918 VSS.t75 0.578278
R3404 VSS.n918 VSS.n118 0.578278
R3405 VSS.t77 VSS.n1262 0.578278
R3406 VSS.n1262 VSS.n1261 0.578278
R3407 VSS.n1061 VSS.n1060 0.578278
R3408 VSS.n1060 VSS.t34 0.578278
R3409 VSS.n1063 VSS.n1062 0.578278
R3410 VSS.n1058 VSS.n472 0.578278
R3411 VSS.n1058 VSS.t32 0.578278
R3412 VSS.n478 VSS.n469 0.578278
R3413 VSS.n1048 VSS.n1047 0.578278
R3414 VSS.n1047 VSS.t183 0.578278
R3415 VSS.n1045 VSS.n1044 0.578278
R3416 VSS.n1045 VSS.t181 0.578278
R3417 VSS.n28 VSS.n829 0.578278
R3418 VSS.t13 VSS.n28 0.578278
R3419 VSS.n828 VSS.n827 0.578278
R3420 VSS.n1209 VSS.n1208 0.573227
R3421 VSS.n1197 VSS.n1196 0.573227
R3422 VSS.n1180 VSS.n1179 0.573227
R3423 VSS.n1211 VSS.n1210 0.573227
R3424 VSS.n124 VSS.n123 0.573227
R3425 VSS.n1177 VSS.n318 0.573227
R3426 VSS.n29 VSS.n101 0.573227
R3427 VSS.n1076 VSS.n1075 0.573227
R3428 VSS.n1074 VSS.n33 0.573227
R3429 VSS.n467 VSS.t105 0.573227
R3430 VSS.n127 VSS.n125 0.573227
R3431 VSS.n254 VSS.n1215 0.573227
R3432 VSS.n45 VSS.n1222 0.573227
R3433 VSS.n1218 VSS.n1217 0.573227
R3434 VSS.n248 VSS.n1220 0.573227
R3435 VSS.n286 VSS.n285 0.573227
R3436 VSS.n242 VSS.n229 0.573227
R3437 VSS.n1228 VSS.n1227 0.573227
R3438 VSS.n240 VSS.n239 0.573227
R3439 VSS.n228 VSS.n227 0.573227
R3440 VSS.n1226 VSS.n1225 0.573227
R3441 VSS.n37 VSS.n1012 0.573227
R3442 VSS.t89 VSS.n40 0.0103017
R3443 VSS.n1015 VSS.n39 0.573227
R3444 VSS.n105 VSS.n103 0.573227
R3445 VSS.n1043 VSS.n1042 0.573227
R3446 VSS.n410 VSS.n108 0.573227
R3447 VSS.n412 VSS.n411 0.573227
R3448 VSS.n415 VSS.n25 0.573227
R3449 VSS.n116 VSS.n418 0.573227
R3450 VSS.n1224 VSS.n235 0.568693
R3451 VSS.n111 VSS.n253 0.568693
R3452 VSS.n1165 VSS.t71 0.567529
R3453 VSS.t231 VSS.t229 0.558926
R3454 VSS.n1149 VSS.n1148 0.546434
R3455 VSS.n1155 VSS.n1154 0.539346
R3456 VSS.t8 VSS.n0 0.53932
R3457 VSS.t105 VSS.n52 0.53932
R3458 VSS.n638 VSS.n636 0.536801
R3459 VSS.n841 VSS.n379 0.534506
R3460 VSS.n793 VSS.n645 0.5325
R3461 VSS.n769 VSS.n705 0.5325
R3462 VSS.n765 VSS.n764 0.5325
R3463 VSS.n1157 VSS.n348 0.5325
R3464 VSS.n512 VSS.n507 0.5325
R3465 VSS.n957 VSS.n504 0.5325
R3466 VSS.n901 VSS.n893 0.5325
R3467 VSS.n558 VSS.n564 0.5325
R3468 VSS.n371 VSS.n366 0.530797
R3469 VSS.n878 VSS.n877 0.5305
R3470 VSS.t231 VSS.n805 0.524248
R3471 VSS.n581 VSS.n552 0.518978
R3472 VSS.n1118 VSS.n1117 0.517767
R3473 VSS.n1121 VSS.n1120 0.517741
R3474 VSS.n1282 VSS.n204 0.515192
R3475 VSS.n568 VSS.n564 0.510588
R3476 VSS.n1283 VSS.n203 0.50901
R3477 VSS.t105 VSS.n51 0.505283
R3478 VSS.n826 VSS.t250 0.503907
R3479 VSS.n67 VSS.t198 0.503907
R3480 VSS.t125 VSS.n180 0.502582
R3481 VSS.t116 VSS.n570 0.501763
R3482 VSS.n1137 VSS.n366 0.50094
R3483 VSS.t269 VSS.n378 0.499656
R3484 VSS.n1008 VSS.n0 0.496952
R3485 VSS.n52 VSS.n126 0.496952
R3486 VSS.n1127 VSS.t220 0.49535
R3487 VSS.n1338 VSS.t101 0.494029
R3488 VSS.n1338 VSS.t113 0.494029
R3489 VSS.t181 VSS.t8 0.491875
R3490 VSS.t47 VSS.t45 0.491732
R3491 VSS.t262 VSS.t261 0.491732
R3492 VSS.n769 VSS.n700 0.48783
R3493 VSS.n774 VSS.t177 0.48525
R3494 VSS.n506 VSS.n505 0.484075
R3495 VSS.n894 VSS.n499 0.484075
R3496 VSS.n887 VSS.n559 0.484075
R3497 VSS.n806 VSS.n93 0.483918
R3498 VSS.n1140 VSS.n59 0.683663
R3499 VSS.t177 VSS.n645 0.47983
R3500 VSS.n860 VSS.t13 0.478347
R3501 VSS.n378 VSS.n136 0.477635
R3502 VSS.t47 VSS.n686 0.476687
R3503 VSS.t262 VSS.n1330 0.476687
R3504 VSS.n59 VSS.t229 0.267165
R3505 VSS.n786 VSS.n785 0.473227
R3506 VSS.n788 VSS.n787 0.473227
R3507 VSS.n789 VSS.n788 0.473227
R3508 VSS.n690 VSS.t71 0.473227
R3509 VSS.t72 VSS.n690 0.473227
R3510 VSS.n662 VSS.t71 0.473227
R3511 VSS.n662 VSS.n658 0.473227
R3512 VSS.n515 VSS.n209 0.473227
R3513 VSS.n943 VSS.n515 0.473227
R3514 VSS.n99 VSS.n947 0.473227
R3515 VSS.t119 VSS.n99 0.473227
R3516 VSS.n955 VSS.n954 0.473227
R3517 VSS.n956 VSS.n955 0.473227
R3518 VSS.n548 VSS.n547 0.473227
R3519 VSS.n547 VSS.t209 0.473227
R3520 VSS.n964 VSS.n963 0.473227
R3521 VSS.n963 VSS.n962 0.473227
R3522 VSS.n900 VSS.n496 0.473227
R3523 VSS.t83 VSS.n900 0.473227
R3524 VSS.n908 VSS.n907 0.473227
R3525 VSS.n907 VSS.n906 0.473227
R3526 VSS.n560 VSS.n909 0.473227
R3527 VSS.t27 VSS.n560 0.473227
R3528 VSS.t143 VSS.n824 0.473227
R3529 VSS.n824 VSS.n83 0.473227
R3530 VSS.n4 VSS.n1104 0.473227
R3531 VSS.t8 VSS.n4 0.473227
R3532 VSS.n1092 VSS.n1091 0.473227
R3533 VSS.n1091 VSS.t241 0.473227
R3534 VSS.n53 VSS.n460 0.473227
R3535 VSS.n969 VSS.n968 0.473227
R3536 VSS.n969 VSS.t141 0.473227
R3537 VSS.n528 VSS.n527 0.473227
R3538 VSS.n527 VSS.t69 0.473227
R3539 VSS.n1306 VSS.n1305 0.473227
R3540 VSS.n1305 VSS.t125 0.473227
R3541 VSS.n1302 VSS.n1301 0.473227
R3542 VSS.t123 VSS.n1302 0.473227
R3543 VSS.n121 VSS.n928 0.473227
R3544 VSS.n670 VSS.t70 0.470856
R3545 VSS.n1008 VSS.n995 0.470823
R3546 VSS.t188 VSS.n1327 0.468397
R3547 VSS.t165 VSS.n602 0.468397
R3548 VSS.t32 VSS.n1057 0.468397
R3549 VSS.n1052 VSS.t183 0.468397
R3550 VSS.t147 VSS.n841 0.468397
R3551 VSS.n677 VSS.t193 0.468397
R3552 VSS.n505 VSS.n956 0.465754
R3553 VSS.n962 VSS.n499 0.465754
R3554 VSS.n906 VSS.n887 0.465754
R3555 VSS.n1139 VSS.n1138 0.46039
R3556 VSS.n1128 VSS.n377 0.45502
R3557 VSS.n692 VSS.n658 0.453551
R3558 VSS.n84 VSS.n83 0.447448
R3559 VSS.n1195 VSS.n320 0.446573
R3560 VSS.n827 VSS.n115 0.437643
R3561 VSS.n19 VSS.n68 0.437643
R3562 VSS.t187 VSS.t213 0.425354
R3563 VSS.t170 VSS.t34 0.425354
R3564 VSS.n1329 VSS.t194 0.425354
R3565 VSS.n861 VSS.n69 0.418786
R3566 VSS.n827 VSS.n69 0.418786
R3567 VSS.n784 VSS.n634 0.418786
R3568 VSS.n784 VSS.n68 0.418786
R3569 VSS.n1327 VSS.n155 0.414856
R3570 VSS.n686 VSS.n685 0.414856
R3571 VSS.n678 VSS.n677 0.414856
R3572 VSS.n1330 VSS.n147 0.414856
R3573 VSS.n1128 VSS.t267 0.41346
R3574 VSS.n1225 VSS.n1224 0.407103
R3575 VSS.n714 VSS.n706 0.4055
R3576 VSS.n669 VSS.n342 0.4055
R3577 VSS.n377 VSS.t269 0.4005
R3578 VSS.n818 VSS.n95 0.399071
R3579 VSS.n638 VSS.n637 0.392709
R3580 VSS.n163 VSS.t192 0.385132
R3581 VSS.t131 VSS.n713 0.381468
R3582 VSS.t229 VSS.n17 0.185959
R3583 VSS.t207 VSS.n570 0.37366
R3584 VSS.t207 VSS.n569 0.37366
R3585 VSS.n58 VSS.n157 0.367069
R3586 VSS.t105 VSS.n50 0.365794
R3587 VSS.n1194 VSS.n323 0.365272
R3588 VSS.n586 VSS.t139 0.361489
R3589 VSS.n323 VSS.t189 0.347167
R3590 VSS.n314 VSS.n313 0.347167
R3591 VSS.n313 VSS.n307 0.347167
R3592 VSS.t214 VSS.n426 0.347167
R3593 VSS.n426 VSS.n25 0.347167
R3594 VSS.n3 VSS.t132 0.347167
R3595 VSS.t8 VSS.n3 0.347167
R3596 VSS.n980 VSS.n976 0.347167
R3597 VSS.n980 VSS.n29 0.347167
R3598 VSS.n1069 VSS.t186 0.347167
R3599 VSS.n1069 VSS.n47 0.347167
R3600 VSS.n1271 VSS.n1270 0.347167
R3601 VSS.n1270 VSS.n1269 0.347167
R3602 VSS.n41 VSS.n208 0.347167
R3603 VSS.t161 VSS.n1284 0.347167
R3604 VSS.n1284 VSS.n1283 0.347167
R3605 VSS.n1257 VSS.t224 0.347167
R3606 VSS.n1258 VSS.n1257 0.347167
R3607 VSS.n1017 VSS.n446 0.347167
R3608 VSS.n1017 VSS.n105 0.347167
R3609 VSS.n107 VSS.n388 0.347167
R3610 VSS.n108 VSS.n107 0.347167
R3611 VSS.n691 VSS.t72 0.346772
R3612 VSS.n1054 VSS.n1053 0.341685
R3613 VSS.n1056 VSS.n1055 0.341685
R3614 VSS.n1269 VSS.n173 0.337093
R3615 VSS.n1259 VSS.n1258 0.337093
R3616 VSS.t8 VSS.n1 0.335353
R3617 VSS.n96 VSS.n113 0.324584
R3618 VSS.n648 VSS.n789 0.323326
R3619 VSS.t129 VSS.n76 0.321872
R3620 VSS.n648 VSS.t167 0.318341
R3621 VSS.t248 VSS.n57 0.316631
R3622 VSS.n1223 VSS.t62 2.67931
R3623 VSS.n158 VSS.n57 0.300151
R3624 VSS.t125 VSS.n1304 0.290894
R3625 VSS.t20 VSS.n274 0.288581
R3626 VSS.n239 VSS.n203 0.287122
R3627 VSS.n1166 VSS.n1165 0.284015
R3628 VSS.n112 VSS.n1214 0.28175
R3629 VSS.n39 VSS.n35 0.28175
R3630 VSS.n1157 VSS.n1156 0.280866
R3631 VSS.t107 VSS.n114 0.278582
R3632 VSS.t112 VSS.n133 0.274897
R3633 VSS.t100 VSS.n132 0.274897
R3634 VSS.n137 VSS.n132 0.274755
R3635 VSS.n772 VSS.t126 0.274184
R3636 VSS.n773 VSS.n772 0.274184
R3637 VSS.n752 VSS.n698 0.274184
R3638 VSS.n752 VSS.t127 0.274184
R3639 VSS.n649 VSS.n87 0.274184
R3640 VSS.n647 VSS.t202 0.274184
R3641 VSS.t201 VSS.n647 0.274184
R3642 VSS.n695 VSS.n694 0.274184
R3643 VSS.n694 VSS.n693 0.274184
R3644 VSS.n656 VSS.n331 0.274184
R3645 VSS.n659 VSS.n656 0.274184
R3646 VSS.n1165 VSS.n1164 0.274184
R3647 VSS.n1164 VSS.t22 0.274184
R3648 VSS.n673 VSS.n339 0.274184
R3649 VSS.n341 VSS.n339 0.274184
R3650 VSS.n133 VSS.t114 0.274184
R3651 VSS.n134 VSS.t113 0.274184
R3652 VSS.t101 VSS.n1337 0.274184
R3653 VSS.n77 VSS.n593 0.274184
R3654 VSS.t220 VSS.n77 0.274184
R3655 VSS.n858 VSS.n857 0.274184
R3656 VSS.n631 VSS.n630 0.274184
R3657 VSS.n630 VSS.t253 0.274184
R3658 VSS.n629 VSS.n628 0.274184
R3659 VSS.n114 VSS.n852 0.274184
R3660 VSS.n854 VSS.n853 0.274184
R3661 VSS.n2 VSS.n1087 0.274184
R3662 VSS.n975 VSS.n974 0.274184
R3663 VSS.n974 VSS.t105 0.274184
R3664 VSS.n585 VSS.n584 0.274184
R3665 VSS.n1307 VSS.t0 0.274184
R3666 VSS.n1307 VSS.t1 0.274184
R3667 VSS.t0 VSS.n178 0.274184
R3668 VSS.n181 VSS.n178 0.274184
R3669 VSS.t61 VSS.n43 0.274184
R3670 VSS.t62 VSS.n43 0.274184
R3671 VSS.t61 VSS.n925 0.274184
R3672 VSS.n925 VSS.n924 0.274184
R3673 VSS.n1337 VSS.t100 0.27411
R3674 VSS.t112 VSS.n134 0.27411
R3675 VSS.n705 VSS.t129 0.274047
R3676 VSS.n665 VSS.t192 0.272711
R3677 VSS.n1269 VSS.n172 0.263577
R3678 VSS.n1258 VSS.n216 0.263577
R3679 VSS.n1260 VSS.n1259 0.263577
R3680 VSS.n76 VSS.n706 0.262588
R3681 VSS.n671 VSS.n670 0.262588
R3682 VSS.n671 VSS.n669 0.262588
R3683 VSS.n288 VSS.n287 0.258236
R3684 VSS.n934 VSS.n44 0.130326
R3685 VSS.n275 VSS.n180 0.2565
R3686 VSS.t62 VSS.n41 0.434426
R3687 VSS.n1163 VSS.n342 0.254574
R3688 VSS.n288 VSS.t62 0.254198
R3689 VSS.n1041 VSS.n6 0.0739091
R3690 VSS.n505 VSS.n507 0.2485
R3691 VSS.n504 VSS.n499 0.2485
R3692 VSS.n893 VSS.n887 0.2485
R3693 VSS.n765 VSS.n706 0.2475
R3694 VSS.n1212 VSS.t145 0.246643
R3695 VSS.n1228 VSS.n243 0.246032
R3696 VSS.t241 VSS.n7 0.095299
R3697 VSS.n670 VSS.n348 0.240263
R3698 VSS.n764 VSS.n712 0.2395
R3699 VSS.n239 VSS.n225 0.238878
R3700 VSS.n227 VSS.n225 0.238878
R3701 VSS.n1225 VSS.n231 0.238878
R3702 VSS.n11 VSS.t116 0.238797
R3703 VSS.n806 VSS.n805 0.238757
R3704 VSS.n514 VSS.n512 0.2385
R3705 VSS.n957 VSS.n506 0.2385
R3706 VSS.n901 VSS.n894 0.2385
R3707 VSS.n559 VSS.n558 0.2385
R3708 VSS.n683 VSS.n673 0.236762
R3709 VSS.n532 VSS.n521 0.235575
R3710 VSS.n1102 VSS.t8 0.232995
R3711 VSS.t123 VSS.n183 0.223735
R3712 VSS.t265 VSS.n1190 0.217167
R3713 VSS.n1190 VSS.n325 0.217167
R3714 VSS.n1191 VSS.t265 0.217167
R3715 VSS.n1192 VSS.n1191 0.217167
R3716 VSS.n579 VSS.n565 0.217167
R3717 VSS.n535 VSS.n534 0.217167
R3718 VSS.n536 VSS.n518 0.217167
R3719 VSS.n336 VSS.n335 0.217167
R3720 VSS.n1203 VSS.n1202 0.217167
R3721 VSS.n1202 VSS.n1201 0.217167
R3722 VSS.n413 VSS.t157 0.217167
R3723 VSS.n413 VSS.n393 0.217167
R3724 VSS.n423 VSS.t157 0.217167
R3725 VSS.n424 VSS.n423 0.217167
R3726 VSS.n1040 VSS.t86 0.217167
R3727 VSS.n1019 VSS.t86 0.217167
R3728 VSS.n1020 VSS.n1019 0.217167
R3729 VSS.n1068 VSS.n461 0.217167
R3730 VSS.n464 VSS.n461 0.217167
R3731 VSS.n987 VSS.n986 0.217167
R3732 VSS.n1320 VSS.n1319 0.217167
R3733 VSS.n1321 VSS.n1320 0.217167
R3734 VSS.n1318 VSS.n1317 0.217167
R3735 VSS.n1317 VSS.n1316 0.217167
R3736 VSS.n282 VSS.n267 0.217167
R3737 VSS.n267 VSS.n46 0.217167
R3738 VSS.n283 VSS.n282 0.217167
R3739 VSS.n283 VSS.n166 0.217167
R3740 VSS.t52 VSS.n220 0.217167
R3741 VSS.n1248 VSS.n220 0.217167
R3742 VSS.t51 VSS.n1251 0.217167
R3743 VSS.n1251 VSS.n1250 0.217167
R3744 VSS.n223 VSS.n217 0.217167
R3745 VSS.n1245 VSS.n1244 0.217167
R3746 VSS.n1246 VSS.n1245 0.217167
R3747 VSS.n1068 VSS.n1067 0.217167
R3748 VSS.n1067 VSS.n1066 0.217167
R3749 VSS.n1079 VSS.n1078 0.217167
R3750 VSS.n1078 VSS.n1077 0.217167
R3751 VSS.n1036 VSS.n1035 0.217167
R3752 VSS.n1036 VSS.n1001 0.217167
R3753 VSS.n1023 VSS.n1022 0.217167
R3754 VSS.n404 VSS.n403 0.217167
R3755 VSS.n404 VSS.n398 0.217167
R3756 VSS.n421 VSS.n420 0.217167
R3757 VSS.n1166 VSS.n337 0.213136
R3758 VSS.n86 VSS.n84 0.211035
R3759 VSS.n1041 VSS.n996 0.209848
R3760 VSS.n318 VSS.n306 0.206816
R3761 VSS.n1219 VSS.n1218 0.206816
R3762 VSS.n1220 VSS.n1219 0.206816
R3763 VSS.n1137 VSS.n363 0.203688
R3764 VSS.t42 VSS.n12 0.203247
R3765 VSS.n962 VSS.t42 0.202172
R3766 VSS.n906 VSS.t42 0.202172
R3767 VSS.n49 VSS.n917 0.201797
R3768 VSS.n933 VSS.n42 0.201797
R3769 VSS.n1167 VSS.n1166 0.2005
R3770 VSS.n1167 VSS.t248 0.2005
R3771 VSS.n1172 VSS.n1171 0.2005
R3772 VSS.n1171 VSS.n164 0.2005
R3773 VSS.n695 VSS.n334 0.2005
R3774 VSS.n334 VSS.n156 0.2005
R3775 VSS.t191 VSS.n55 0.2005
R3776 VSS.t248 VSS.n55 0.2005
R3777 VSS.t191 VSS.n1324 0.2005
R3778 VSS.n1324 VSS.n1323 0.2005
R3779 VSS.n145 VSS.n144 0.2005
R3780 VSS.n158 VSS.n145 0.2005
R3781 VSS.n56 VSS.n1325 0.2005
R3782 VSS.t248 VSS.n56 0.2005
R3783 VSS.t234 VSS.n936 0.2005
R3784 VSS.n936 VSS.n935 0.2005
R3785 VSS.n940 VSS.t234 0.2005
R3786 VSS.n940 VSS.n522 0.2005
R3787 VSS.n1132 VSS.n1131 0.2005
R3788 VSS.n1132 VSS.n372 0.2005
R3789 VSS.n1141 VSS.n363 0.2005
R3790 VSS.n604 VSS.t14 0.2005
R3791 VSS.n604 VSS.n383 0.2005
R3792 VSS.t14 VSS.n382 0.2005
R3793 VSS.n1120 VSS.n382 0.2005
R3794 VSS.t84 VSS.n617 0.2005
R3795 VSS.n88 VSS.n617 0.2005
R3796 VSS.t84 VSS.n850 0.2005
R3797 VSS.n850 VSS.n849 0.2005
R3798 VSS.n1107 VSS.n1106 0.197643
R3799 VSS.n1106 VSS.n1105 0.197643
R3800 VSS.n66 VSS.n65 0.0314565
R3801 VSS.n111 VSS.n251 0.189927
R3802 VSS.n915 VSS.t141 0.189799
R3803 VSS.t185 VSS.n432 0.189747
R3804 VSS.n1172 VSS.n331 0.18951
R3805 VSS.t144 VSS.t110 0.18951
R3806 VSS.n227 VSS.n215 0.186581
R3807 VSS.n1065 VSS.n127 0.183658
R3808 VSS.n286 VSS.t62 0.183236
R3809 VSS.n324 VSS.n124 0.182605
R3810 VSS.n131 VSS.n128 0.182605
R3811 VSS.n1207 VSS.n306 0.180237
R3812 VSS.n287 VSS.n100 0.178543
R3813 VSS.n665 VSS.t248 0.178441
R3814 VSS.n1042 VSS.n995 0.178372
R3815 VSS.n278 VSS.n275 0.176552
R3816 VSS.n79 VSS.t62 0.176245
R3817 VSS.n1207 VSS.n1206 0.176
R3818 VSS.n756 VSS.n700 0.175137
R3819 VSS.n1117 VSS.n136 0.173577
R3820 VSS.n1117 VSS.n1116 0.173577
R3821 VSS.n1138 VSS.t229 0.170912
R3822 VSS.n431 VSS.t185 0.170637
R3823 VSS.n1215 VSS.n246 0.164212
R3824 VSS.n45 VSS.n246 0.164212
R3825 VSS.n1218 VSS.n251 0.164184
R3826 VSS.n117 VSS.n106 0.00940507
R3827 VSS.n916 VSS.n915 0.16288
R3828 VSS.n84 VSS.t13 0.161461
R3829 VSS.n1053 VSS.n483 0.156013
R3830 VSS.n1056 VSS.n480 0.155925
R3831 VSS.n131 VSS.n130 0.1555
R3832 VSS.n1200 VSS.n124 0.1555
R3833 VSS.n1208 VSS.n305 0.154447
R3834 VSS.n39 VSS.n37 0.154447
R3835 VSS.n1076 VSS.n33 0.154447
R3836 VSS.n117 VSS.n116 0.154447
R3837 VSS.n75 VSS.n756 0.151824
R3838 VSS.n1055 VSS.n33 0.151114
R3839 VSS.n1054 VSS.n39 0.1508
R3840 VSS.n956 VSS.t42 0.149972
R3841 VSS.n138 VSS.t114 0.148429
R3842 VSS.n308 VSS.n307 0.146353
R3843 VSS.t201 VSS.n646 0.145095
R3844 VSS.n695 VSS.n651 0.144944
R3845 VSS.t45 VSS.n651 0.144944
R3846 VSS.n695 VSS.n654 0.144944
R3847 VSS.n654 VSS.t261 0.144944
R3848 VSS.n688 VSS.n160 0.144944
R3849 VSS.n688 VSS.t50 0.144944
R3850 VSS.n1333 VSS.n1332 0.144944
R3851 VSS.n1332 VSS.t264 0.144944
R3852 VSS.n807 VSS.t231 0.144944
R3853 VSS.t230 VSS.n804 0.144944
R3854 VSS.n775 VSS.n774 0.144407
R3855 VSS.n1116 VSS.n1115 0.14331
R3856 VSS.n686 VSS.t213 0.140086
R3857 VSS.n1330 VSS.n1329 0.140086
R3858 VSS.n935 VSS.n934 0.138173
R3859 VSS.t105 VSS.n53 0.500549
R3860 VSS.t65 VSS.n121 0.504603
R3861 VSS.t65 VSS.n120 0.435863
R3862 VSS.n1095 VSS.n1094 0.133833
R3863 VSS.n1095 VSS.n1093 0.133833
R3864 VSS.n1103 VSS.n1102 0.133833
R3865 VSS.n712 VSS.t131 0.131609
R3866 VSS.n79 VSS.n78 0.127096
R3867 VSS.n1277 VSS.n1276 0.126272
R3868 VSS.n1276 VSS.n182 0.126272
R3869 VSS.t22 VSS.n1163 0.125685
R3870 VSS.n1119 VSS.t269 0.1255
R3871 VSS.n377 VSS.n376 0.1255
R3872 VSS.n1297 VSS.n1296 0.12431
R3873 VSS.n587 VSS.n572 0.124233
R3874 VSS.t62 VSS.t65 0.171973
R3875 VSS.n74 VSS.t201 0.121911
R3876 VSS.n72 VSS.n26 0.114715
R3877 VSS.n1322 VSS.n79 0.121036
R3878 VSS.t70 VSS.n342 0.1205
R3879 VSS.n11 VSS.n569 0.1199
R3880 VSS.n746 VSS.n745 0.119374
R3881 VSS.n744 VSS.n722 0.119374
R3882 VSS.n1272 VSS.n188 0.118682
R3883 VSS.n272 VSS.n188 0.118682
R3884 VSS.n1273 VSS.n1272 0.118682
R3885 VSS.n1274 VSS.n1273 0.118682
R3886 VSS.n1215 VSS.n96 0.118064
R3887 VSS.n571 VSS.n553 0.116056
R3888 VSS.t105 VSS.n49 0.114842
R3889 VSS.t42 VSS.n11 0.114661
R3890 VSS.n915 VSS.n48 0.19745
R3891 VSS.t102 VSS.n138 0.113421
R3892 VSS.n1213 VSS.n1212 0.111581
R3893 VSS.t57 VSS.n572 0.111138
R3894 VSS.t57 VSS.n873 0.111138
R3895 VSS.n873 VSS.n552 0.111138
R3896 VSS.n1123 VSS.t53 0.111138
R3897 VSS.n1124 VSS.n1123 0.111138
R3898 VSS.t53 VSS.n1122 0.111138
R3899 VSS.n1122 VSS.n1121 0.111138
R3900 VSS.n163 VSS.t213 0.109377
R3901 VSS.n1008 VSS.n1001 0.10908
R3902 VSS.n1077 VSS.n126 0.10908
R3903 VSS.n602 VSS.n65 0.187547
R3904 VSS.n1053 VSS.n1052 0.109052
R3905 VSS.n1057 VSS.n1056 0.109052
R3906 VSS.n1010 VSS.n1009 0.108915
R3907 VSS.n32 VSS.n1073 0.108743
R3908 VSS.n1156 VSS.n349 0.105098
R3909 VSS.n1115 VSS 0.104908
R3910 VSS.t62 VSS.n42 0.104316
R3911 VSS.n1153 VSS.n26 0.102773
R3912 VSS.n1116 VSS 0.102401
R3913 VSS.n1201 VSS.n318 0.101553
R3914 VSS.n1220 VSS.n46 0.101553
R3915 VSS.n37 VSS.n1001 0.101553
R3916 VSS.n1077 VSS.n1076 0.101553
R3917 VSS.n116 VSS.n398 0.101553
R3918 VSS.n1329 VSS.t145 0.101369
R3919 VSS.n1327 VSS.n1326 0.101328
R3920 VSS.n833 VSS.t13 0.0989051
R3921 VSS.n291 VSS.n260 0.0982881
R3922 VSS.n1340 VSS.n1339 0.0977893
R3923 VSS.n309 VSS.n299 0.0975782
R3924 VSS.t83 VSS.t42 0.0961664
R3925 VSS.t42 VSS.t27 0.0959527
R3926 VSS.t50 VSS.n660 0.0952979
R3927 VSS.t209 VSS.t40 0.0947086
R3928 VSS.n677 VSS.n299 0.09376
R3929 VSS.n790 VSS.n646 0.0930352
R3930 VSS.n876 VSS.n568 0.0914084
R3931 VSS.n105 VSS.n39 0.0957659
R3932 VSS.n108 VSS.n106 0.0957659
R3933 VSS.n878 VSS.n568 0.0905
R3934 VSS.n646 VSS.n648 0.0898488
R3935 VSS.t42 VSS.n63 1.02387
R3936 VSS.n243 VSS.n242 0.0885851
R3937 VSS.n1126 VSS.n1125 0.0874849
R3938 VSS.n894 VSS.t83 0.0849615
R3939 VSS.n559 VSS.t27 0.0849615
R3940 VSS.n506 VSS.t209 0.0849615
R3941 VSS.n876 VSS.t42 0.0848047
R3942 VSS.n397 VSS.n106 0.0529786
R3943 VSS.n1055 VSS.n1054 0.0821911
R3944 VSS.n1200 VSS.n319 0.0810025
R3945 VSS.n130 VSS.n25 0.0810025
R3946 VSS.n877 VSS.n569 0.0803
R3947 VSS.t42 VSS.n13 0.0789884
R3948 VSS.n659 VSS.n349 0.0769542
R3949 VSS.n588 VSS.n587 0.0762412
R3950 VSS.n1278 VSS.t243 0.0761986
R3951 VSS.n324 VSS.n320 0.0755
R3952 VSS.n1065 VSS.n47 0.0755
R3953 VSS.n128 VSS.n25 0.0755
R3954 VSS.n805 VSS.t56 0.0748154
R3955 VSS.n627 VSS.t13 0.498224
R3956 VSS.n115 VSS.t13 0.468863
R3957 VSS.n785 VSS.t167 0.498224
R3958 VSS.t264 VSS.n57 0.0738775
R3959 VSS.t43 VSS.n1109 0.071682
R3960 VSS.n193 VSS.t221 0.071682
R3961 VSS.n1212 VSS.n1211 0.0701769
R3962 VSS.n24 VSS.n412 0.0698899
R3963 VSS.n1275 VSS.t243 0.0685548
R3964 VSS.n1196 VSS.n1195 0.0669942
R3965 VSS.n122 VSS.t69 0.0637862
R3966 VSS.n412 VSS.n65 0.063375
R3967 VSS.n774 VSS.t127 0.0603002
R3968 VSS.n756 VSS.t127 0.0603002
R3969 VSS.n1303 VSS.t123 0.059903
R3970 VSS.n775 VSS.n74 0.0592823
R3971 VSS.n763 VSS.n715 0.0592823
R3972 VSS.t129 VSS.n75 0.0592823
R3973 VSS.n372 VSS.n371 0.0589319
R3974 VSS.n1135 VSS.n361 0.0582778
R3975 VSS.n1136 VSS.n1135 0.0582778
R3976 VSS.n368 VSS.t226 0.0582778
R3977 VSS.n368 VSS.n367 0.0582778
R3978 VSS.n1125 VSS.t107 0.0581855
R3979 VSS.n32 VSS.n50 0.0570076
R3980 VSS.n1009 VSS.n1 0.0570076
R3981 VSS.n378 VSS.n1118 0.0560556
R3982 VSS.n1118 VSS.n1114 0.0560556
R3983 VSS.n1212 VSS.n300 0.0543356
R3984 VSS.n1201 VSS.n1200 0.0533947
R3985 VSS.n130 VSS.n398 0.0533947
R3986 VSS.t131 VSS.n763 0.0531937
R3987 VSS.n231 VSS.n215 0.0527973
R3988 VSS.n1073 VSS.n126 0.0519716
R3989 VSS.n1010 VSS.n1008 0.0519716
R3990 VSS.n1163 VSS.n1162 0.0514248
R3991 VSS.t50 VSS.n687 0.0513776
R3992 VSS.t264 VSS.n1331 0.0513776
R3993 VSS.n660 VSS.n659 0.0502348
R3994 VSS.n50 VSS.n31 0.0492786
R3995 VSS.n36 VSS.n1 0.0491069
R3996 VSS.n751 VSS.n718 0.0473468
R3997 VSS.n747 VSS.n718 0.0473468
R3998 VSS.n751 VSS.n750 0.0473468
R3999 VSS.n750 VSS.n749 0.0473468
R4000 VSS.n729 VSS.n725 0.0473468
R4001 VSS.n729 VSS.n728 0.0473468
R4002 VSS.n731 VSS.n725 0.0473468
R4003 VSS.n732 VSS.n731 0.0473468
R4004 VSS.n735 VSS.n726 0.0473468
R4005 VSS.n735 VSS.n734 0.0473468
R4006 VSS.n737 VSS.n736 0.0473468
R4007 VSS.n736 VSS.n711 0.0473468
R4008 VSS.n834 VSS.n592 0.0473468
R4009 VSS.n834 VSS.n97 0.0473468
R4010 VSS.n833 VSS.n832 0.0473468
R4011 VSS.n582 VSS.n581 0.0469299
R4012 VSS.n582 VSS.t195 0.0449953
R4013 VSS.t62 VSS.n96 1.4109
R4014 VSS.n1195 VSS.n1194 0.0433103
R4015 VSS.n1182 VSS.n301 0.0423342
R4016 VSS.n1182 VSS.n306 0.0423342
R4017 VSS.n322 VSS.n319 0.0423342
R4018 VSS.n1236 VSS.n232 0.0423342
R4019 VSS.n1236 VSS.n231 0.0423342
R4020 VSS.n1239 VSS.n205 0.0423342
R4021 VSS.n1239 VSS.n225 0.0423342
R4022 VSS.n1219 VSS.n247 0.0423342
R4023 VSS.n247 VSS.n246 0.0423342
R4024 VSS.n813 VSS.n812 0.0414449
R4025 VSS.n812 VSS.n636 0.0414449
R4026 VSS.n1152 VSS.n1151 0.0414449
R4027 VSS.n1151 VSS.n1150 0.0414449
R4028 VSS.n358 VSS.n351 0.0414449
R4029 VSS.n358 VSS.n353 0.0414449
R4030 VSS.n1146 VSS.n1145 0.0414449
R4031 VSS.n1147 VSS.n1146 0.0414449
R4032 VSS.n102 VSS.n482 0.0413456
R4033 VSS.n104 VSS.n481 0.0413456
R4034 VSS.n803 VSS.n135 0.0408927
R4035 VSS.n801 VSS.n135 0.0403915
R4036 VSS.n1331 VSS.t145 0.0402234
R4037 VSS.n803 VSS.n802 0.0398939
R4038 VSS.n801 VSS.n635 0.0398939
R4039 VSS.n1125 VSS.n379 0.0396691
R4040 VSS.t62 VSS.n45 0.164179
R4041 VSS.n24 VSS.n397 0.0388338
R4042 VSS.n1207 VSS.n307 0.0362353
R4043 VSS.n715 VSS.n714 0.0361879
R4044 VSS.n1196 VSS.n322 0.0359395
R4045 VSS.n1179 VSS.n322 0.0359395
R4046 VSS.n1179 VSS.n301 0.0359395
R4047 VSS.n1211 VSS.n301 0.0359395
R4048 VSS.n1210 VSS.n304 0.0343415
R4049 VSS.n1180 VSS.t98 0.0343415
R4050 VSS.n1177 VSS.n1176 0.0343415
R4051 VSS.n1198 VSS.n1197 0.0343415
R4052 VSS.n123 VSS.t174 0.0343415
R4053 VSS.t171 VSS.n1209 0.0343415
R4054 VSS.n1075 VSS.n458 0.0343415
R4055 VSS.t29 VSS.n1074 0.0343415
R4056 VSS.n1227 VSS.n245 0.0343415
R4057 VSS.t222 VSS.n1226 0.0343415
R4058 VSS.n230 VSS.n229 0.0343415
R4059 VSS.t227 VSS.n228 0.0343415
R4060 VSS.n241 VSS.n238 0.0343415
R4061 VSS.t256 VSS.n240 0.0343415
R4062 VSS.n1012 VSS.n40 1.08761
R4063 VSS.t259 VSS.n1043 0.0343415
R4064 VSS.n1016 VSS.n1015 0.0343415
R4065 VSS.n103 VSS.t79 0.0343415
R4066 VSS.n1217 VSS.n252 0.0343415
R4067 VSS.t73 VSS.n254 0.0343415
R4068 VSS.n249 VSS.n248 0.0343415
R4069 VSS.n1222 VSS.t36 0.0343415
R4070 VSS.n285 VSS.t178 0.0343415
R4071 VSS.n125 VSS.n466 0.0343415
R4072 VSS.t150 VSS.n467 0.0343415
R4073 VSS.n411 VSS.n409 0.0343415
R4074 VSS.n54 VSS.n131 0.606791
R4075 VSS.n416 VSS.n415 0.0343415
R4076 VSS.n418 VSS.t93 0.0343415
R4077 VSS.t196 VSS.n410 0.0343415
R4078 VSS.n1042 VSS.n1041 0.03425
R4079 VSS.n1115 VSS.n1114 0.0322348
R4080 VSS.n273 VSS.n272 0.0317648
R4081 VSS.n1154 VSS.n349 0.0307753
R4082 VSS.n587 VSS.t141 0.0306586
R4083 VSS.n814 VSS.n639 0.0302143
R4084 VSS.n639 VSS.n638 0.0302143
R4085 VSS.n816 VSS.n815 0.0302143
R4086 VSS.n817 VSS.n816 0.0302143
R4087 VSS.n180 VSS.t1 0.0299059
R4088 VSS.n305 VSS.n300 0.0297603
R4089 VSS.n287 VSS.n286 0.0293851
R4090 VSS.n935 VSS.t69 0.0289629
R4091 VSS.n308 VSS.n305 0.0285274
R4092 VSS.n714 VSS.t10 0.0280875
R4093 VSS.n1208 VSS.n1207 0.0270789
R4094 VSS.n102 VSS.n483 0.0269797
R4095 VSS.n104 VSS.n480 0.0269797
R4096 VSS.n877 VSS.n876 0.0261021
R4097 VSS.n11 VSS.t195 0.0255714
R4098 VSS.n808 VSS.n807 0.0249085
R4099 VSS.n673 VSS.n655 0.0241262
R4100 VSS.n687 VSS.n665 0.023
R4101 VSS.n279 VSS.n278 0.0220217
R4102 VSS.t76 VSS.t62 0.973907
R4103 VSS.t85 VSS.n88 0.77502
R4104 VSS.n1160 VSS.n345 0.0211397
R4105 VSS.n655 VSS.n346 0.0211033
R4106 VSS.n1154 VSS.n343 0.0189575
R4107 VSS.n1162 VSS.n343 0.017369
R4108 VSS.n917 VSS.n916 0.0160639
R4109 VSS.n934 VSS.n933 0.0160639
R4110 VSS.t102 VSS.n137 0.0155674
R4111 VSS.n1054 VSS.n482 0.0145552
R4112 VSS.n1055 VSS.n481 0.0145552
R4113 VSS.n309 VSS.n308 0.0144726
R4114 VSS.n272 VSS.n183 0.013704
R4115 VSS.t8 VSS.n2 0.285615
R4116 VSS.n1121 VSS.t15 0.257779
R4117 VSS.n113 VSS.n112 0.257612
R4118 VSS.n91 VSS.n90 0.217812
R4119 VSS.n110 VSS.n109 0.141938
R4120 VSS.n79 VSS.t42 0.126633
R4121 VSS.n790 VSS.t198 0.116106
R4122 VSS.t250 VSS.n86 0.116106
R4123 VSS.n82 VSS.n74 0.107153
R4124 VSS.t129 VSS.t10 0.107099
R4125 VSS.n33 VSS.n29 0.0957659
R4126 VSS.n108 VSS.n65 0.0776994
R4127 VSS.n105 VSS.n104 0.0776994
R4128 VSS.n29 VSS.n102 0.0776994
R4129 VSS.n601 VSS.t107 0.0598504
R4130 VSS.t62 VSS.n46 0.105835
R4131 VSS.n95 VSS.n94 0.104986
R4132 VSS.t56 VSS.n81 0.0912332
R4133 VSS.n514 VSS.t119 0.0898077
R4134 VSS.t105 VSS.n47 0.0844219
R4135 VSS.n98 VSS.n82 0.0262779
R4136 VSS.t253 VSS.n84 0.0828158
R4137 VSS.t42 VSS.n16 1.03423
R4138 VSS.t167 VSS.n19 0.468863
R4139 VSS.n94 VSS.t167 0.432302
R4140 VSS.n372 VSS.t229 0.426398
R4141 VSS.n25 VSS.n24 0.389867
R4142 VSS.n1326 VSS.t248 0.385153
R4143 VSS.n371 VSS.n26 0.374395
R4144 VSS.t220 VSS.t13 0.367386
R4145 VSS.t62 VSS.n44 0.360385
R4146 VSS.t40 VSS.t42 0.155725
R4147 VSS.t139 VSS.t105 0.353774
R4148 VSS.n33 VSS.n32 0.342885
R4149 VSS.n1009 VSS.n39 0.342747
R4150 VSS.n522 VSS.n14 2.61553
R4151 VSS.t8 VSS.n5 1.00859
C0 a_27936_308366# a_25791_309144# 0.00302f
C1 x1.OUT4 WM 0
C2 a_5044_273700# x1.OUT2 0
C3 VDD a_22462_290353# 0.0297f
C4 x1.EN3 a_25120_282778# 0.00438f
C5 HALFBAT REFOUT 0.03474f
C6 x1.x1.x2.VREF a_7588_288447# 0.44258f
C7 a_14012_250994# x2.x1.OUT 3.22121f
C8 a_8361_274636# x1.x4.R 0.26609f
C9 x1.x2.R a_10056_287214# 0
C10 a_23654_250994# a_22478_251302# 0.13602f
C11 x1.OUT1 a_15046_289227# 0.0014f
C12 a_22478_250994# x2.x3.MINUS 0.09306f
C13 a_15044_280595# x1.x3.x2.VREF 0.07645f
C14 DISABLE a_21793_252030# 0.0207f
C15 a_13869_282343# x1.x2.R 0.06981f
C16 a_25120_285050# x1.S0N 0.02111f
C17 a_4934_308695# VDD 1.44136f
C18 VDD a_10054_278582# 0.1205f
C19 x1.EN3 x1.S0N 0.62607f
C20 x1.EN4 x1.OUT3 0.00321f
C21 x1.x2.x2.VREF a_14837_285088# 0.00957f
C22 GATE CE 0
C23 a_12835_310048# x10.MINUS 0.09876f
C24 VDD a_25120_285050# 0.2709f
C25 a_10653_275509# x1.x4.R 0.26628f
C26 a_12836_250994# x2.x1.OUT 0.00262f
C27 VDD x1.EN3 2.73918f
C28 a_22462_290353# x1.OUT1 0.0183f
C29 a_15729_279867# a_7586_279815# 0
C30 a_23654_250994# a_21793_252030# 0.1225f
C31 a_4886_309840# VDD 10.659f
C32 a_6194_285737# a_5090_285737# 0.00396f
C33 a_25120_280506# x1.OUT3 0.46666f
C34 LENb PROG 0.47496f
C35 x1.S1N a_25612_286326# 0.3227f
C36 a_25120_282778# x1.S0N 0.04827f
C37 x1.OUT3 x1.OUT2 0.07329f
C38 a_17971_276456# a_13867_273711# 0.00342f
C39 VDD a_21358_286211# 0.02309f
C40 x1.x2.x2.VREF a_8363_282343# 0.07645f
C41 a_12150_310776# x10.MINUS 0.65031f
C42 VDD a_17973_285088# 0.00404f
C43 VDD a_43001_277554# 0.10737f
C44 a_15044_280595# a_7586_279815# 0.00532f
C45 PWRENb LENb 0.00596f
C46 VDD a_25120_282778# 0.27009f
C47 x1.x4.x1.OUT x1.x4.R 0.48832f
C48 a_25120_285050# x1.OUT1 0.2302f
C49 REFOUT a_25612_281782# 0.01955f
C50 a_25120_278234# S0 0.02109f
C51 x1.x1.x1.OUT x1.x1.R 0.36007f
C52 VDD a_12418_278990# 0.0252f
C53 x6.B CEN 0.00462f
C54 DISABLE CEN 0.24033f
C55 a_8361_273711# a_10429_273931# 0.86973f
C56 a_17971_276456# a_16243_275356# 0.0341f
C57 a_16287_275856# a_13867_273711# 0.00182f
C58 a_8363_283268# a_8363_282343# 0.0757f
C59 x1.EN1 S0 0.00186f
C60 VDD x1.S0N 1.1328f
C61 a_5090_282373# x1.x2.R 0.0301f
C62 PWRENb WEH 0.03423f
C63 VDD a_10431_282563# 3.01489f
C64 a_25612_279510# S0 0.30632f
C65 x1.x1.x1.OUT a_15731_288191# 0.04672f
C66 LATCH x6.B 1.27689f
C67 x1.EN2 x1.S1N 0.20331f
C68 a_16287_275856# a_16243_275356# 0.49277f
C69 a_14835_276456# a_13867_273711# 0.00755f
C70 OPOUT PROG 0.72822f
C71 a_7666_278098# a_7634_278670# 0.33125f
C72 a_10655_284141# a_8363_282343# 0.03669f
C73 a_7586_279815# x1.x2.R 0.08135f
C74 a_12836_251302# a_14012_250994# 0.13602f
C75 x2.MINUS a_12836_250994# 0.09313f
C76 a_4886_309840# x10.MINUS 0.00151f
C77 x1.OUT4 REFOUT 0.74093f
C78 x1.x2.x2.VREF a_16245_283988# 0
C79 VDD a_25612_284054# 0
C80 x1.S0N x1.OUT1 0.0193f
C81 x1.x1.x1.OUT a_15731_288499# 0.01368f
C82 a_4934_308695# a_7354_308607# 0.49277f
C83 a_8363_282343# x1.x2.R 0.34548f
C84 a_8361_273711# a_13867_273711# 0.00532f
C85 a_14835_276456# a_16243_275356# 0.04671f
C86 VDD x1.OUT1 3.28937f
C87 a_7666_278098# a_7586_279815# 0.16355f
C88 a_12836_251302# a_12836_250994# 0.13302f
C89 a_9719_250269# a_7355_249861# 0.03516f
C90 a_12420_287622# x1.x1.x2.VREF 0.00957f
C91 a_8361_274636# x1.OUT2 0.00375f
C92 VDD x2.x3.OUT 8.54916f
C93 VDD HALFBAT 1.79463f
C94 x1.EN3 a_25612_281782# 0.0044f
C95 a_19144_309740# x5.MINUS 0.09345f
C96 x1.x1.x1.OUT a_15046_289227# 1.03953f
C97 x1.EN2 x1.OUT2 0.29231f
C98 a_4886_309840# a_7354_308607# 0.00182f
C99 a_8363_283268# x1.OUT2 0.0205f
C100 a_28942_249702# GATE 3.22671f
C101 VDD x1.x3.R 4.724f
C102 a_33989_250071# CEN 0.30358f
C103 VDD x10.MINUS 0.79269f
C104 a_27936_308366# PWRENb 0
C105 a_4967_249377# a_7355_249861# 0
C106 VDD a_22478_251302# 2.91683f
C107 a_51049_278076# CEN 0.00636f
C108 a_12151_252030# VDD 9.79901f
C109 a_7666_278098# a_8788_278098# 0.01906f
C110 LENb x6.B 0
C111 a_4934_308695# a_9718_309015# 0.04671f
C112 VDD a_15729_279559# 0.58667f
C113 x8.schmitt_0.Y RESET 1.20617f
C114 x1.OUT3 REFOUT 1.62486f
C115 x1.OUT4 x1.EN3 0.00932f
C116 VDD a_21793_252030# 9.94423f
C117 a_7355_249861# a_6089_249377# 0.01245f
C118 x1.S0N a_25612_281782# 0.31791f
C119 a_7588_288447# a_7636_287302# 0.86805f
C120 PD DONEb 0.20794f
C121 LATCH a_51049_278076# 0.30413f
C122 PU LENb 0.03298f
C123 CHRGb PROG 0.42766f
C124 x1.x4.x1.OUT x1.OUT2 0.00434f
C125 RESET DONEb 0.06581f
C126 a_4935_249949# VDD 1.44136f
C127 x1.OUT2 x1.x2.R 0.60257f
C128 x2.x3.PLUS PROG 0.01609f
C129 a_7354_308607# VDD 0.00134f
C130 a_4886_309840# a_9718_309015# 0.00755f
C131 a_24723_308864# VDD 0.58588f
C132 REFAMP x5.MINUS 0
C133 WEH a_40856_278332# 0.09706f
C134 VDD a_25612_281782# 0
C135 a_28942_249702# CE 0
C136 x8.schmitt_0.Y a_43777_278925# 0.1906f
C137 x1.S1N S1 2.64098f
C138 a_22478_251302# x2.x3.OUT 0.00116f
C139 x1.x3.x1.OUT VDD 1.90779f
C140 LATCH a_47649_278076# 0.00544f
C141 a_4887_251094# VDD 10.4978f
C142 a_14012_250994# PROG 0.1017f
C143 x1.EN4 S1 0.62921f
C144 S1 PROG 2.85587f
C145 a_13867_273711# a_10429_273931# 0
C146 x11.schmitt_0.Y a_28712_309737# 0.1906f
C147 a_20320_309740# VDD 1.20534f
C148 REFAMP a_14011_309740# 1.63466f
C149 WEH a_39788_278052# 0.10081f
C150 a_14011_309740# x5.MINUS 0.00187f
C151 x1.x2.x1.OUT a_10431_282563# 0.01363f
C152 a_21793_252030# x2.x3.OUT 2.56912f
C153 a_8361_273711# x1.x4.R 0.34548f
C154 x1.x2.x1.OUT VDD 1.98739f
C155 REFOUT WEH 0.18803f
C156 a_15729_279559# x1.x3.R 0.26628f
C157 a_25120_280506# S1 0.06936f
C158 x1.OUT4 VDD 8.68164f
C159 a_12836_250994# PROG 0.05935f
C160 GATE DONEb 0.75719f
C161 a_9718_309015# VDD 0.0314f
C162 a_27906_309737# a_28712_309737# 0.13792f
C163 VDD CEN 2.4529f
C164 VDD a_16905_279559# 1.01692f
C165 OPOUT a_39788_278052# 0.0017f
C166 a_21793_252030# a_22478_251302# 0.87704f
C167 x1.x1.x1.OUT VDD 1.94594f
C168 x1.OUT3 x1.EN3 0.4213f
C169 a_51049_278076# LENb 0
C170 OPOUT REFOUT 0.13237f
C171 a_4967_249377# a_6089_249377# 0.01906f
C172 a_10056_287214# a_7636_287302# 0.49277f
C173 x1.x3.x1.OUT x1.x3.R 0.49006f
C174 a_5044_273700# VDD 0.06351f
C175 x11.schmitt_0.A a_28712_309737# 0.04753f
C176 a_27906_309737# x11.schmitt_0.Y 0.26594f
C177 PD PROG 2.90038f
C178 VDD LATCH 5.05855f
C179 a_12835_309740# a_14011_309740# 0.13955f
C180 x1.EN2 REFOUT 0.36705f
C181 PD PWRENb 0.3588f
C182 RESET PWRENb 0.33818f
C183 x1.OUT3 a_25120_282778# 0.00312f
C184 a_10056_287214# a_7588_288447# 0.00182f
C185 a_4887_251094# a_12151_252030# 0.00375f
C186 x1.x3.x1.OUT a_15729_279559# 0.04672f
C187 x1.x1.x1.OUT x1.OUT1 0.4992f
C188 a_9719_250269# x2.MINUS 0.00957f
C189 a_16243_275356# a_13867_273711# 0.86805f
C190 x11.schmitt_0.A x11.schmitt_0.Y 0.34776f
C191 a_25791_309144# a_28712_309737# 0
C192 a_25791_309144# REFAMP 0.097f
C193 x1.OUT3 x1.S0N 0.00484f
C194 a_9718_309015# x10.MINUS 0
C195 x1.x3.R a_16905_279559# 0.2648f
C196 a_43777_278925# PWRENb 0.06706f
C197 a_4887_251094# a_4935_249949# 0.86805f
C198 a_12420_287622# a_7636_287302# 0.04671f
C199 VDD x1.OUT3 1.20226f
C200 a_25791_309144# x11.schmitt_0.Y 0.00767f
C201 x11.schmitt_0.A a_27906_309737# 0.13556f
C202 x1.x1.R S1 0
C203 a_10429_273931# x1.x4.R 0.3942f
C204 a_20320_309740# a_24723_308864# 0
C205 CHRGb PU 0.20708f
C206 a_15729_279559# a_16905_279559# 0.10299f
C207 a_12150_310776# a_18459_310776# 0.00179f
C208 WM a_32580_277758# 0
C209 a_7668_286730# a_7636_287302# 0.33125f
C210 a_12420_287622# a_7588_288447# 0.00755f
C211 x2.x3.PLUS a_23654_250994# 0.10026f
C212 GATE PWRENb 0.48855f
C213 VDD LENb 0.53869f
C214 x1.x1.x2.VREF x1.x1.R 0.31825f
C215 a_25791_309144# a_27906_309737# 0.00245f
C216 a_9718_309015# a_7354_308607# 0.03516f
C217 x1.S0N a_25612_286326# 0.30358f
C218 x1.S1N x1.EN1 0.71779f
C219 x1.EN2 a_25120_285050# 0.00438f
C220 x1.EN4 a_25120_278234# 0.48439f
C221 x1.EN3 x1.EN2 0.03606f
C222 a_12836_251302# x2.x1.OUT 0.00116f
C223 a_21404_278263# a_22508_278263# 0.00396f
C224 a_8361_273711# x1.OUT2 0
C225 PU S1 0.07981f
C226 VDD a_25612_286326# 0
C227 WM a_31404_278437# 0.37278f
C228 a_7668_286730# a_7588_288447# 0.16355f
C229 a_22478_250994# a_23654_250994# 0.19212f
C230 x1.x3.x1.OUT a_16905_279559# 1.73099f
C231 x1.x1.x2.VREF a_15731_288191# 0.09306f
C232 PWRENb BAT 0.59973f
C233 VDD a_22508_281381# 0.10229f
C234 VDD WEH 1.11076f
C235 a_25791_309144# x11.schmitt_0.A 0.24126f
C236 a_22462_286211# a_21358_286211# 0.00396f
C237 a_43777_278925# a_42971_278925# 0.13792f
C238 a_13867_273711# x1.x4.R 0.06981f
C239 VDD x1.x4.x2.VREF 2.60222f
C240 x1.OUT3 x1.x3.R 0.50852f
C241 x1.EN4 a_25612_279510# 0.0044f
C242 x1.S1N S0 0.2486f
C243 REFOUT S1 0.13111f
C244 PROG CE 0.47496f
C245 x1.EN2 a_25120_282778# 0.48439f
C246 x1.x4.x1.OUT a_10054_278582# 0.00661f
C247 VDD CTRLAMP 2.66115f
C248 a_10431_282563# x1.x2.x2.VREF 0.09876f
C249 PWRENb LEN 0.0027f
C250 x1.EN4 S0 0.19975f
C251 VDD x1.x2.x2.VREF 2.60227f
C252 x1.EN1 x1.OUT2 0.00932f
C253 VDD a_15729_279867# 2.89848f
C254 x1.x1.x2.VREF a_15731_288499# 0.09876f
C255 RESET x6.B 1.37808f
C256 OPOUT VDD 9.46942f
C257 x1.EN2 x1.S0N 0.00151f
C258 x1.S0N a_22462_286211# 0
C259 a_43777_278925# x8.schmitt_0.A 0.04753f
C260 VDD a_8361_274636# 0.99762f
C261 VDD a_19144_310048# 2.93562f
C262 PU PD 86.49271f
C263 a_10431_282563# a_8363_283268# 0.14627f
C264 VDD x1.EN2 2.81235f
C265 a_7666_278098# a_10054_278582# 0
C266 VDD a_8363_283268# 1.0501f
C267 a_12420_287622# a_10056_287214# 0.03516f
C268 a_5044_273700# x1.OUT4 0.02365f
C269 x1.x1.x2.VREF a_15046_289227# 0.07645f
C270 VDD a_15044_280595# 6.20724f
C271 PD a_3855_36764# 0.00812f
C272 a_43777_278925# a_40856_278332# 0
C273 VDD a_10653_275509# 0.64608f
C274 a_22462_290353# S1 0
C275 a_22508_281381# x1.x3.R 0.00459f
C276 x1.OUT3 a_25612_281782# 0.0128f
C277 LATCH CEN 0.31517f
C278 a_12836_251302# x2.MINUS 0.09876f
C279 x1.EN2 a_25612_284054# 0.0044f
C280 REFAMP x4.VREF 0.0039f
C281 x1.x3.x1.OUT x1.OUT3 0.48643f
C282 VDD a_18459_310776# 6.27693f
C283 a_10431_282563# a_10655_284141# 0.13302f
C284 a_27936_308366# VDD 0.18559f
C285 a_13869_282343# a_16289_284488# 0.00182f
C286 a_6088_308123# a_4934_308695# 0.0341f
C287 a_7668_286730# a_10056_287214# 0
C288 VDD a_10655_284141# 0.64577f
C289 x1.EN2 x1.OUT1 0.00171f
C290 DISABLE GATE 1.23667f
C291 PU a_5831_36764# 0.00302f
C292 VDD a_18663_275856# 0.02153f
C293 a_28712_309737# PWRENb 0
C294 a_15729_279867# x1.x3.R 0.39612f
C295 a_10431_282563# x1.x2.R 0.3942f
C296 x1.EN3 S1 0.20854f
C297 x4.VREF a_14011_309740# 0.13005f
C298 x1.x4.x1.OUT VDD 1.94221f
C299 a_3855_36764# a_5831_36764# 0.03049f
C300 VDD x1.x2.R 5.54807f
C301 a_6088_308123# a_4886_309840# 0.00342f
C302 a_13869_282343# a_14837_285088# 0.00755f
C303 x2.x1.OUT PROG 4.16576f
C304 a_34961_250959# DISABLE 0.27896f
C305 a_23654_250994# GATE 0
C306 x11.schmitt_0.Y PWRENb 1.19905f
C307 a_15729_279867# a_15729_279559# 0.13302f
C308 a_15044_280595# x1.x3.R 0.35375f
C309 x1.OUT3 a_16905_279559# 0.01737f
C310 a_7634_278670# x1.x3.x2.VREF 0
C311 x4.VREF a_12835_309740# 0.05935f
C312 a_25120_282778# S1 0.05088f
C313 VDD a_7666_278098# 0.00196f
C314 CHRGb VDD 1.54688f
C315 RESET a_51049_278076# 0.31791f
C316 a_13869_282343# a_8363_282343# 0.00532f
C317 a_24723_308864# CTRLAMP 0.11441f
C318 x2.x3.PLUS VDD 1.43421f
C319 OPOUT a_4935_249949# 0.03935f
C320 LENb CEN 0.0883f
C321 x1.x1.R S0 0.52987f
C322 DISABLE CE 0.62631f
C323 a_13867_273711# x1.OUT2 0
C324 x1.S0N S1 2.96595f
C325 a_15044_280595# a_15729_279559# 0.03669f
C326 a_7586_279815# x1.x3.x2.VREF 0.44258f
C327 x1.x3.x1.OUT a_15729_279867# 0.01368f
C328 a_6088_308123# VDD 0.00404f
C329 a_25120_278234# REFOUT 0.1438f
C330 RESET a_47649_278076# 0.01783f
C331 a_14012_250994# VDD 1.30554f
C332 VDD S1 3.4871f
C333 a_20320_309740# CTRLAMP 1.60761f
C334 a_22478_250994# VDD 0.60505f
C335 a_14837_285088# a_16289_284488# 0.03516f
C336 PU CE 0.03298f
C337 OPOUT a_4887_251094# 0.13019f
C338 LATCH LENb 0.15066f
C339 REFOUT x1.EN1 0.09713f
C340 x1.OUT4 x1.x4.x2.VREF 0
C341 OPOUT a_20320_309740# 0.12437f
C342 a_7586_279815# a_7634_278670# 0.86805f
C343 a_8363_282343# a_12420_287622# 0
C344 VDD x1.x1.x2.VREF 2.60102f
C345 x1.x3.x1.OUT a_15044_280595# 1.03953f
C346 x2.x3.PLUS x2.x3.OUT 0.00332f
C347 RESET a_43001_277554# 0
C348 a_12836_250994# VDD 0.60505f
C349 a_25612_279510# REFOUT 0.01955f
C350 x2.MINUS PROG 0.30791f
C351 a_20320_309740# a_19144_310048# 0.14144f
C352 a_13869_282343# a_16245_283988# 0.86805f
C353 x1.OUT1 S1 0.06496f
C354 x1.OUT4 a_8361_274636# 0.02532f
C355 a_8790_286730# a_7636_287302# 0.0341f
C356 x1.x1.R a_7588_288447# 0.06981f
C357 a_17971_276456# VDD 0.00404f
C358 a_15729_279867# a_16905_279559# 0.14661f
C359 REFOUT S0 0.10825f
C360 x1.x2.x1.OUT a_8363_283268# 1.73099f
C361 x2.x3.PLUS a_22478_251302# 0.33888f
C362 a_22478_250994# x2.x3.OUT 0.00262f
C363 a_20320_309740# a_18459_310776# 0.07096f
C364 a_12836_251302# PROG 0.37836f
C365 PD VDD 16.0872f
C366 a_7634_278670# a_8788_278098# 0.0341f
C367 VDD RESET 3.54698f
C368 a_7586_279815# a_8363_282343# 0.00103f
C369 a_8790_286730# a_7588_288447# 0.00342f
C370 a_15044_280595# a_16905_279559# 0.07588f
C371 a_16287_275856# VDD 0.00134f
C372 a_33989_250071# CE 0.31791f
C373 VDD a_32580_277758# 7.34153f
C374 x1.x2.x1.OUT a_10655_284141# 0.04672f
C375 x2.x3.PLUS a_21793_252030# 0.06348f
C376 a_22478_250994# a_22478_251302# 0.13302f
C377 a_4934_308695# a_4966_308123# 0.33125f
C378 a_14012_250994# a_12151_252030# 0.1225f
C379 a_7586_279815# a_8788_278098# 0.00342f
C380 a_22508_281381# x1.OUT3 0.01814f
C381 VDD a_43777_278925# 0.51086f
C382 x8.schmitt_0.Y PWRENb 0.05212f
C383 DONEb PROG 0.42766f
C384 a_25120_285050# x1.EN1 0.48439f
C385 a_16245_283988# a_16289_284488# 0.49277f
C386 a_22462_290353# S0 0.0038f
C387 x1.x2.x1.OUT x1.x2.R 0.48832f
C388 a_14835_276456# VDD 0.01082f
C389 a_15731_288499# a_7588_288447# 0
C390 a_8361_273711# a_12418_278990# 0
C391 VDD a_31404_278437# 0.76341f
C392 VDD a_5831_36764# 2.38428f
C393 x1.OUT2 x1.x4.R 0
C394 a_54864_254859# GATE 0.27461f
C395 a_22478_250994# a_21793_252030# 0.03677f
C396 x1.x4.x1.OUT x1.OUT4 0.48947f
C397 PWRENb DONEb 15.0553f
C398 a_12835_310048# REFAMP 0.01368f
C399 a_12836_250994# a_12151_252030# 0.03677f
C400 a_4886_309840# a_4966_308123# 0.16355f
C401 a_6088_308123# a_7354_308607# 0.01245f
C402 VDD GATE 15.4853f
C403 DISABLE a_28942_249702# 1.68157f
C404 S1 a_25612_281782# 0.30749f
C405 a_16245_283988# a_14837_285088# 0.04671f
C406 a_15046_289227# a_7588_288447# 0.00532f
C407 HALFBAT a_32580_277758# 0.43368f
C408 a_8361_273711# VDD 6.26049f
C409 a_5090_282373# x1.OUT2 0.01986f
C410 a_25120_285050# S0 0.04822f
C411 x1.EN3 S0 0
C412 a_12150_310776# REFAMP 1.06355f
C413 a_16287_275856# x1.x3.R 0
C414 a_12835_310048# a_14011_309740# 0.14661f
C415 x1.OUT3 x1.EN2 0.00189f
C416 CHRGb CEN 0.00186f
C417 a_34961_250959# VDD 0.84856f
C418 a_23654_250994# a_28942_249702# 0.0053f
C419 x1.S0N x1.EN1 0.20095f
C420 a_25120_278234# VDD 0.27025f
C421 VDD BAT 3.22731f
C422 a_8790_286730# a_10056_287214# 0.01245f
C423 HALFBAT a_31404_278437# 0.01701f
C424 x8.schmitt_0.Y a_42971_278925# 0.26594f
C425 x1.OUT2 a_5044_277502# 0.00587f
C426 VDD x1.EN1 2.67645f
C427 a_4966_308123# VDD 0.00179f
C428 a_12835_310048# a_12835_309740# 0.13302f
C429 a_12150_310776# a_14011_309740# 0.07588f
C430 a_8363_282343# x1.OUT2 0.00141f
C431 x2.x3.OUT GATE 6.00622f
C432 VDD LEN 0.69282f
C433 a_25612_279510# VDD 0
C434 a_26682_270558# WM 0.01339f
C435 OPOUT WEH 0.07521f
C436 VDD CE 0.45163f
C437 a_7355_249861# VDD 0.00134f
C438 x1.S0N S0 3.45666f
C439 a_19144_309740# VDD 0.62232f
C440 x8.schmitt_0.Y x8.schmitt_0.A 0.34776f
C441 a_12150_310776# a_12835_309740# 0.03677f
C442 OPOUT CTRLAMP 0.0715f
C443 VDD S0 6.51932f
C444 x1.S1N x1.OUT2 0
C445 a_16289_284488# x1.x1.R 0
C446 x1.x3.x1.OUT a_16287_275856# 0.00661f
C447 x1.EN1 x1.OUT1 0.62718f
C448 a_25120_280506# x1.EN4 0.00438f
C449 a_53474_278076# CEN 0.0044f
C450 a_19144_310048# CTRLAMP 0.01363f
C451 x1.EN4 x1.OUT2 0.07007f
C452 x8.schmitt_0.Y a_40856_278332# 0.00767f
C453 a_10653_275509# x1.x4.x2.VREF 0.09306f
C454 a_25612_284054# S0 0.31791f
C455 OPOUT a_19144_310048# 0.33868f
C456 a_13869_282343# a_18665_284488# 0.16355f
C457 DONEb x6.B 0.36166f
C458 VDD a_7636_287302# 1.61497f
C459 a_21793_252030# GATE 0
C460 a_10429_273931# VDD 3.01552f
C461 a_15044_280595# a_15729_279867# 0.86973f
C462 x1.OUT1 S0 0.34394f
C463 a_53474_278076# LATCH 0.32051f
C464 a_9719_250269# VDD 0.01082f
C465 a_8790_286730# a_7668_286730# 0.01906f
C466 RESET CEN 0.0217f
C467 a_18459_310776# CTRLAMP 1.03953f
C468 a_16907_288191# x1.x1.R 0.21595f
C469 a_27936_308366# CTRLAMP 0.04417f
C470 a_10653_275509# a_8361_274636# 0.10299f
C471 a_28712_309737# VDD 0.56654f
C472 VDD REFAMP 7.18883f
C473 VDD x5.MINUS 0.75323f
C474 PU DONEb 0.20708f
C475 CHRGb LENb 0.10575f
C476 a_10655_284141# x1.x2.x2.VREF 0.09306f
C477 OPOUT a_18459_310776# 0.06093f
C478 x1.OUT3 S1 0.31974f
C479 VDD a_7588_288447# 10.7599f
C480 S0 x1.x3.R 0.01315f
C481 RESET LATCH 0.16133f
C482 a_4967_249377# VDD 0.00179f
C483 a_16907_288191# a_15731_288191# 0.10299f
C484 a_18459_310776# a_19144_310048# 0.86973f
C485 x11.schmitt_0.Y VDD 3.1516f
C486 WM x1.OUT2 0.07268f
C487 VDD a_14011_309740# 0.93857f
C488 x1.x2.x2.VREF x1.x2.R 0.31819f
C489 a_4966_308123# a_7354_308607# 0
C490 x2.x1.OUT VDD 16.782f
C491 VDD x2.x3.MINUS 0.84075f
C492 a_10655_284141# a_8363_283268# 0.10299f
C493 x1.x4.x1.OUT a_8361_274636# 1.73099f
C494 PWRENb a_42971_278925# 0.00475f
C495 a_13867_273711# VDD 10.6479f
C496 a_18665_284488# a_16289_284488# 0
C497 a_7355_249861# a_4935_249949# 0.49277f
C498 a_8361_273711# x1.OUT4 0.00232f
C499 a_16907_288191# a_15731_288499# 0.14661f
C500 GATE CEN 1.57436f
C501 a_6089_249377# VDD 0.00404f
C502 a_27906_309737# VDD 0.74406f
C503 a_25612_286326# S1 0
C504 a_8363_283268# x1.x2.R 0.26608f
C505 VDD a_12835_309740# 0.59713f
C506 a_13869_282343# a_17973_285088# 0.00342f
C507 a_14837_285088# a_15046_289227# 0
C508 x1.x4.x1.OUT a_10653_275509# 0.04672f
C509 PWRENb x8.schmitt_0.A 0.03277f
C510 a_16243_275356# VDD 1.46632f
C511 a_28942_249702# VDD 4.0514f
C512 a_53474_278076# LENb 0
C513 a_25120_278234# x1.OUT4 0.23031f
C514 a_34961_250959# CEN 0.0053f
C515 a_7355_249861# a_4887_251094# 0.00182f
C516 a_10054_278582# x1.x4.R 0
C517 a_16907_288191# a_15046_289227# 0.07588f
C518 x11.schmitt_0.A VDD 1.76087f
C519 a_19144_309740# a_20320_309740# 0.13955f
C520 a_10655_284141# x1.x2.R 0.26628f
C521 PWRENb x6.B 0.14057f
C522 a_10054_278582# a_7634_278670# 0.49277f
C523 PWRENb a_40856_278332# 0.01171f
C524 PD LENb 0.03384f
C525 PU PROG 71.2308f
C526 VDD a_10056_287214# 0.1206f
C527 x8.schmitt_0.Y a_47649_278076# 0
C528 a_13869_282343# a_10431_282563# 0
C529 RESET LENb 0
C530 REFOUT x1.S1N 0.06423f
C531 a_9719_250269# a_4935_249949# 0.04671f
C532 VDD a_13869_282343# 10.4712f
C533 LEN CEN 0.71384f
C534 CE CEN 0.14713f
C535 PU PWRENb 0.32816f
C536 a_47649_278076# DONEb 0.00272f
C537 a_25791_309144# VDD 1.29784f
C538 x1.EN2 S1 0.01619f
C539 a_22478_251302# x2.x3.MINUS 0.09876f
C540 x1.EN4 REFOUT 0.38452f
C541 x2.MINUS VDD 2.5941f
C542 x2.x1.OUT a_12151_252030# 2.52611f
C543 a_24723_308864# REFAMP 0.02805f
C544 x1.OUT4 S0 0
C545 a_10054_278582# a_7586_279815# 0.00182f
C546 a_12418_278990# x1.x3.x2.VREF 0.00957f
C547 a_28942_249702# x2.x3.OUT 1.49503f
C548 a_12835_310048# x4.VREF 0.33892f
C549 x8.schmitt_0.Y a_43001_277554# 0.32212f
C550 a_17973_285088# a_16289_284488# 0.01245f
C551 x10.MINUS a_12835_309740# 0.09345f
C552 a_4967_249377# a_4935_249949# 0.33125f
C553 a_9719_250269# a_4887_251094# 0.00755f
C554 a_21404_278263# VDD 0.0198f
C555 LATCH LEN 0.40287f
C556 REFOUT PWRENb 0.09385f
C557 x8.schmitt_0.A a_42971_278925# 0.13556f
C558 a_32580_277758# WEH 0
C559 a_21793_252030# x2.x3.MINUS 0.22438f
C560 VDD x1.x3.x2.VREF 2.60102f
C561 a_25120_280506# REFOUT 0.14002f
C562 a_12836_251302# VDD 2.91374f
C563 a_20320_309740# REFAMP 0.02158f
C564 a_12418_278990# a_7634_278670# 0.04671f
C565 REFOUT x1.OUT2 0.70503f
C566 VDD a_12420_287622# 0.02515f
C567 a_12150_310776# x4.VREF 0.06156f
C568 GATE LENb 0.44989f
C569 a_4967_249377# a_4887_251094# 0.16355f
C570 VDD x1.x4.R 4.98597f
C571 VDD x8.schmitt_0.Y 3.1146f
C572 a_16245_283988# a_18665_284488# 0.33125f
C573 a_10054_278582# a_8788_278098# 0.01245f
C574 a_6089_249377# a_4935_249949# 0.0341f
C575 a_40856_278332# a_42971_278925# 0.00245f
C576 VDD a_16289_284488# 0.00134f
C577 OPOUT a_32580_277758# 6.40013f
C578 a_14835_276456# x1.x4.x2.VREF 0.00957f
C579 a_13869_282343# x1.x3.R 0.05923f
C580 VDD a_7634_278670# 1.61492f
C581 a_28942_249702# a_21793_252030# 0.00122f
C582 a_12418_278990# a_7586_279815# 0.00755f
C583 VDD DONEb 1.52073f
C584 VDD a_7668_286730# 0.00196f
C585 a_4934_308695# x4.VREF 0
C586 VDD a_5090_282373# 0.06418f
C587 a_25120_285050# x1.S1N 0.06703f
C588 x1.EN3 x1.S1N 0
C589 a_25612_279510# x1.OUT3 0.00256f
C590 a_40856_278332# x8.schmitt_0.A 0.24126f
C591 a_6089_249377# a_4887_251094# 0.00342f
C592 VDD a_14837_285088# 0.01082f
C593 a_17971_276456# a_18663_275856# 0.01906f
C594 a_8361_273711# x1.x4.x2.VREF 0.07645f
C595 x2.MINUS a_12151_252030# 0.09485f
C596 a_14012_250994# x2.x3.PLUS 0.02155f
C597 VDD a_7586_279815# 10.7102f
C598 a_22478_250994# x2.x3.PLUS 0.05966f
C599 x1.EN4 x1.EN3 0.03606f
C600 a_15731_288191# x1.x1.R 0.26628f
C601 x1.OUT3 S0 0.07612f
C602 a_6148_277502# a_5044_277502# 0.00396f
C603 a_26682_270558# VDD 0.01517f
C604 a_4886_309840# x4.VREF 0.48095f
C605 VDD a_16907_288191# 1.02265f
C606 x1.OUT4 a_13867_273711# 0.30891f
C607 x1.x3.x2.VREF x1.x3.R 0.3182f
C608 LENb LEN 0.35054f
C609 LENb CE 0.08379f
C610 x1.EN1 a_25612_286326# 0.0044f
C611 a_10431_282563# a_8363_282343# 0.86973f
C612 a_14835_276456# a_15044_280595# 0
C613 a_25120_282778# x1.S1N 0.02109f
C614 a_47649_278076# PWRENb 0.31791f
C615 VDD a_8363_282343# 6.26809f
C616 a_8361_273711# a_8361_274636# 0.0757f
C617 a_16287_275856# a_18663_275856# 0
C618 a_12836_251302# a_12151_252030# 0.87704f
C619 x2.MINUS a_4935_249949# 0
C620 a_24723_308864# a_25791_309144# 0.1636f
C621 a_25120_280506# x1.EN3 0.48439f
C622 a_15731_288499# x1.x1.R 0.36057f
C623 x1.EN3 x1.OUT2 0.08837f
C624 x1.S0N x1.S1N 0.26334f
C625 a_23654_250994# DISABLE 0.03942f
C626 x1.x3.x2.VREF a_15729_279559# 0.09306f
C627 VDD a_8788_278098# 0.01014f
C628 a_16245_283988# a_17973_285088# 0.0341f
C629 x1.OUT1 a_16907_288191# 0.0179f
C630 a_28942_249702# CEN 0.00212f
C631 a_39788_278052# a_40856_278332# 0.1636f
C632 OPOUT BAT 0.60952f
C633 VDD x1.S1N 1.08745f
C634 CHRGb PD 0.20794f
C635 x1.x2.x1.OUT a_10056_287214# 0.00661f
C636 a_12836_250994# a_14012_250994# 0.19212f
C637 a_38304_271110# a_38304_270558# 0.01269f
C638 a_8361_273711# a_10653_275509# 0.03669f
C639 x2.MINUS a_4887_251094# 0.45182f
C640 REFOUT a_40856_278332# 0.0011f
C641 a_15046_289227# x1.x1.R 0.22319f
C642 a_15731_288499# a_15731_288191# 0.13302f
C643 a_22508_281381# S0 0
C644 VDD x4.VREF 2.97291f
C645 PU a_3855_36764# 0.3542f
C646 a_7586_279815# x1.x3.R 0.06981f
C647 x1.EN4 VDD 2.74204f
C648 VDD PROG 38.3275f
C649 a_25120_282778# x1.OUT2 0.2302f
C650 x1.EN2 x1.EN1 0.03606f
C651 a_25612_284054# x1.S1N 0.30837f
C652 a_19144_309740# OPOUT 0.05935f
C653 a_12836_251302# a_4887_251094# 0
C654 VDD PWRENb 7.93091f
C655 VDD a_16245_283988# 1.46643f
C656 REFOUT a_39788_278052# 0.07419f
C657 x1.S0N x1.OUT2 0.00406f
C658 PD S1 0.0606f
C659 a_22462_290353# x1.x1.R 0.0256f
C660 x1.S1N x1.OUT1 0.00656f
C661 a_15046_289227# a_15731_288191# 0.03669f
C662 x1.x4.x1.OUT a_8361_273711# 1.03953f
C663 a_6148_277502# x1.OUT2 0
C664 a_19144_309740# a_19144_310048# 0.13302f
C665 a_25120_280506# VDD 0.27009f
C666 DISABLE a_33989_250071# 0.00544f
C667 a_10429_273931# x1.x4.x2.VREF 0.09876f
C668 VDD x1.OUT2 9.98965f
C669 x1.EN2 S0 0.62607f
C670 a_22462_286211# S0 0
C671 a_51049_278076# x6.B 0.0044f
C672 a_15046_289227# a_15731_288499# 0.86973f
C673 CHRGb GATE 0.01785f
C674 a_19144_309740# a_18459_310776# 0.03677f
C675 x1.OUT4 x1.x4.R 1.65932f
C676 a_10429_273931# a_8361_274636# 0.14628f
C677 REFAMP CTRLAMP 0.27121f
C678 VDD WM 1.08127f
C679 x4.VREF x10.MINUS 0.40181f
C680 a_34961_250959# CHRGb 0.37659f
C681 a_16287_275856# a_17971_276456# 0.01245f
C682 a_47649_278076# x6.B 0.30358f
C683 OPOUT REFAMP 0.46938f
C684 OPOUT x5.MINUS 0.45879f
C685 a_43001_277554# x8.schmitt_0.A 0.21732f
C686 DONEb CEN 1.82419f
C687 a_12150_310776# a_12835_310048# 0.86973f
C688 x1.x1.x1.OUT a_16289_284488# 0.00661f
C689 a_12151_252030# PROG 0.31768f
C690 VDD a_42971_278925# 0.67823f
C691 x11.schmitt_0.Y CTRLAMP 0
C692 a_5044_273700# x1.x4.R 0.02053f
C693 a_10429_273931# a_10653_275509# 0.13302f
C694 a_13867_273711# x1.x4.x2.VREF 0.44258f
C695 REFAMP a_19144_310048# 0.04138f
C696 a_19144_310048# x5.MINUS 0.09876f
C697 OPOUT a_4967_249377# 0.05193f
C698 x8.schmitt_0.Y LATCH 0
C699 OPOUT a_14011_309740# 0.00891f
C700 a_43001_277554# a_40856_278332# 0.00302f
C701 CHRGb CE 1.50792f
C702 LATCH DONEb 0.37464f
C703 x1.x2.x1.OUT a_8363_282343# 1.03953f
C704 a_25120_285050# REFOUT 0.07844f
C705 a_43777_278925# RESET 0
C706 HALFBAT WM 0.54961f
C707 x1.EN3 REFOUT 0.51715f
C708 VDD x8.schmitt_0.A 1.48799f
C709 REFAMP a_18459_310776# 0.12536f
C710 a_16243_275356# x1.x4.x2.VREF 0
C711 a_18459_310776# x5.MINUS 0.65028f
C712 a_6088_308123# a_4966_308123# 0.01906f
C713 PD a_5831_36764# 0.61973f
C714 VDD x1.x1.R 5.20001f
C715 x1.EN1 S1 0.00829f
C716 x1.x1.x1.OUT a_16907_288191# 1.73099f
C717 a_14835_276456# a_16287_275856# 0.03516f
C718 OPOUT a_6089_249377# 0.00357f
C719 x1.x4.x1.OUT a_10429_273931# 0.01363f
C720 a_31404_278437# a_32580_277758# 0.25239f
C721 VDD x6.B 2.39969f
C722 DISABLE VDD 5.54993f
C723 a_25612_279510# S1 0.31791f
C724 a_4887_251094# PROG 0.08501f
C725 a_4886_309840# a_12835_310048# 0
C726 VDD a_40856_278332# 1.26333f
C727 a_27936_308366# x11.schmitt_0.Y 0.32212f
C728 x11.schmitt_0.A CTRLAMP 0.0097f
C729 a_18459_310776# a_14011_309740# 0.00135f
C730 VDD a_8790_286730# 0.01016f
C731 a_25120_282778# REFOUT 0.12684f
C732 VDD a_15731_288191# 0.58667f
C733 m2_148463_0# GATE 0.14843f
C734 S0 S1 18.5414f
C735 x1.OUT1 x1.x1.R 0.5147f
C736 PU VDD 33.6258f
C737 a_9718_309015# x4.VREF 0.00957f
C738 a_23654_250994# VDD 1.30554f
C739 REFOUT x1.S0N 0.06117f
C740 a_4886_309840# a_12150_310776# 0.03551f
C741 x1.EN4 x1.OUT4 0.30219f
C742 a_17973_285088# a_18665_284488# 0.01906f
C743 VDD a_39788_278052# 0.58189f
C744 VDD a_3855_36764# 1.20326f
C745 a_53474_278076# LEN 0.31791f
C746 a_13869_282343# x1.x2.x2.VREF 0.44258f
C747 a_25791_309144# CTRLAMP 0.02636f
C748 a_13867_273711# a_18663_275856# 0.16355f
C749 VDD a_15731_288499# 2.91371f
C750 VDD REFOUT 7.62116f
C751 DISABLE x2.x3.OUT 1.87068f
C752 m2_148463_0# BAT 0.17749f
C753 DONEb LENb 0.09739f
C754 PWRENb CEN 0.08769f
C755 x1.x2.x1.OUT x1.OUT2 0.48835f
C756 a_12835_310048# VDD 2.90951f
C757 a_4886_309840# a_4934_308695# 0.86805f
C758 PD CE 0.03384f
C759 a_15044_280595# a_13869_282343# 0.00103f
C760 a_27936_308366# x11.schmitt_0.A 0.21732f
C761 a_16243_275356# a_18663_275856# 0.33125f
C762 x1.OUT4 x1.OUT2 11.1522f
C763 a_25612_284054# REFOUT 0.01955f
C764 VDD a_15046_289227# 6.20843f
C765 x1.x1.x2.VREF a_7636_287302# 0
C766 x1.x4.x2.VREF x1.x4.R 0.31874f
C767 VDD a_18665_284488# 0.0216f
C768 x2.x3.PLUS x2.x1.OUT 0.05086f
C769 x2.x3.PLUS x2.x3.MINUS 0.59495f
C770 a_23654_250994# x2.x3.OUT 3.4497f
C771 a_15729_279867# x1.x3.x2.VREF 0.09876f
C772 REFOUT x1.OUT1 0.56566f
C773 LATCH PWRENb 1.22655f
C774 a_12150_310776# VDD 6.22184f
C775 a_34961_250959# GATE 0.03385f
C776 a_12418_278990# a_10054_278582# 0.03516f
C777 VDD a_33989_250071# 0.00983f
C778 PD VSS 69.75644f
C779 PU VSS 43.31757f
C780 CHRGb VSS 43.2264f
C781 CE VSS 30.6302f
C782 PROG VSS 0.227p
C783 LENb VSS 38.7864f
C784 DONEb VSS 71.6257f
C785 BAT VSS 72.6679f
C786 S1 VSS 38.7289f
C787 S0 VSS 25.1935f
C788 PWRENb VSS 0.12096p
C789 GATE VSS 69.0566f
C790 VDD VSS 1.2949p
C791 m2_148463_0# VSS 0.12381p ; **FLOATING
C792 a_5831_36764# VSS 1.70182f
C793 a_3855_36764# VSS 2.45916f
C794 a_33989_250071# VSS 0.24039f
C795 a_6089_249377# VSS 2.02972f
C796 a_7355_249861# VSS 2.60738f
C797 a_9719_250269# VSS 2.367f
C798 a_4967_249377# VSS 1.5478f
C799 a_34961_250959# VSS 0.95782f
C800 a_28942_249702# VSS 4.53907f
C801 DISABLE VSS 6.94382f
C802 a_23654_250994# VSS 7.97756f
C803 x2.x3.PLUS VSS 4.40226f
C804 a_22478_250994# VSS 1.94124f
C805 x2.x3.MINUS VSS 2.72197f
C806 x2.x3.OUT VSS 6.78719f
C807 a_22478_251302# VSS 0.06648f
C808 a_21793_252030# VSS 1.18083f
C809 a_54864_254859# VSS 0.60354f
C810 a_14012_250994# VSS 8.00615f
C811 a_12836_250994# VSS 1.94051f
C812 x2.MINUS VSS 1.19075f
C813 a_12836_251302# VSS 0.02275f
C814 a_12151_252030# VSS 1.34919f
C815 a_4935_249949# VSS 3.21535f
C816 a_4887_251094# VSS 1.56955f
C817 x2.x1.OUT VSS 5.28554f
C818 a_54864_264981# VSS 0.98524f
C819 a_54864_275577# VSS 0.98524f
C820 a_53474_278076# VSS 0.21995f
C821 a_51049_278076# VSS 0.21995f
C822 a_47649_278076# VSS 0.24047f
C823 a_43001_277554# VSS 1.1578f
C824 a_38304_270558# VSS 2.62914f
C825 a_26682_270558# VSS 0.96418f
C826 a_38304_271110# VSS 0.95175f
C827 a_10429_273931# VSS 0.12871f
C828 a_13867_273711# VSS 1.46233f
C829 a_16243_275356# VSS 3.24903f
C830 x1.x4.x2.VREF VSS 1.06883f
C831 a_8361_274636# VSS 3.04702f
C832 a_10653_275509# VSS 2.04529f
C833 a_18663_275856# VSS 1.5988f
C834 a_17971_276456# VSS 2.03452f
C835 a_16287_275856# VSS 2.60075f
C836 a_14835_276456# VSS 2.35711f
C837 a_8361_273711# VSS 1.00392f
C838 CEN VSS 16.5302f
C839 LEN VSS 1.22959f
C840 x6.B VSS 2.27623f
C841 LATCH VSS 4.64385f
C842 RESET VSS 6.42648f
C843 a_43777_278925# VSS 0.17031f
C844 x8.schmitt_0.Y VSS 3.28872f
C845 x8.schmitt_0.A VSS 1.58552f
C846 a_40856_278332# VSS 1.43666f
C847 a_39788_278052# VSS 1.88248f
C848 WEH VSS 2.39368f
C849 a_32580_277758# VSS 7.99599f
C850 a_31404_278437# VSS 2.80255f
C851 WM VSS 6.71823f
C852 HALFBAT VSS 3.12438f
C853 a_25120_278234# VSS 1.04445f
C854 a_25612_279510# VSS 0.21995f
C855 x1.EN4 VSS 1.27071f
C856 a_25120_280506# VSS 0.88156f
C857 a_22508_278263# VSS 0.86882f
C858 a_21404_278263# VSS 0.92489f
C859 a_6148_277502# VSS 0.88138f
C860 x1.OUT4 VSS 6.31545f
C861 a_5044_273700# VSS 0.83659f
C862 x1.x4.R VSS 2.83069f
C863 a_5044_277502# VSS 0.86129f
C864 a_8788_278098# VSS 2.03452f
C865 a_10054_278582# VSS 2.65763f
C866 a_12418_278990# VSS 2.45179f
C867 a_7666_278098# VSS 1.59988f
C868 a_16905_279559# VSS 2.98607f
C869 x1.x3.R VSS 2.85206f
C870 a_15729_279559# VSS 1.89175f
C871 a_25612_281782# VSS 0.21995f
C872 x1.OUT3 VSS 4.98532f
C873 a_22508_281381# VSS 0.85528f
C874 a_15729_279867# VSS 0.01323f
C875 a_15044_280595# VSS 0.92629f
C876 x1.x3.x2.VREF VSS 1.05097f
C877 a_7634_278670# VSS 3.31954f
C878 a_7586_279815# VSS 1.7377f
C879 x1.EN3 VSS 1.21032f
C880 a_25120_282778# VSS 0.93646f
C881 a_10431_282563# VSS 0.12921f
C882 a_25612_284054# VSS 0.21995f
C883 x1.EN2 VSS 1.21271f
C884 a_13869_282343# VSS 1.55709f
C885 a_16245_283988# VSS 3.24901f
C886 x1.x2.x2.VREF VSS 1.06955f
C887 a_8363_283268# VSS 3.00789f
C888 a_10655_284141# VSS 2.04528f
C889 REFOUT VSS 13.9185f
C890 a_18665_284488# VSS 1.59882f
C891 a_25120_285050# VSS 0.92746f
C892 a_17973_285088# VSS 2.03452f
C893 a_16289_284488# VSS 2.60075f
C894 a_14837_285088# VSS 2.35711f
C895 a_8363_282343# VSS 1.00153f
C896 a_25612_286326# VSS 0.21995f
C897 x1.EN1 VSS 1.24778f
C898 x1.S1N VSS 4.01522f
C899 x1.S0N VSS 4.28051f
C900 a_22462_286211# VSS 0.86913f
C901 a_22462_290353# VSS 0.83251f
C902 a_21358_286211# VSS 0.91081f
C903 a_6194_285737# VSS 0.94015f
C904 x1.OUT2 VSS 12.7196f
C905 a_5090_282373# VSS 0.83415f
C906 x1.x2.R VSS 2.81008f
C907 a_5090_285737# VSS 0.86129f
C908 a_8790_286730# VSS 2.03452f
C909 x1.OUT1 VSS 6.19582f
C910 a_10056_287214# VSS 2.65802f
C911 a_12420_287622# VSS 2.4515f
C912 a_7668_286730# VSS 1.59988f
C913 a_16907_288191# VSS 3.02608f
C914 x1.x1.R VSS 3.39636f
C915 a_15731_288191# VSS 1.89175f
C916 a_15731_288499# VSS 0.01323f
C917 a_15046_289227# VSS 0.92861f
C918 x1.x1.x2.VREF VSS 1.05055f
C919 a_7636_287302# VSS 3.32003f
C920 a_7588_288447# VSS 1.75499f
C921 a_27936_308366# VSS 1.09286f
C922 a_6088_308123# VSS 2.03893f
C923 a_7354_308607# VSS 2.60848f
C924 a_9718_309015# VSS 2.36452f
C925 a_4966_308123# VSS 1.5992f
C926 a_28712_309737# VSS 0.21048f
C927 x11.schmitt_0.Y VSS 3.24438f
C928 x11.schmitt_0.A VSS 1.60046f
C929 a_25791_309144# VSS 1.40909f
C930 a_24723_308864# VSS 1.90302f
C931 a_20320_309740# VSS 3.17899f
C932 OPOUT VSS 58.6024f
C933 a_19144_309740# VSS 1.92376f
C934 x5.MINUS VSS 1.82958f
C935 a_14011_309740# VSS 3.22325f
C936 a_12835_309740# VSS 1.92139f
C937 x10.MINUS VSS 2.16813f
C938 x4.VREF VSS 1.10638f
C939 CTRLAMP VSS 7.23212f
C940 a_19144_310048# VSS 0.01533f
C941 a_18459_310776# VSS 0.80248f
C942 REFAMP VSS 5.98168f
C943 a_12835_310048# VSS 0.05053f
C944 a_12150_310776# VSS 0.82339f
C945 a_4934_308695# VSS 3.21535f
C946 a_4886_309840# VSS 1.5293f
C947 x1.x4.x1.OUT VSS 7.63211f
C948 x1.x3.x1.OUT VSS 7.57686f
C949 x1.x2.x1.OUT VSS 7.59842f
C950 x1.x1.x1.OUT VSS 7.62883f
C951 VDD.t131 VSS 0.07145f
C952 VDD.n0 VSS 0.14664f
C953 VDD.n1 VSS 0.02212f
C954 VDD.t136 VSS 0.57726f
C955 VDD.t6 VSS 7.63165f
C956 VDD.t93 VSS 25.3775f
C957 VDD.n3 VSS 0.14637f
C958 VDD.n4 VSS 0.53261f
C959 VDD.t95 VSS 2.65368f
C960 VDD.n5 VSS 0.10632f
C961 VDD.n7 VSS 0.37208f
C962 VDD.t116 VSS 0.06007f
C963 VDD.n8 VSS 0.03936f
C964 VDD.n9 VSS 0.02143f
C965 VDD.n10 VSS 0.0285f
C966 VDD.t209 VSS 0.06007f
C967 VDD.n11 VSS 9.20657f
C968 VDD.n12 VSS 0.55829f
C969 VDD.n13 VSS 0.02321f
C970 VDD.n14 VSS 0.12924f
C971 VDD.n15 VSS 7.6639f
C972 VDD.n16 VSS 0.02143f
C973 VDD.n17 VSS 0.31242f
C974 VDD.n18 VSS 0.24384f
C975 VDD.t53 VSS 2.11774f
C976 VDD.t97 VSS 0.07531f
C977 VDD.n19 VSS 0.13755f
C978 VDD.n20 VSS 0.04589f
C979 VDD.t94 VSS 0.07531f
C980 VDD.t66 VSS 0.06196f
C981 VDD.n22 VSS 0.04339f
C982 VDD.t68 VSS 0.06007f
C983 VDD.n23 VSS 0.1692f
C984 VDD.n24 VSS 0.34489f
C985 VDD.n25 VSS 1.55414f
C986 VDD.n26 VSS 0.04255f
C987 VDD.n27 VSS 0.01437f
C988 VDD.n28 VSS 0.71353f
C989 VDD.n29 VSS 0.07316f
C990 VDD.t77 VSS 0.06007f
C991 VDD.n30 VSS 0.11252f
C992 VDD.t61 VSS 7.11608f
C993 VDD.n31 VSS 0.08654f
C994 VDD.n32 VSS 0.01134f
C995 VDD.n33 VSS 0.23655f
C996 VDD.n34 VSS 4.42992f
C997 VDD.n35 VSS 0.06236f
C998 VDD.n36 VSS 0.0645f
C999 VDD.n37 VSS 0.03073f
C1000 VDD.n38 VSS 16.429f
C1001 VDD.n39 VSS 0.07378f
C1002 VDD.n40 VSS 0.00699f
C1003 VDD.n41 VSS 0.18907f
C1004 VDD.t89 VSS 0.06007f
C1005 VDD.n42 VSS 0.04589f
C1006 VDD.n43 VSS 4.02951f
C1007 VDD.t49 VSS 0.07531f
C1008 VDD.t51 VSS 0.07531f
C1009 VDD.n44 VSS 0.10882f
C1010 VDD.t47 VSS 18.967f
C1011 VDD.n45 VSS 0.4668f
C1012 VDD.n46 VSS 0.13829f
C1013 VDD.n47 VSS 0.09204f
C1014 VDD.t70 VSS 0.06007f
C1015 VDD.n48 VSS 0.07531f
C1016 VDD.t16 VSS 0.06007f
C1017 VDD.n49 VSS 0.09676f
C1018 VDD.n50 VSS 13.4689f
C1019 VDD.n51 VSS 0.15339f
C1020 VDD.n52 VSS 0.07445f
C1021 VDD.n53 VSS 0.03926f
C1022 VDD.n54 VSS 0.17191f
C1023 VDD.n55 VSS 0.0435f
C1024 VDD.n56 VSS 0.03736f
C1025 VDD.t92 VSS 0.13997f
C1026 VDD.n57 VSS 0.03755f
C1027 VDD.n59 VSS 0.49264f
C1028 VDD.n60 VSS 0.06721f
C1029 VDD.n61 VSS 0.07298f
C1030 VDD.n62 VSS 0.44138f
C1031 VDD.n63 VSS 0.04589f
C1032 VDD.n64 VSS 0.06708f
C1033 VDD.n65 VSS 0.05217f
C1034 VDD.n66 VSS 17.1538f
C1035 VDD.n67 VSS 0.03415f
C1036 VDD.t101 VSS 0.03142f
C1037 VDD.n68 VSS 0.06695f
C1038 VDD.n69 VSS 0.10325f
C1039 VDD.n70 VSS 0.16167f
C1040 VDD.n71 VSS 0.03065f
C1041 VDD.n72 VSS 0.06236f
C1042 VDD.n73 VSS 0.3042f
C1043 VDD.n74 VSS 0.99961f
C1044 VDD.n75 VSS 0.4785f
C1045 VDD.t52 VSS 0.77387f
C1046 VDD.t99 VSS 0.82779f
C1047 VDD.t0 VSS 0.77387f
C1048 VDD.n76 VSS 0.04558f
C1049 VDD.t126 VSS 0.82779f
C1050 VDD.t3 VSS 5.80553f
C1051 VDD.n77 VSS 0.04013f
C1052 VDD.n78 VSS 0.05398f
C1053 VDD.n79 VSS 0.00442f
C1054 VDD.n80 VSS 0.03584f
C1055 VDD.n81 VSS 0.05354f
C1056 VDD.n82 VSS 0.00442f
C1057 VDD.n83 VSS 0.03584f
C1058 VDD.n84 VSS 0.05213f
C1059 VDD.n85 VSS 0.03358f
C1060 VDD.n86 VSS 0.05217f
C1061 VDD.t177 VSS 1.30504f
C1062 VDD.t193 VSS 2.2728f
C1063 VDD.n87 VSS 0.02784f
C1064 VDD.n88 VSS 0.0232f
C1065 VDD.n89 VSS 0.04236f
C1066 VDD.n90 VSS 0.04183f
C1067 VDD.n91 VSS 0.06236f
C1068 VDD.n92 VSS 0.0232f
C1069 VDD.n93 VSS 0.04236f
C1070 VDD.n94 VSS 0.04183f
C1071 VDD.n95 VSS 0.0232f
C1072 VDD.n96 VSS 0.0232f
C1073 VDD.n97 VSS 0.03546f
C1074 VDD.t34 VSS 0.3785f
C1075 VDD.t15 VSS 0.6732f
C1076 VDD.n98 VSS 0.0808f
C1077 VDD.t60 VSS 1.08918f
C1078 VDD.n99 VSS 0.09204f
C1079 VDD.t69 VSS 2.18206f
C1080 VDD.n100 VSS 0.75344f
C1081 VDD.n101 VSS 3.84212f
C1082 VDD.t56 VSS 2.30274f
C1083 VDD.t54 VSS 2.36864f
C1084 VDD.t96 VSS 2.36864f
C1085 VDD.t85 VSS 1.40954f
C1086 VDD.t50 VSS 2.16088f
C1087 VDD.n102 VSS 0.10882f
C1088 VDD.t46 VSS 2.36864f
C1089 VDD.t159 VSS 2.30274f
C1090 VDD.t163 VSS 2.36864f
C1091 VDD.n103 VSS 0.10882f
C1092 VDD.t109 VSS 2.36864f
C1093 VDD.n104 VSS 0.10882f
C1094 VDD.t105 VSS 2.16088f
C1095 VDD.n105 VSS 0.55172f
C1096 VDD.n106 VSS 6.68827f
C1097 VDD.n107 VSS 0.27448f
C1098 VDD.n108 VSS 0.54526f
C1099 VDD.n109 VSS 0.09743f
C1100 VDD.n110 VSS 0.08115f
C1101 VDD.t165 VSS 1.31371f
C1102 VDD.n111 VSS 0.28494f
C1103 VDD.n112 VSS 0.08115f
C1104 VDD.n113 VSS 0.09089f
C1105 VDD.n114 VSS 0.11629f
C1106 VDD.n115 VSS 0.033f
C1107 VDD.n116 VSS 0.03768f
C1108 VDD.n117 VSS 0.20762f
C1109 VDD.t167 VSS 0.62582f
C1110 VDD.n118 VSS 0.13417f
C1111 VDD.n119 VSS 0.08054f
C1112 VDD.n120 VSS 0.137f
C1113 VDD.t168 VSS 0.64946f
C1114 VDD.n121 VSS 0.0376f
C1115 VDD.n122 VSS 0.46158f
C1116 VDD.t170 VSS 0.64462f
C1117 VDD.n123 VSS 0.03844f
C1118 VDD.n124 VSS 0.11117f
C1119 VDD.n125 VSS 0.07316f
C1120 VDD.t112 VSS 0.36569f
C1121 VDD.n126 VSS 0.03373f
C1122 VDD.n127 VSS 0.2162f
C1123 VDD.n128 VSS 0.07847f
C1124 VDD.t157 VSS 0.83868f
C1125 VDD.n129 VSS 0.04646f
C1126 VDD.n130 VSS 0.08054f
C1127 VDD.n131 VSS 0.07378f
C1128 VDD.n132 VSS 0.13417f
C1129 VDD.n133 VSS 0.11117f
C1130 VDD.n134 VSS 0.033f
C1131 VDD.n135 VSS 0.55387f
C1132 VDD.t113 VSS 0.62582f
C1133 VDD.n136 VSS 0.07316f
C1134 VDD.t115 VSS 0.23437f
C1135 VDD.t13 VSS 0.02335f
C1136 VDD.n137 VSS 0.04699f
C1137 VDD.n138 VSS 0.03329f
C1138 VDD.n139 VSS 0.31242f
C1139 VDD.n140 VSS 0.03329f
C1140 VDD.n141 VSS 0.02524f
C1141 VDD.n142 VSS 0.0435f
C1142 VDD.n143 VSS 0.02982f
C1143 VDD.n144 VSS 0.06706f
C1144 VDD.n145 VSS 0.05312f
C1145 VDD.n146 VSS 0.04255f
C1146 VDD.t210 VSS 0.1663f
C1147 VDD.t208 VSS 0.30867f
C1148 VDD.t211 VSS 0.16753f
C1149 VDD.t213 VSS 0.02537f
C1150 VDD.t212 VSS 0.28756f
C1151 VDD.n147 VSS 0.25286f
C1152 VDD.t100 VSS 0.30128f
C1153 VDD.t102 VSS 0.30128f
C1154 VDD.n148 VSS 0.01546f
C1155 VDD.n149 VSS 0.20085f
C1156 VDD.t206 VSS 0.20085f
C1157 VDD.n150 VSS 0.21206f
C1158 VDD.t207 VSS 0.03359f
C1159 VDD.n151 VSS 0.05117f
C1160 VDD.n152 VSS 0.04779f
C1161 VDD.n153 VSS 0.06074f
C1162 VDD.n154 VSS 0.03329f
C1163 VDD.t127 VSS 0.02335f
C1164 VDD.t1 VSS 0.02335f
C1165 VDD.n155 VSS 0.05544f
C1166 VDD.n156 VSS 0.03329f
C1167 VDD.n157 VSS 0.02143f
C1168 VDD.n158 VSS 0.04198f
C1169 VDD.n159 VSS 0.0383f
C1170 VDD.n160 VSS 0.02964f
C1171 VDD.n161 VSS 0.0285f
C1172 VDD.t12 VSS 0.59806f
C1173 VDD.n162 VSS 4.56429f
C1174 VDD.n163 VSS 0.89012f
C1175 VDD.t80 VSS 0.00778f
C1176 VDD.t142 VSS 0.00762f
C1177 VDD.n164 VSS 0.03404f
C1178 VDD.t41 VSS 0.01559f
C1179 VDD.n165 VSS 0.01024f
C1180 VDD.t21 VSS 0.01524f
C1181 VDD.n166 VSS 0.99976f
C1182 VDD.n167 VSS 0.65185f
C1183 VDD.n168 VSS 0.35945f
C1184 VDD.t84 VSS 0.01524f
C1185 VDD.n169 VSS 1.25034f
C1186 VDD.t146 VSS 0.12014f
C1187 VDD.n170 VSS 0.55994f
C1188 VDD.n171 VSS 0.08357f
C1189 VDD.n172 VSS 0.12519f
C1190 VDD.n173 VSS 0.04718f
C1191 VDD.t145 VSS 1.30645f
C1192 VDD.n174 VSS 0.04646f
C1193 VDD.n175 VSS 0.07415f
C1194 VDD.t149 VSS 0.06007f
C1195 VDD.t150 VSS 0.03048f
C1196 VDD.t245 VSS 0.0227f
C1197 VDD.t247 VSS 0.00634f
C1198 VDD.t249 VSS 0.0227f
C1199 VDD.t251 VSS 0.00634f
C1200 VDD.t253 VSS 0.0227f
C1201 VDD.t255 VSS 0.00634f
C1202 VDD.t257 VSS 0.0227f
C1203 VDD.t259 VSS 0.00634f
C1204 VDD.n176 VSS 0.17965f
C1205 VDD.n177 VSS 0.43047f
C1206 VDD.n178 VSS 0.15124f
C1207 VDD.n179 VSS 0.48172f
C1208 VDD.n180 VSS 0.07378f
C1209 VDD.t151 VSS 0.10247f
C1210 VDD.n181 VSS 0.13245f
C1211 VDD.t147 VSS 0.38425f
C1212 VDD.n182 VSS 0.69165f
C1213 VDD.n183 VSS 0.07316f
C1214 VDD.n184 VSS 0.04407f
C1215 VDD.n185 VSS 0.11127f
C1216 VDD.t154 VSS 0.12014f
C1217 VDD.n186 VSS 0.04181f
C1218 VDD.n187 VSS 0.06224f
C1219 VDD.n188 VSS 0.05468f
C1220 VDD.n189 VSS 0.10048f
C1221 VDD.n190 VSS 0.04961f
C1222 VDD.n191 VSS 0.03473f
C1223 VDD.n192 VSS 0.10048f
C1224 VDD.t11 VSS 0.01557f
C1225 VDD.n193 VSS 0.03597f
C1226 VDD.t8 VSS 0.20595f
C1227 VDD.n194 VSS 0.02983f
C1228 VDD.n195 VSS 0.02159f
C1229 VDD.n196 VSS 0.13962f
C1230 VDD.t5 VSS 0.13962f
C1231 VDD.n197 VSS 0.15384f
C1232 VDD.n198 VSS 0.0292f
C1233 VDD.n200 VSS 0.04323f
C1234 VDD.n201 VSS 0.03736f
C1235 VDD.t117 VSS 0.13962f
C1236 VDD.n202 VSS 0.07037f
C1237 VDD.n203 VSS 0.06113f
C1238 VDD.n204 VSS 0.09005f
C1239 VDD.n205 VSS 0.36462f
C1240 VDD.n206 VSS 0.04181f
C1241 VDD.n207 VSS 0.0452f
C1242 VDD.n208 VSS 0.02613f
C1243 VDD.n209 VSS 0.05152f
C1244 VDD.n210 VSS 0.14195f
C1245 VDD.n211 VSS 0.0435f
C1246 VDD.n212 VSS 0.05134f
C1247 VDD.n213 VSS 0.03736f
C1248 VDD.t130 VSS 0.13962f
C1249 VDD.n214 VSS 0.54839f
C1250 VDD.n215 VSS 0.38228f
C1251 VDD.n216 VSS 0.48231f
C1252 VDD.t133 VSS 0.20085f
C1253 VDD.n217 VSS 0.0435f
C1254 VDD.n218 VSS 0.04255f
C1255 VDD.n219 VSS 0.06526f
C1256 VDD.n220 VSS 0.07717f
C1257 VDD.t134 VSS 0.102f
C1258 VDD.n221 VSS 0.01024f
C1259 VDD.n222 VSS 0.02964f
C1260 VDD.n223 VSS 0.06706f
C1261 VDD.n224 VSS 0.05312f
C1262 VDD.n225 VSS 0.04699f
C1263 VDD.n226 VSS 0.01546f
C1264 VDD.n227 VSS 0.20085f
C1265 VDD.t191 VSS 0.30128f
C1266 VDD.t190 VSS 0.30128f
C1267 VDD.n228 VSS 0.0285f
C1268 VDD.n229 VSS 0.03329f
C1269 VDD.n230 VSS 0.0383f
C1270 VDD.n231 VSS 0.03329f
C1271 VDD.n232 VSS 0.03329f
C1272 VDD.n233 VSS 0.02143f
C1273 VDD.n234 VSS 0.04181f
C1274 VDD.n235 VSS 0.0576f
C1275 VDD.n236 VSS 0.04558f
C1276 VDD.n237 VSS 0.03329f
C1277 VDD.n238 VSS 0.0285f
C1278 VDD.t192 VSS 0.59806f
C1279 VDD.n239 VSS 0.05577f
C1280 VDD.n240 VSS 0.03936f
C1281 VDD.n241 VSS 0.21206f
C1282 VDD.t138 VSS 0.28281f
C1283 VDD.n242 VSS 0.25286f
C1284 VDD.t137 VSS 0.1663f
C1285 VDD.t135 VSS 0.3076f
C1286 VDD.t156 VSS 0.30061f
C1287 VDD.n243 VSS 0.14664f
C1288 VDD.t155 VSS 0.13997f
C1289 VDD.n244 VSS 0.13962f
C1290 VDD.n245 VSS 0.01546f
C1291 VDD.n246 VSS 0.01024f
C1292 VDD.n247 VSS 0.04076f
C1293 VDD.n248 VSS 0.04181f
C1294 VDD.t90 VSS 0.66639f
C1295 VDD.n249 VSS 0.02495f
C1296 VDD.n250 VSS 0.13962f
C1297 VDD.t91 VSS 0.13997f
C1298 VDD.t22 VSS 17.1853f
C1299 VDD.n251 VSS 5.49875f
C1300 VDD.n252 VSS 15.197f
C1301 VDD.n253 VSS 0.03768f
C1302 VDD.t183 VSS 0.12014f
C1303 VDD.n254 VSS 0.60338f
C1304 VDD.t180 VSS 0.12014f
C1305 VDD.t181 VSS 0.30847f
C1306 VDD.t182 VSS 0.05075f
C1307 VDD.n255 VSS 0.70727f
C1308 VDD.n256 VSS 0.51605f
C1309 VDD.n257 VSS 0.00769f
C1310 VDD.t179 VSS 3.82146f
C1311 VDD.t178 VSS 0.03113f
C1312 VDD.t194 VSS 0.03113f
C1313 VDD.n258 VSS 0.08274f
C1314 VDD.n259 VSS 0.03768f
C1315 VDD.n260 VSS 0.04654f
C1316 VDD.n261 VSS 0.04341f
C1317 VDD.n262 VSS 0.04345f
C1318 VDD.t119 VSS 0.01557f
C1319 VDD.t35 VSS 0.00778f
C1320 VDD.n263 VSS 0.02287f
C1321 VDD.n264 VSS 0.05164f
C1322 VDD.n265 VSS 0.05164f
C1323 VDD.n266 VSS 0.01737f
C1324 VDD.n267 VSS 0.09758f
C1325 VDD.n268 VSS 0.02271f
C1326 VDD.n269 VSS 0.10507f
C1327 VDD.t118 VSS 0.13962f
C1328 VDD.n270 VSS 0.14664f
C1329 VDD.t10 VSS 0.13997f
C1330 VDD.n271 VSS 0.13962f
C1331 VDD.n272 VSS 0.01749f
C1332 VDD.t71 VSS 0.18766f
C1333 VDD.t72 VSS 0.02537f
C1334 VDD.n273 VSS 0.27249f
C1335 VDD.t73 VSS 0.06007f
C1336 VDD.n274 VSS 0.12288f
C1337 VDD.n275 VSS 0.04342f
C1338 VDD.t38 VSS 1.63025f
C1339 VDD.t36 VSS 0.27328f
C1340 VDD.n276 VSS 0.69553f
C1341 VDD.n277 VSS 0.05164f
C1342 VDD.n278 VSS 0.05999f
C1343 VDD.n279 VSS 0.07453f
C1344 VDD.n280 VSS 0.2088f
C1345 VDD.t37 VSS 0.03048f
C1346 VDD.n281 VSS 0.12704f
C1347 VDD.n282 VSS 0.04626f
C1348 VDD.n283 VSS 0.64042f
C1349 VDD.t98 VSS 0.60199f
C1350 VDD.t153 VSS 0.65323f
C1351 VDD.n284 VSS 0.08054f
C1352 VDD.n285 VSS 0.42068f
C1353 VDD.n286 VSS 0.05659f
C1354 VDD.n287 VSS 0.04957f
C1355 VDD.n288 VSS 0.13417f
C1356 VDD.n289 VSS 0.03768f
C1357 VDD.n290 VSS 0.0356f
C1358 VDD.n291 VSS 0.675f
C1359 VDD.n292 VSS 0.51474f
C1360 VDD.n293 VSS 0.24609f
C1361 VDD.t148 VSS 0.2308f
C1362 VDD.t152 VSS 0.05075f
C1363 VDD.n294 VSS 0.78578f
C1364 VDD.n295 VSS 0.14242f
C1365 VDD.n296 VSS 0.22321f
C1366 VDD.n297 VSS 0.18092f
C1367 VDD.n298 VSS 0.2162f
C1368 VDD.n299 VSS 0.137f
C1369 VDD.n300 VSS 0.20802f
C1370 VDD.n301 VSS 0.10919f
C1371 VDD.n302 VSS 0.34369f
C1372 VDD.n303 VSS 1.23993f
C1373 VDD.t214 VSS 0.16721f
C1374 VDD.t216 VSS 0.1691f
C1375 VDD.t218 VSS 0.1691f
C1376 VDD.t220 VSS 0.1691f
C1377 VDD.t222 VSS 0.1691f
C1378 VDD.t224 VSS 0.1691f
C1379 VDD.t226 VSS 0.1691f
C1380 VDD.t228 VSS 0.1691f
C1381 VDD.t230 VSS 0.1691f
C1382 VDD.t232 VSS 0.1691f
C1383 VDD.t234 VSS 0.1691f
C1384 VDD.t236 VSS 0.1691f
C1385 VDD.t238 VSS 0.1691f
C1386 VDD.t240 VSS 0.1691f
C1387 VDD.t242 VSS 0.1691f
C1388 VDD.t244 VSS 0.1691f
C1389 VDD.t246 VSS 0.1691f
C1390 VDD.t248 VSS 0.1691f
C1391 VDD.t250 VSS 0.1691f
C1392 VDD.t252 VSS 0.1691f
C1393 VDD.t254 VSS 0.1157f
C1394 VDD.t200 VSS 0.38425f
C1395 VDD.n304 VSS 0.15157f
C1396 VDD.n305 VSS 0.05432f
C1397 VDD.n306 VSS 0.36059f
C1398 VDD.n307 VSS 0.08115f
C1399 VDD.n308 VSS 0.16259f
C1400 VDD.t197 VSS 0.03048f
C1401 VDD.n309 VSS 0.29307f
C1402 VDD.n310 VSS 0.10645f
C1403 VDD.n311 VSS 0.2162f
C1404 VDD.n312 VSS 0.09764f
C1405 VDD.n313 VSS 0.16297f
C1406 VDD.t196 VSS 1.30645f
C1407 VDD.n314 VSS 0.10919f
C1408 VDD.n315 VSS 0.13417f
C1409 VDD.n316 VSS 0.04407f
C1410 VDD.t205 VSS 0.12014f
C1411 VDD.n317 VSS 0.24609f
C1412 VDD.t199 VSS 0.12014f
C1413 VDD.t215 VSS 0.01557f
C1414 VDD.t217 VSS 0.0227f
C1415 VDD.t219 VSS 0.00634f
C1416 VDD.t221 VSS 0.0227f
C1417 VDD.t223 VSS 0.00634f
C1418 VDD.t225 VSS 0.0227f
C1419 VDD.t227 VSS 0.00634f
C1420 VDD.t229 VSS 0.0227f
C1421 VDD.t231 VSS 0.00634f
C1422 VDD.t233 VSS 0.0227f
C1423 VDD.t235 VSS 0.00634f
C1424 VDD.t237 VSS 0.0227f
C1425 VDD.t239 VSS 0.00634f
C1426 VDD.t241 VSS 0.0227f
C1427 VDD.t243 VSS 0.00634f
C1428 VDD.n318 VSS 0.33692f
C1429 VDD.n319 VSS 1.21781f
C1430 VDD.n320 VSS 1.28911f
C1431 VDD.t198 VSS 0.06007f
C1432 VDD.n321 VSS 0.29854f
C1433 VDD.n322 VSS 0.74259f
C1434 VDD.n323 VSS 0.27534f
C1435 VDD.n324 VSS 0.51474f
C1436 VDD.n325 VSS 0.03768f
C1437 VDD.t202 VSS 0.65323f
C1438 VDD.t9 VSS 0.69165f
C1439 VDD.t204 VSS 0.65323f
C1440 VDD.n326 VSS 0.04421f
C1441 VDD.n327 VSS 0.03571f
C1442 VDD.n328 VSS 0.675f
C1443 VDD.n329 VSS 0.0356f
C1444 VDD.n330 VSS 0.2088f
C1445 VDD.n331 VSS 0.13245f
C1446 VDD.n332 VSS 0.12519f
C1447 VDD.n333 VSS 0.04718f
C1448 VDD.n334 VSS 0.07378f
C1449 VDD.n335 VSS 0.08054f
C1450 VDD.n336 VSS 0.04646f
C1451 VDD.n337 VSS 0.03322f
C1452 VDD.n338 VSS 0.94355f
C1453 VDD.n339 VSS 0.08308f
C1454 VDD.n340 VSS 0.97181f
C1455 VDD.t201 VSS 0.2308f
C1456 VDD.t203 VSS 0.05075f
C1457 VDD.n341 VSS 0.85083f
C1458 VDD.n342 VSS 0.14242f
C1459 VDD.n343 VSS 0.22321f
C1460 VDD.n344 VSS 0.20802f
C1461 VDD.n345 VSS 0.137f
C1462 VDD.n346 VSS 0.07316f
C1463 VDD.n347 VSS 0.69165f
C1464 VDD.n348 VSS 0.05347f
C1465 VDD.n349 VSS 0.0819f
C1466 VDD.n350 VSS 0.1188f
C1467 VDD.n351 VSS 0.09175f
C1468 VDD.n352 VSS 0.27502f
C1469 VDD.n353 VSS 0.04646f
C1470 VDD.n354 VSS 0.05524f
C1471 VDD.t39 VSS 0.83868f
C1472 VDD.t33 VSS 0.4518f
C1473 VDD.n355 VSS 0.13417f
C1474 VDD.n356 VSS 0.09718f
C1475 VDD.n357 VSS 0.19288f
C1476 VDD.n358 VSS 0.0376f
C1477 VDD.t7 VSS 0.05375f
C1478 VDD.t64 VSS 0.03113f
C1479 VDD.n359 VSS 0.41679f
C1480 VDD.n360 VSS 0.07845f
C1481 VDD.t173 VSS 0.03048f
C1482 VDD.n361 VSS 0.04646f
C1483 VDD.n362 VSS 0.41679f
C1484 VDD.t26 VSS 0.83868f
C1485 VDD.n363 VSS 0.07847f
C1486 VDD.n364 VSS 0.033f
C1487 VDD.n365 VSS 0.08054f
C1488 VDD.n366 VSS 0.07378f
C1489 VDD.n367 VSS 0.13417f
C1490 VDD.n368 VSS 0.11117f
C1491 VDD.n369 VSS 0.62717f
C1492 VDD.t174 VSS 0.62582f
C1493 VDD.t24 VSS 0.04919f
C1494 VDD.n370 VSS 0.2001f
C1495 VDD.t176 VSS 0.07347f
C1496 VDD.t175 VSS 0.31801f
C1497 VDD.n371 VSS 0.4761f
C1498 VDD.n372 VSS 0.04339f
C1499 VDD.n373 VSS 0.05524f
C1500 VDD.n374 VSS 0.0376f
C1501 VDD.n375 VSS 0.59724f
C1502 VDD.n376 VSS 0.09718f
C1503 VDD.t44 VSS 0.4518f
C1504 VDD.n377 VSS 0.03844f
C1505 VDD.n378 VSS 0.03768f
C1506 VDD.n379 VSS 0.03617f
C1507 VDD.t172 VSS 1.40954f
C1508 VDD.n380 VSS 0.08054f
C1509 VDD.n381 VSS 0.07378f
C1510 VDD.n382 VSS 0.1213f
C1511 VDD.n383 VSS 0.16039f
C1512 VDD.n384 VSS 0.05501f
C1513 VDD.n385 VSS 0.0403f
C1514 VDD.n386 VSS 0.11117f
C1515 VDD.n387 VSS 0.03844f
C1516 VDD.n388 VSS 0.03768f
C1517 VDD.n389 VSS 0.03619f
C1518 VDD.n390 VSS 0.0523f
C1519 VDD.n391 VSS 0.03014f
C1520 VDD.n392 VSS 0.3376f
C1521 VDD.t125 VSS 0.09098f
C1522 VDD.n393 VSS 0.00829f
C1523 VDD.t63 VSS 1.40954f
C1524 VDD.n394 VSS 0.4761f
C1525 VDD.t65 VSS 0.31801f
C1526 VDD.n395 VSS 0.62717f
C1527 VDD.n396 VSS 0.59724f
C1528 VDD.n397 VSS 0.17834f
C1529 VDD.n398 VSS 0.13646f
C1530 VDD.n399 VSS 0.07316f
C1531 VDD.t67 VSS 0.62582f
C1532 VDD.n400 VSS 2.341f
C1533 VDD.n401 VSS 0.21955f
C1534 VDD.t185 VSS 0.06007f
C1535 VDD.t187 VSS 0.55073f
C1536 VDD.n402 VSS 0.04646f
C1537 VDD.n403 VSS 0.05524f
C1538 VDD.t2 VSS 0.83868f
C1539 VDD.t171 VSS 0.4518f
C1540 VDD.n404 VSS 0.13417f
C1541 VDD.n405 VSS 0.09718f
C1542 VDD.n406 VSS 0.2162f
C1543 VDD.n407 VSS 0.033f
C1544 VDD.t195 VSS 0.0509f
C1545 VDD.n408 VSS 0.83552f
C1546 VDD.n409 VSS 0.41679f
C1547 VDD.n410 VSS 0.09221f
C1548 VDD.n411 VSS 0.24454f
C1549 VDD.n412 VSS 0.11887f
C1550 VDD.n413 VSS 0.08115f
C1551 VDD.n414 VSS 0.08115f
C1552 VDD.n415 VSS 0.35483f
C1553 VDD.t108 VSS 0.07531f
C1554 VDD.n416 VSS 0.08115f
C1555 VDD.n417 VSS 0.08115f
C1556 VDD.t110 VSS 0.07531f
C1557 VDD.n418 VSS 0.58082f
C1558 VDD.n419 VSS 0.10882f
C1559 VDD.n420 VSS 0.13977f
C1560 VDD.n421 VSS 0.11887f
C1561 VDD.n422 VSS 0.09999f
C1562 VDD.n423 VSS 0.05217f
C1563 VDD.t107 VSS 2.30274f
C1564 VDD.n424 VSS 0.05217f
C1565 VDD.n425 VSS 0.43078f
C1566 VDD.n426 VSS 0.35483f
C1567 VDD.t106 VSS 0.07531f
C1568 VDD.t189 VSS 0.03048f
C1569 VDD.n427 VSS 0.07378f
C1570 VDD.n428 VSS 0.08054f
C1571 VDD.n429 VSS 0.07845f
C1572 VDD.n430 VSS 0.0819f
C1573 VDD.n431 VSS 0.00527f
C1574 VDD.t188 VSS 1.40954f
C1575 VDD.n432 VSS 0.04589f
C1576 VDD.n433 VSS 0.23386f
C1577 VDD.n434 VSS 0.34666f
C1578 VDD.n435 VSS 0.45936f
C1579 VDD.n436 VSS 0.10882f
C1580 VDD.n437 VSS 0.09903f
C1581 VDD.n438 VSS 0.19342f
C1582 VDD.n439 VSS 0.07777f
C1583 VDD.n440 VSS 0.02639f
C1584 VDD.n441 VSS 0.03619f
C1585 VDD.n442 VSS 0.03768f
C1586 VDD.n443 VSS 0.03844f
C1587 VDD.n444 VSS 0.11117f
C1588 VDD.n445 VSS 0.0376f
C1589 VDD.n446 VSS 0.4761f
C1590 VDD.t186 VSS 0.31801f
C1591 VDD.n447 VSS 0.62717f
C1592 VDD.n448 VSS 0.59724f
C1593 VDD.n449 VSS 0.14578f
C1594 VDD.n450 VSS 0.14637f
C1595 VDD.n451 VSS 0.09098f
C1596 VDD.n452 VSS 0.137f
C1597 VDD.n453 VSS 0.07316f
C1598 VDD.t184 VSS 0.62582f
C1599 VDD.n454 VSS 0.04339f
C1600 VDD.n455 VSS 0.35759f
C1601 VDD.n456 VSS 0.19699f
C1602 VDD.n457 VSS 3.81682f
C1603 VDD.n458 VSS 2.98705f
C1604 VDD.t59 VSS 0.07531f
C1605 VDD.n459 VSS 0.48886f
C1606 VDD.n460 VSS 0.54526f
C1607 VDD.n461 VSS 0.11887f
C1608 VDD.n462 VSS 0.08115f
C1609 VDD.t57 VSS 0.07531f
C1610 VDD.n463 VSS 0.08115f
C1611 VDD.n464 VSS 0.05217f
C1612 VDD.n465 VSS 0.61859f
C1613 VDD.n466 VSS 0.54526f
C1614 VDD.t55 VSS 0.07531f
C1615 VDD.n467 VSS 0.10882f
C1616 VDD.n468 VSS 0.95556f
C1617 VDD.n469 VSS 0.18347f
C1618 VDD.n470 VSS 0.10882f
C1619 VDD.n471 VSS 0.08115f
C1620 VDD.n472 VSS 0.05217f
C1621 VDD.n473 VSS 0.09999f
C1622 VDD.n474 VSS 0.11887f
C1623 VDD.n475 VSS 0.12486f
C1624 VDD.n476 VSS 0.05982f
C1625 VDD.t58 VSS 1.76f
C1626 VDD.n477 VSS 0.94165f
C1627 VDD.n478 VSS 0.57151f
C1628 VDD.n479 VSS 0.96031f
C1629 VDD.t256 VSS 0.13767f
C1630 VDD.t258 VSS 0.16721f
C1631 VDD.n480 VSS 0.30443f
C1632 VDD.n481 VSS 0.03855f
C1633 VDD.n482 VSS 0.94355f
C1634 VDD.n483 VSS 0.09196f
C1635 VDD.n484 VSS 0.05389f
C1636 VDD.n485 VSS 0.14629f
C1637 VDD.n486 VSS 0.02917f
C1638 VDD.n487 VSS 0.04652f
C1639 VDD.t121 VSS 0.00779f
C1640 VDD.n488 VSS 0.03045f
C1641 VDD.n489 VSS 0.03045f
C1642 VDD.t31 VSS 0.00779f
C1643 VDD.n490 VSS 0.04652f
C1644 VDD.n491 VSS 0.04961f
C1645 VDD.t20 VSS 0.19902f
C1646 VDD.n492 VSS 0.04459f
C1647 VDD.t79 VSS 0.20049f
C1648 VDD.n493 VSS 0.0407f
C1649 VDD.n494 VSS 0.23265f
C1650 VDD.n495 VSS 0.0407f
C1651 VDD.n496 VSS 0.01265f
C1652 VDD.n497 VSS 0.19886f
C1653 VDD.t141 VSS 0.19886f
C1654 VDD.n498 VSS 0.18929f
C1655 VDD.n499 VSS 0.18941f
C1656 VDD.t40 VSS 0.19902f
C1657 VDD.n500 VSS 0.19902f
C1658 VDD.n501 VSS 0.01704f
C1659 VDD.n502 VSS 0.04646f
C1660 VDD.n503 VSS 0.02962f
C1661 VDD.n504 VSS 0.14629f
C1662 VDD.t32 VSS 0.19902f
C1663 VDD.n505 VSS 0.09914f
C1664 VDD.t82 VSS 0.01524f
C1665 VDD.n506 VSS 0.06417f
C1666 VDD.n507 VSS 0.03073f
C1667 VDD.t42 VSS 0.19902f
C1668 VDD.n508 VSS 0.0464f
C1669 VDD.n509 VSS 0.04454f
C1670 VDD.t43 VSS 0.01524f
C1671 VDD.n510 VSS 0.03073f
C1672 VDD.n511 VSS 0.0464f
C1673 VDD.n512 VSS 0.04454f
C1674 VDD.n513 VSS 0.15739f
C1675 VDD.t19 VSS 0.01524f
C1676 VDD.n514 VSS 0.06417f
C1677 VDD.n515 VSS 0.04097f
C1678 VDD.t75 VSS 0.00779f
C1679 VDD.n516 VSS 0.01684f
C1680 VDD.n517 VSS 0.03711f
C1681 VDD.t76 VSS 0.19902f
C1682 VDD.n518 VSS 0.19024f
C1683 VDD.t74 VSS 0.19902f
C1684 VDD.n519 VSS 0.14629f
C1685 VDD.n520 VSS 0.14629f
C1686 VDD.n521 VSS 0.02962f
C1687 VDD.n522 VSS 0.04652f
C1688 VDD.n523 VSS 0.02917f
C1689 VDD.n524 VSS 0.04961f
C1690 VDD.n525 VSS 0.09914f
C1691 VDD.n526 VSS 0.15739f
C1692 VDD.t18 VSS 0.19902f
C1693 VDD.n527 VSS 0.14629f
C1694 VDD.n528 VSS 0.04652f
C1695 VDD.t140 VSS 0.01524f
C1696 VDD.t144 VSS 0.01524f
C1697 VDD.n529 VSS 0.06417f
C1698 VDD.n530 VSS 0.09914f
C1699 VDD.n531 VSS 0.04097f
C1700 VDD.t27 VSS 0.19902f
C1701 VDD.t83 VSS 0.19902f
C1702 VDD.n532 VSS 0.02962f
C1703 VDD.n533 VSS 0.0464f
C1704 VDD.n534 VSS 0.04454f
C1705 VDD.n535 VSS 0.01704f
C1706 VDD.n536 VSS 0.19902f
C1707 VDD.t143 VSS 0.19902f
C1708 VDD.n537 VSS 0.15739f
C1709 VDD.n538 VSS 0.15739f
C1710 VDD.t29 VSS 0.19902f
C1711 VDD.n539 VSS 0.19024f
C1712 VDD.n540 VSS 0.03711f
C1713 VDD.n541 VSS 0.02917f
C1714 VDD.n542 VSS 0.04961f
C1715 VDD.n543 VSS 0.01684f
C1716 VDD.t28 VSS 0.00779f
C1717 VDD.n544 VSS 0.06236f
C1718 VDD.n545 VSS 0.02962f
C1719 VDD.n546 VSS 0.14629f
C1720 VDD.t139 VSS 0.19902f
C1721 VDD.n547 VSS 0.19902f
C1722 VDD.n548 VSS 0.01704f
C1723 VDD.n549 VSS 0.01299f
C1724 VDD.n550 VSS 0.37015f
C1725 VDD.n551 VSS 0.31178f
C1726 VDD.n552 VSS 0.47092f
C1727 VDD.n553 VSS 0.37015f
C1728 VDD.n554 VSS 0.01299f
C1729 VDD.n555 VSS 0.01704f
C1730 VDD.n556 VSS 0.19902f
C1731 VDD.t81 VSS 0.19902f
C1732 VDD.n557 VSS 0.15739f
C1733 VDD.n558 VSS 0.15739f
C1734 VDD.n559 VSS 0.04097f
C1735 VDD.n560 VSS 0.02917f
C1736 VDD.n561 VSS 0.03711f
C1737 VDD.n562 VSS 0.19024f
C1738 VDD.t30 VSS 0.19902f
C1739 VDD.n563 VSS 0.14629f
C1740 VDD.n564 VSS 0.01684f
C1741 VDD.n565 VSS 0.03736f
C1742 VDD.n566 VSS 0.04396f
C1743 VDD.n567 VSS 0.07814f
C1744 VDD.n568 VSS 0.01684f
C1745 VDD.n569 VSS 0.14629f
C1746 VDD.t120 VSS 0.19902f
C1747 VDD.n570 VSS 0.19024f
C1748 VDD.t122 VSS 0.19954f
C1749 VDD.n571 VSS 0.15751f
C1750 VDD.n572 VSS 0.63577f
C1751 VDD.n573 VSS 0.7069f
C1752 VDD.n574 VSS 3.39922f
C1753 VDD.n575 VSS 1.71275f
C1754 VDD.n576 VSS 5.71647f
C1755 VDD.t17 VSS 0.03072f
C1756 VDD.n577 VSS 0.73124f
C1757 VDD.n578 VSS 0.14637f
C1758 VDD.n579 VSS 0.4761f
C1759 VDD.n580 VSS 0.0376f
C1760 VDD.t87 VSS 0.31801f
C1761 VDD.t88 VSS 0.62582f
C1762 VDD.n581 VSS 0.03844f
C1763 VDD.n582 VSS 0.11117f
C1764 VDD.n583 VSS 0.07316f
C1765 VDD.n584 VSS 0.13417f
C1766 VDD.n585 VSS 0.08054f
C1767 VDD.n586 VSS 0.03768f
C1768 VDD.n587 VSS 0.07847f
C1769 VDD.n588 VSS 0.41679f
C1770 VDD.n589 VSS 0.033f
C1771 VDD.n590 VSS 0.08115f
C1772 VDD.n591 VSS 0.08115f
C1773 VDD.n592 VSS 0.19664f
C1774 VDD.n593 VSS 0.08115f
C1775 VDD.t86 VSS 0.03113f
C1776 VDD.n594 VSS 0.05524f
C1777 VDD.n595 VSS 0.04339f
C1778 VDD.n596 VSS 0.04646f
C1779 VDD.n597 VSS 0.35563f
C1780 VDD.n598 VSS 0.05217f
C1781 VDD.t48 VSS 2.30274f
C1782 VDD.n599 VSS 0.05217f
C1783 VDD.n600 VSS 0.08115f
C1784 VDD.n601 VSS 0.15273f
C1785 VDD.n602 VSS 0.03415f
C1786 VDD.n603 VSS 0.03617f
C1787 VDD.t132 VSS 0.83868f
C1788 VDD.n604 VSS 0.137f
C1789 VDD.n605 VSS 0.09098f
C1790 VDD.n606 VSS 0.09718f
C1791 VDD.t14 VSS 0.4518f
C1792 VDD.n607 VSS 0.62717f
C1793 VDD.n608 VSS 0.59724f
C1794 VDD.n609 VSS 0.30182f
C1795 VDD.n610 VSS 3.14207f
C1796 VDD.t128 VSS 4.33316f
C1797 VDD.n611 VSS 2.60422f
C1798 VDD.n612 VSS 0.29854f
C1799 VDD.t114 VSS 0.45805f
C1800 VDD.n613 VSS 0.04339f
C1801 VDD.n614 VSS 0.05524f
C1802 VDD.n615 VSS 0.0376f
C1803 VDD.n616 VSS 0.46158f
C1804 VDD.n617 VSS 0.10344f
C1805 VDD.n618 VSS 0.14637f
C1806 VDD.n619 VSS 0.137f
C1807 VDD.n620 VSS 0.09098f
C1808 VDD.n621 VSS 0.09718f
C1809 VDD.t45 VSS 0.4518f
C1810 VDD.n622 VSS 0.03844f
C1811 VDD.n623 VSS 0.03768f
C1812 VDD.n624 VSS 0.03617f
C1813 VDD.n625 VSS 0.41679f
C1814 VDD.n626 VSS 0.04589f
C1815 VDD.t111 VSS 1.01376f
C1816 VDD.n627 VSS 0.00527f
C1817 VDD.n628 VSS 0.13627f
C1818 VDD.n629 VSS 0.27731f
C1819 VDD.n630 VSS 0.48618f
C1820 VDD.n631 VSS 0.63372f
C1821 VDD.n632 VSS 0.10344f
C1822 VDD.n633 VSS 0.14637f
C1823 VDD.n634 VSS 0.09098f
C1824 VDD.n635 VSS 0.09718f
C1825 VDD.t158 VSS 0.4518f
C1826 VDD.n636 VSS 0.55387f
C1827 VDD.t169 VSS 0.23437f
C1828 VDD.n637 VSS 0.37208f
C1829 VDD.n638 VSS 0.05524f
C1830 VDD.n639 VSS 0.04339f
C1831 VDD.n640 VSS 0.04646f
C1832 VDD.n641 VSS 0.03322f
C1833 VDD.t166 VSS 0.32355f
C1834 VDD.n642 VSS 0.29854f
C1835 VDD.n643 VSS 0.07847f
C1836 VDD.n644 VSS 0.00527f
C1837 VDD.n645 VSS 0.0819f
C1838 VDD.n646 VSS 0.2162f
C1839 VDD.n647 VSS 0.07378f
C1840 VDD.t25 VSS 0.83868f
C1841 VDD.n648 VSS 0.03617f
C1842 VDD.n649 VSS 0.02447f
C1843 VDD.n650 VSS 0.08651f
C1844 VDD.n651 VSS 0.16366f
C1845 VDD.n652 VSS 0.11887f
C1846 VDD.n653 VSS 0.08115f
C1847 VDD.n654 VSS 0.05217f
C1848 VDD.t160 VSS 0.69389f
C1849 VDD.n655 VSS 0.54526f
C1850 VDD.n656 VSS 0.10882f
C1851 VDD.t164 VSS 1.03087f
C1852 VDD.n657 VSS 0.18347f
C1853 VDD.n658 VSS 0.10882f
C1854 VDD.n659 VSS 0.08115f
C1855 VDD.n660 VSS 0.05217f
C1856 VDD.n661 VSS 0.09999f
C1857 VDD.n662 VSS 0.11887f
C1858 VDD.n663 VSS 0.12568f
C1859 VDD.n664 VSS 0.05994f
C1860 VDD.t161 VSS 2.06869f
C1861 VDD.n665 VSS 0.05432f
C1862 VDD.t162 VSS 0.56441f
C1863 VDD.n666 VSS 0.43372f
C1864 VDD.n667 VSS 4.47391f
C1865 VDD.n668 VSS 8.35886f
C1866 VDD.n669 VSS 3.84034f
C1867 VDD.n670 VSS 0.08247f
C1868 VDD.t103 VSS 0.60498f
C1869 VDD.t78 VSS 0.06007f
C1870 VDD.n671 VSS 0.0808f
C1871 VDD.n672 VSS 0.2205f
C1872 VDD.t62 VSS 0.06007f
C1873 VDD.n673 VSS 0.22608f
C1874 VDD.n674 VSS 23.5482f
C1875 VDD.n675 VSS 17.2089f
C1876 VDD.n676 VSS 0.10296f
C1877 VDD.n677 VSS 0.08404f
C1878 PWRENb.t3 VSS 0.2628f
C1879 PWRENb.t1 VSS 0.26288f
C1880 PWRENb.n0 VSS 2.56593f
C1881 PWRENb.t5 VSS 0.04722f
C1882 PWRENb.t4 VSS 0.07304f
C1883 PWRENb.n1 VSS 0.24073f
C1884 PWRENb.t2 VSS 0.20965f
C1885 PWRENb.t0 VSS 0.20974f
C1886 PWRENb.n2 VSS 12.9785f
C1887 S0.n0 VSS 10.6862f
C1888 S0.t4 VSS 0.16554f
C1889 S0.t0 VSS 0.33598f
C1890 S0.t1 VSS 0.53272f
C1891 S0.n1 VSS 2.29932f
C1892 S0.t2 VSS 0.34431f
C1893 S0.t3 VSS 0.53254f
C1894 S0.n2 VSS 1.53829f
C1895 S0.n3 VSS 3.13407f
C1896 S0.t5 VSS 0.26251f
C1897 S1.n0 VSS 13.354f
C1898 S1.t0 VSS 0.25279f
C1899 S1.t1 VSS 0.39099f
C1900 S1.n1 VSS 1.25474f
C1901 S1.t2 VSS 0.24667f
C1902 S1.t3 VSS 0.39112f
C1903 S1.n2 VSS 0.89489f
C1904 S1.n3 VSS 1.96656f
C1905 S1.t5 VSS 0.18874f
C1906 S1.t4 VSS 0.12028f
C1907 DONEb.t1 VSS 0.1746f
C1908 DONEb.t0 VSS 0.17038f
C1909 DONEb.n0 VSS 8.92771f
C1910 PROG.t3 VSS 0.036f
C1911 PROG.t9 VSS 0.036f
C1912 PROG.t8 VSS 0.036f
C1913 PROG.t5 VSS 0.036f
C1914 PROG.t0 VSS 0.036f
C1915 PROG.t10 VSS 0.036f
C1916 PROG.t2 VSS 0.036f
C1917 PROG.t7 VSS 0.036f
C1918 PROG.t1 VSS 0.036f
C1919 PROG.t4 VSS 0.036f
C1920 PROG.t6 VSS 0.036f
C1921 PROG.n0 VSS 1.23139f
C1922 PROG.n1 VSS 58.0867f
C1923 PROG.t12 VSS 0.20302f
C1924 PROG.t11 VSS 0.02933f
C1925 PU.t0 VSS 50.6697f
C1926 PU.n0 VSS 14.2094f
C1927 PU.n1 VSS 13.5639f
C1928 PU.n2 VSS 10.4801f
C1929 PU.n3 VSS 10.4804f
C1930 PU.n4 VSS 65.0816f
C1931 PU.n5 VSS 18.275f
C1932 PD.n0 VSS 2.10183f
C1933 PD.n1 VSS 4.44264f
C1934 PD.n2 VSS 1.57347f
C1935 PD.n3 VSS 1.57334f
C1936 PD.n4 VSS 1.57334f
C1937 PD.t0 VSS 27.4611f
C1938 PD.n5 VSS 7.25187f
C1939 PD.n6 VSS 6.93076f
C1940 PD.n7 VSS 5.49771f
C1941 PD.n8 VSS 3.44122f
C1942 PD.n9 VSS 3.27001f
C1943 PD.n10 VSS 32.9635f
C1944 PD.n11 VSS 2.53322f
C1945 PD.n12 VSS 0.24015f
.ends
