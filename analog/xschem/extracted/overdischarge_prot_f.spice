* NGSPICE file created from flattened.ext - technology: gf180mcuD

.subckt overdischarge_prot_f VDDP VSSP S0P S1P SAFE PD PU
X0 SAFE.t0 x1.OUT VDDP VDDP pfet_06v0 ad=3.52p pd=16.88u as=3.52p ps=16.88u w=8u l=0.55u
X1 a_n28896_102835# a_n27774_102835# VSSP.t35 ppolyf_u_1k_6p0 r_width=1u r_length=5u
X2 x1.MINUS a_n20338_99700# VSSP.t9 ppolyf_u_1k_6p0 r_width=1u r_length=17u
X3 S1Pn S1P.t1 VDDP VDDP pfet_06v0 ad=0.44p pd=2.88u as=0.44p ps=2.88u w=1u l=0.55u
D0 a_n24144_103727# VSSP.t30 diode_pd2nw_06v0 pj=12u area=5p
X4 VDDP x1.schmitt_0.Y a_n15885_102546# VSSP.t15 nfet_06v0 ad=0.88p pd=4.88u as=0.88p ps=4.88u w=2u l=0.7u
X5 x1.OUT x1.schmitt_0.Y VSSP.t6 VSSP.t6 nfet_06v0 ad=3.52p pd=16.88u as=2.08p ps=8.52u w=8u l=0.7u
X6 S1Pn S1P.t0 VSSP VSSP.t21 nfet_06v0 ad=0.44p pd=2.88u as=0.44p ps=2.88u w=1u l=0.7u
X7 VSSP.t6 x1.schmitt_0.Y a_n15109_103917# VDDP pfet_06v0 ad=0.88p pd=4.88u as=0.88p ps=4.88u w=2u l=0.55u
X8 SAFE.t1 x1.OUT VSSP.t13 VSSP.t12 nfet_06v0 ad=3.52p pd=16.88u as=3.52p ps=16.88u w=8u l=0.7u
X9 a_n3812_103083# a_n3812_103083# VSSP VSSP.t26 nfet_06v0 ad=2.08p pd=8.52u as=3.52p ps=16.88u w=8u l=0.7u
X10 a_n19642_100980# VSSP.t6 VSSP.t24 ppolyf_u_1k_6p0 r_width=1u r_length=2u
X11 a_n28928_103407# a_n28928_103407# a_n26508_103319# VSSP.t33 nfet_06v0 ad=4.4p pd=20.88u as=4.4p ps=20.88u w=10u l=2.5u
X12 VSSP.t6 x1.OUT a_n19642_100980# VSSP.t14 nfet_06v0 ad=0.88p pd=4.88u as=0.88p ps=4.88u w=2u l=0.7u
X13 VDDP a_n28976_104552# a_n28976_104552# VDDP pfet_06v0 ad=4.4p pd=20.88u as=4.4p ps=20.88u w=10u l=5u
X14 x1.OUT x1.schmitt_0.Y VDDP VDDP pfet_06v0 ad=2.08p pd=8.52u as=2.08p ps=8.52u w=8u l=0.55u
X15 VDDP a_n3812_103083# PU.t0 VDDP pfet_06v0 ad=3.52p pd=16.88u as=2.08p ps=8.52u w=8u l=0.55u
X16 VDDP x1.MINUS a_n19098_103044# VDDP pfet_06v0 ad=1.32p pd=6.88u as=1.32p ps=6.88u w=3u l=1.1u
X17 x1.MINUS a_n19642_100980# VSSP.t24 ppolyf_u_1k_6p0 r_width=1u r_length=8u
X18 VSSP.t6 x1.schmitt_0.Y x1.OUT VSSP.t6 nfet_06v0 ad=2.08p pd=8.52u as=2.08p ps=8.52u w=8u l=0.7u
X19 VDDP a_n5860_103083# a_n5860_103083# VDDP pfet_06v0 ad=3.52p pd=16.88u as=2.08p ps=8.52u w=8u l=0.55u
D1 a_n27774_102835# VSSP.t7 diode_pd2nw_06v0 pj=12u area=5p
X20 a_n15915_103917# x1.schmitt_0.A VDDP VDDP pfet_06v0 ad=1.76p pd=8.88u as=1.76p ps=8.88u w=4u l=0.55u
X21 x1.MINUS a_n21730_97160# VSSP.t34 ppolyf_u_1k_6p0 r_width=1u r_length=29.7u
X22 a_n18030_103324# a_n19098_103044# VSSP.t6 VSSP.t10 nfet_06v0 ad=1.32p pd=6.88u as=1.32p ps=6.88u w=3u l=1.4u
X23 x1.schmitt_0.A a_n18030_103324# VSSP.t6 VSSP.t5 nfet_06v0 ad=1.32p pd=6.88u as=1.32p ps=6.88u w=3u l=1.4u
X24 a_n15885_102546# x1.schmitt_0.A VSSP.t6 VSSP.t28 nfet_06v0 ad=1.76p pd=8.88u as=1.76p ps=8.88u w=4u l=0.7u
X25 S0Pn S0P VDDP VDDP pfet_06v0 ad=0.44p pd=2.88u as=0.44p ps=2.88u w=1u l=0.55u
X26 VDDP S1P.t2 a_n20373_104694# VDDP pfet_06v0 ad=3.52p pd=16.88u as=3.52p ps=16.88u w=8u l=0.55u
X27 VSSP a_n3812_103083# a_n3812_103083# VSSP.t26 nfet_06v0 ad=3.52p pd=16.88u as=2.08p ps=8.52u w=8u l=0.7u
X28 VDDP a_n28976_104552# x2.VREF VDDP pfet_06v0 ad=4.4p pd=20.88u as=4.4p ps=20.88u w=10u l=5u
X29 a_n24144_103727# x2.VREF VSSP.t0 ppolyf_u_1k_6p0 r_width=1u r_length=5u
X30 x1.schmitt_0.Y x1.schmitt_0.A a_n15915_103917# VDDP pfet_06v0 ad=1.76p pd=8.88u as=1.76p ps=8.88u w=4u l=0.55u
X31 PD.t0 a_n5860_103083# VSSP VSSP nfet_06v0 ad=2.08p pd=8.52u as=3.52p ps=16.88u w=8u l=0.7u
X32 VDDP a_n28976_104552# a_n28928_103407# VDDP pfet_06v0 ad=4.4p pd=20.88u as=4.4p ps=20.88u w=10u l=5u
X33 a_n21034_99300# S0P a_n20373_104694# VDDP pfet_06v0 ad=3.52p pd=16.88u as=3.52p ps=16.88u w=8u l=0.55u
X34 a_n20338_99700# S0Pn a_n20373_104694# VDDP pfet_06v0 ad=3.52p pd=16.88u as=3.52p ps=16.88u w=8u l=0.55u
X35 VDDP x1.schmitt_0.Y x1.OUT VDDP pfet_06v0 ad=3.52p pd=16.88u as=2.08p ps=8.52u w=8u l=0.55u
X36 x1.MINUS a_n21034_99300# VSSP.t25 ppolyf_u_1k_6p0 r_width=1u r_length=19u
X37 a_n28976_104552# a_n28928_103407# a_n28896_102835# VSSP.t32 nfet_06v0 ad=4.4p pd=20.88u as=4.4p ps=20.88u w=10u l=2.5u
X38 a_n19098_103044# a_n19098_103044# VSSP.t6 VSSP.t11 nfet_06v0 ad=1.32p pd=6.88u as=1.32p ps=6.88u w=3u l=1.4u
X39 S0Pn S0P VSSP.t23 VSSP.t22 nfet_06v0 ad=0.44p pd=2.88u as=0.44p ps=2.88u w=1u l=0.7u
X40 VDDP x1.schmitt_0.Y x1.OUT VDDP pfet_06v0 ad=2.08p pd=8.52u as=3.52p ps=16.88u w=8u l=0.55u
X41 PU.t0 a_n3812_103083# VDDP VDDP pfet_06v0 ad=2.08p pd=8.52u as=3.52p ps=16.88u w=8u l=0.55u
X42 VSSP a_n5860_103083# PD.t0 VSSP nfet_06v0 ad=3.52p pd=16.88u as=2.08p ps=8.52u w=8u l=0.7u
X43 a_n21730_97160# S1Pn VDDP VDDP pfet_06v0 ad=3.52p pd=16.88u as=3.52p ps=16.88u w=8u l=0.55u
X44 a_n5860_103083# a_n5860_103083# VDDP VDDP pfet_06v0 ad=2.08p pd=8.52u as=3.52p ps=16.88u w=8u l=0.55u
X45 VDDP a_n18030_103324# x1.schmitt_0.A VDDP pfet_06v0 ad=1.32p pd=6.88u as=1.32p ps=6.88u w=3u l=1.1u
X46 x1.schmitt_0.Y x1.schmitt_0.A a_n15885_102546# VSSP.t29 nfet_06v0 ad=1.76p pd=8.88u as=1.76p ps=8.88u w=4u l=0.7u
X47 VDDP x2.VREF a_n18030_103324# VDDP pfet_06v0 ad=1.32p pd=6.88u as=1.32p ps=6.88u w=3u l=1.1u
D2 a_n26508_103319# VSSP.t19 diode_pd2nw_06v0 pj=12u area=5p
X48 x1.OUT x1.schmitt_0.Y VSSP.t6 VSSP.t6 nfet_06v0 ad=2.08p pd=8.52u as=3.52p ps=16.88u w=8u l=0.7u
R0 PD.n0 PD.t0 23.2104
R1 PD.n1 PD.n0 12.6905
R2 PD PD.n1 12.5955
R3 PD.n1 PD 2.60576
R4 PD.n0 PD 2.60576
R5 PU PU.t0 23.2266
R6 SAFE SAFE.t1 50.0511
R7 SAFE.t1 SAFE.t0 4.44182
R8 S1P.n0 S1P.t2 56.5608
R9 S1P S1P.n0 46.5683
R10 S1P.n0 S1P.t1 13.82
R11 S1P.n0 S1P.t0 13.5625
R12 VSSP.n69 VSSP.n34 489938
R13 VSSP.n37 VSSP.n34 402458
R14 VSSP.n18 VSSP.n17 118721
R15 VSSP.n53 VSSP.n17 11155.7
R16 VSSP.n70 VSSP.n34 10612.4
R17 VSSP VSSP.n37 8421.61
R18 VSSP.n17 VSSP 4991
R19 VSSP.n57 VSSP.n36 4152.78
R20 VSSP.n28 VSSP.n36 4152.78
R21 VSSP.n56 VSSP.n40 4152.78
R22 VSSP.n40 VSSP.n28 4152.78
R23 VSSP.n9 VSSP.t6 0.743535
R24 VSSP.n8 VSSP.t13 0.0159461
R25 VSSP.t10 VSSP.t11 2578.86
R26 VSSP.t10 VSSP.t5 2578.86
R27 VSSP.n37 VSSP.t11 2322.56
R28 VSSP.n50 VSSP.t5 1408.33
R29 VSSP.t29 VSSP.t28 1405.69
R30 VSSP.n11 VSSP.t13 42.3002
R31 VSSP.n53 VSSP.n16 1046.34
R32 VSSP.n58 VSSP.t35 991.649
R33 VSSP.n67 VSSP.t32 738.308
R34 VSSP.t35 VSSP.n13 92.7445
R35 VSSP.t28 VSSP.n50 702.846
R36 VSSP.n51 VSSP.t29 702.846
R37 VSSP.n51 VSSP.t15 702.846
R38 VSSP.t15 VSSP.n9 703.59
R39 VSSP.n63 VSSP.n58 582.684
R40 VSSP VSSP.n55 570.111
R41 VSSP.n59 VSSP.t21 482.647
R42 VSSP.n62 VSSP.t21 481.348
R43 VSSP.t22 VSSP.n62 481.348
R44 VSSP.n63 VSSP.t22 481.348
R45 VSSP VSSP.n24 364.389
R46 VSSP.n18 VSSP.t6 0.953404
R47 VSSP.n3 VSSP.t12 209.683
R48 VSSP.n68 VSSP.n67 195.435
R49 VSSP.n15 VSSP.n39 180.972
R50 VSSP.n39 VSSP.n14 178.112
R51 VSSP VSSP.n28 165.107
R52 VSSP.n71 VSSP.n10 164.561
R53 VSSP.n16 VSSP.n11 124.112
R54 VSSP.t0 VSSP.n69 115.865
R55 VSSP.n13 VSSP.t32 86.2133
R56 VSSP.t32 VSSP.n21 115.501
R57 VSSP.n71 VSSP.n21 115.501
R58 VSSP.t32 VSSP.n65 112.001
R59 VSSP.n71 VSSP.n70 111.013
R60 VSSP.n48 VSSP.n47 107.334
R61 VSSP.n49 VSSP.n48 105.389
R62 VSSP.n1 VSSP.n46 96.2116
R63 VSSP.n46 VSSP.n45 96.2116
R64 VSSP.n18 VSSP.n11 96.7928
R65 VSSP.n8 VSSP.t6 0.863342
R66 VSSP.n58 VSSP.n57 92.4579
R67 VSSP.n70 VSSP.t0 89.0714
R68 VSSP.n44 VSSP.n42 85.9449
R69 VSSP.n44 VSSP.n43 85.9449
R70 VSSP.n48 VSSP.n43 83.6116
R71 VSSP.n55 VSSP.n54 83.2227
R72 VSSP.n47 VSSP.n46 82.2505
R73 VSSP.n38 VSSP.n21 79.7227
R74 VSSP.t35 VSSP.n14 77.5838
R75 VSSP.n56 VSSP 77.2281
R76 VSSP.n60 VSSP.n59 76.2227
R77 VSSP.n59 VSSP.n35 76.2227
R78 VSSP.n25 VSSP.n24 71.232
R79 VSSP VSSP.n66 0.893958
R80 VSSP.n20 VSSP.n23 64.7505
R81 VSSP.n33 VSSP.n31 58.3338
R82 VSSP.n32 VSSP.n30 58.3338
R83 VSSP.n54 VSSP.n20 58.269
R84 VSSP.n52 VSSP.n42 53.6672
R85 VSSP.n47 VSSP.n42 51.7227
R86 VSSP.n57 VSSP.n56 49.7511
R87 VSSP.n60 VSSP.n12 48.2227
R88 VSSP.n65 VSSP.n35 48.2227
R89 VSSP.n6 VSSP.n31 47.4449
R90 VSSP.n2 VSSP.n31 47.4449
R91 VSSP.n2 VSSP.n30 47.4449
R92 VSSP.n1 VSSP.n30 47.4449
R93 VSSP.n74 VSSP.n33 47.4449
R94 VSSP.n77 VSSP.n33 47.4449
R95 VSSP.n77 VSSP.n32 47.4449
R96 VSSP.n45 VSSP.n32 47.4449
R97 VSSP.n24 VSSP.n23 46.6672
R98 VSSP.n72 VSSP.n23 46.6672
R99 VSSP.n73 VSSP.n72 46.6672
R100 VSSP.n5 VSSP.n73 53.3726
R101 VSSP.n74 VSSP.n73 43.9449
R102 VSSP.n68 VSSP.n10 39.9686
R103 VSSP.t33 VSSP.n68 37.6565
R104 VSSP.t32 VSSP.n22 37.4797
R105 VSSP.n55 VSSP.n27 36.5561
R106 VSSP.n72 VSSP.t6 35.5838
R107 VSSP.n40 VSSP.n15 0.992795
R108 VSSP.n15 VSSP 0.689923
R109 VSSP.n0 VSSP.n39 33.8338
R110 VSSP VSSP.n38 38.7417
R111 VSSP.n66 VSSP.n22 33.8338
R112 VSSP.n38 VSSP.n22 28.438
R113 VSSP.n13 VSSP.n12 40.6515
R114 VSSP.n61 VSSP.n60 24.5005
R115 VSSP.n61 VSSP.n35 24.5005
R116 VSSP.n49 VSSP.n46 23.1394
R117 VSSP.n10 VSSP 0.428388
R118 VSSP.t12 VSSP.n53 21.0049
R119 VSSP.n54 VSSP.t6 132.639
R120 VSSP.n52 VSSP.n43 14.7783
R121 VSSP.n64 VSSP.n12 14.0005
R122 VSSP.n65 VSSP.n64 14.0005
R123 VSSP VSSP.t34 8.75761
R124 VSSP.n27 VSSP.t34 8.75761
R125 VSSP.n25 VSSP.t25 8.75761
R126 VSSP.t25 VSSP.n20 8.75761
R127 VSSP.t9 VSSP.n20 8.98251
R128 VSSP.t6 VSSP.t9 8.75761
R129 VSSP.t6 VSSP.t24 4.20106
R130 VSSP.t6 VSSP.n3 0.695824
R131 VSSP.t14 VSSP.n3 4.01485
R132 VSSP.n69 VSSP.t33 7.24203
R133 VSSP.n41 VSSP 4.68393
R134 VSSP.n26 VSSP.n25 0.193465
R135 VSSP.n16 VSSP.n8 233.439
R136 VSSP VSSP.t30 1.41084
R137 VSSP.n71 VSSP 0.865675
R138 VSSP.n59 VSSP 1.3005
R139 VSSP.n62 VSSP.n61 1.3005
R140 VSSP.n61 VSSP.t23 1.3005
R141 VSSP.n64 VSSP.n63 1.3005
R142 VSSP.n64 VSSP 1.3005
R143 VSSP VSSP.t32 1.29646
R144 VSSP.n76 VSSP.n4 0.632953
R145 VSSP.n66 VSSP.n14 1.16717
R146 VSSP.t6 VSSP.n4 0.386477
R147 VSSP.n26 VSSP.n41 1.08549
R148 VSSP VSSP.t32 0.572289
R149 VSSP.t35 VSSP 1.39749
R150 VSSP.n20 VSSP.n29 1.01146
R151 VSSP.n29 VSSP.n7 0.298985
R152 VSSP.n67 VSSP.n66 0.867167
R153 VSSP.n0 VSSP.n36 0.867167
R154 VSSP VSSP.n0 0.595972
R155 VSSP.n76 VSSP.n75 0.837071
R156 VSSP.n44 VSSP.n9 0.00116095
R157 VSSP.n52 VSSP.t6 0.931056
R158 VSSP VSSP.t7 1.31594
R159 VSSP.n29 VSSP.n27 0.668231
R160 VSSP.n26 VSSP.n27 0.547062
R161 VSSP.n6 VSSP.t11 0.578278
R162 VSSP.n5 VSSP.n6 0.302585
R163 VSSP.n2 VSSP.t10 0.578278
R164 VSSP.t6 VSSP.n2 0.578278
R165 VSSP.n1 VSSP.t5 0.578278
R166 VSSP.t6 VSSP.n1 0.578278
R167 VSSP.n45 VSSP.t5 0.578278
R168 VSSP.t10 VSSP.n77 0.578278
R169 VSSP.n77 VSSP.n76 0.578278
R170 VSSP.n74 VSSP.t11 0.578278
R171 VSSP.n75 VSSP.n74 0.578278
R172 VSSP VSSP.t19 0.45337
R173 VSSP.n49 VSSP.t6 0.497802
R174 VSSP.n50 VSSP.n49 0.473227
R175 VSSP.n52 VSSP.n51 0.473227
R176 VSSP.n41 VSSP.n19 0.434214
R177 VSSP.n19 VSSP.t6 0.590664
R178 VSSP.n45 VSSP.n4 0.710425
R179 VSSP.n75 VSSP.t6 0.550636
R180 VSSP.t23 VSSP 0.468453
R181 VSSP.n20 VSSP.n19 1.25818
R182 VSSP.n7 VSSP 1.18489
R183 VSSP VSSP.n16 1.11043
R184 VSSP.t6 VSSP.n5 1.09267
R185 VSSP.t26 VSSP 1.08803
R186 VSSP.n7 VSSP.t6 1.06768
C0 a_n28976_104552# a_n27774_102835# 0.00342f
C1 S0P S1Pn 0.13999f
C2 SAFE a_n3812_103083# 0.02693f
C3 S0Pn S1P 0.02333f
C4 x1.OUT a_n15885_102546# 0.03476f
C5 a_n21730_97160# x2.VREF 0.10138f
C6 a_n5860_103083# a_n3812_103083# 0.24905f
C7 a_n15885_102546# x1.schmitt_0.Y 0.32212f
C8 SAFE S1P 4.93304f
C9 a_n19642_100980# a_n20338_99700# 0.03653f
C10 PD S0P 0.09833f
C11 VDDP a_n26508_103319# 0.00129f
C12 a_n24144_103727# x2.VREF 0.00957f
C13 a_n26508_103319# a_n27774_102835# 0.01245f
C14 S0P a_n20338_99700# 0
C15 a_n18030_103324# x1.schmitt_0.Y 0.00767f
C16 S0P a_n28896_102835# 0.01937f
C17 a_n28976_104552# a_n28928_103407# 0.86805f
C18 S1Pn x2.VREF 0
C19 a_n28976_104552# S1P 0
C20 x1.MINUS S0Pn 0.00529f
C21 PU PD 41.7682f
C22 PU S0P 0.1029f
C23 a_n26508_103319# a_n28928_103407# 0.49277f
C24 a_n20338_99700# a_n18030_103324# 0
C25 S0P x2.VREF 0.15324f
C26 VDDP a_n21730_97160# 1.21034f
C27 a_n20338_99700# x2.VREF 0.30886f
C28 a_n21730_97160# a_n21034_99300# 0.33702f
C29 x1.MINUS a_n19098_103044# 0.10528f
C30 VDDP x1.OUT 4.95396f
C31 a_n18030_103324# a_n15885_102546# 0.00302f
C32 VDDP a_n24144_103727# 0.01091f
C33 S0Pn a_n28976_104552# 0.25652f
C34 VDDP x1.schmitt_0.Y 3.13011f
C35 x1.schmitt_0.A x1.OUT 0.00296f
C36 VDDP S1Pn 5.23184f
C37 SAFE a_n5860_103083# 0.07915f
C38 a_n21034_99300# S1Pn 0
C39 a_n20373_104694# a_n21730_97160# 0.00146f
C40 x1.schmitt_0.A x1.schmitt_0.Y 0.34776f
C41 a_n18030_103324# x2.VREF 0.097f
C42 x1.OUT a_n15109_103917# 0
C43 a_n21730_97160# S1P 0.01083f
C44 VDDP PD 0.12677f
C45 a_n21034_99300# a_n19642_100980# 0.00143f
C46 a_n15109_103917# x1.schmitt_0.Y 0.1906f
C47 a_n20373_104694# S1Pn 0.00412f
C48 a_n28928_103407# a_n24144_103727# 0.04671f
C49 VDDP S0P 1.80915f
C50 VDDP a_n20338_99700# 1.17974f
C51 VDDP a_n28896_102835# 0.00175f
C52 S0P a_n27774_102835# 0
C53 S0P a_n21034_99300# 1.51302f
C54 a_n28896_102835# a_n27774_102835# 0.01906f
C55 S1Pn a_n28928_103407# 0
C56 a_n21034_99300# a_n20338_99700# 0.48615f
C57 S1Pn S1P 5.12072f
C58 VDDP a_n15885_102546# 0.10737f
C59 PD a_n3812_103083# 0.40679f
C60 x1.schmitt_0.A a_n15885_102546# 0.21732f
C61 a_n20373_104694# S0P 1.48492f
C62 PU VDDP 2.35836f
C63 a_n20373_104694# a_n20338_99700# 0.0303f
C64 a_n15915_103917# x1.schmitt_0.Y 0.26594f
C65 a_n28976_104552# a_n26508_103319# 0.00182f
C66 VDDP a_n18030_103324# 1.26556f
C67 x1.MINUS a_n21730_97160# 0.04709f
C68 S0P a_n28928_103407# 0.06278f
C69 VDDP x2.VREF 4.11159f
C70 S0Pn a_n21730_97160# 0.01254f
C71 a_n28896_102835# a_n28928_103407# 0.33125f
C72 a_n21034_99300# x2.VREF 0.30316f
C73 PD S1P 0.09898f
C74 x1.schmitt_0.A a_n18030_103324# 0.24126f
C75 S0P S1P 26.083f
C76 a_n28896_102835# S1P 0.00178f
C77 PU a_n3812_103083# 1.94179f
C78 x1.MINUS S1Pn 0
C79 S0Pn S1Pn 0.1609f
C80 a_n15109_103917# a_n18030_103324# 0
C81 a_n20373_104694# x2.VREF 0.13243f
C82 SAFE x1.OUT 3.04084f
C83 a_n28928_103407# x2.VREF 0
C84 PU S1P 0.10354f
C85 a_n21730_97160# a_n28976_104552# 0.04355f
C86 SAFE x1.schmitt_0.Y 0.01545f
C87 S1P x2.VREF 0.00169f
C88 x1.MINUS S0P 0.00167f
C89 a_n28976_104552# a_n24144_103727# 0.00755f
C90 x1.MINUS a_n20338_99700# 0.21027f
C91 S0Pn S0P 4.91558f
C92 S0Pn a_n20338_99700# 1.51079f
C93 VDDP a_n27774_102835# 0.00387f
C94 VDDP a_n21034_99300# 1.16304f
C95 S1Pn a_n28976_104552# 0.22964f
C96 a_n15915_103917# a_n18030_103324# 0.00245f
C97 VDDP x1.schmitt_0.A 1.49388f
C98 SAFE PD 40.4122f
C99 SAFE S0P 11.8503f
C100 PD a_n5860_103083# 2.14872f
C101 VDDP a_n3812_103083# 1.68826f
C102 VDDP a_n20373_104694# 3.2262f
C103 a_n26508_103319# a_n24144_103727# 0.03516f
C104 VDDP a_n15109_103917# 0.53584f
C105 a_n20338_99700# a_n19098_103044# 0.01226f
C106 x1.MINUS a_n18030_103324# 0.00112f
C107 a_n20373_104694# a_n21034_99300# 0.03706f
C108 x1.MINUS x2.VREF 0.19672f
C109 VDDP a_n28928_103407# 1.4451f
C110 S0Pn x2.VREF 0.09012f
C111 x1.schmitt_0.A a_n15109_103917# 0.04753f
C112 S0P a_n28976_104552# 0.85639f
C113 a_n28928_103407# a_n27774_102835# 0.0341f
C114 a_n28976_104552# a_n28896_102835# 0.16355f
C115 PU SAFE 0.54239f
C116 VDDP S1P 7.08755f
C117 PU a_n5860_103083# 0.01482f
C118 VDDP a_n15915_103917# 0.67823f
C119 a_n18030_103324# a_n19098_103044# 0.1636f
C120 a_n19098_103044# x2.VREF 0.02805f
C121 a_n21730_97160# a_n24144_103727# 0
C122 a_n26508_103319# a_n28896_102835# 0
C123 x1.schmitt_0.A a_n15915_103917# 0.13556f
C124 a_n28976_104552# x2.VREF 0.44249f
C125 a_n20373_104694# S1P 1.42251f
C126 a_n21730_97160# S1Pn 1.45923f
C127 S1P a_n28928_103407# 0
C128 x1.MINUS VDDP 0.69151f
C129 x1.OUT x1.schmitt_0.Y 1.20799f
C130 S0Pn VDDP 2.63028f
C131 a_n15915_103917# a_n15109_103917# 0.13792f
C132 x1.MINUS a_n21034_99300# 0.23371f
C133 S0Pn a_n21034_99300# 0.02639f
C134 SAFE VDDP 1.48444f
C135 S0P a_n21730_97160# 0.0203f
C136 a_n21730_97160# a_n20338_99700# 0
C137 x1.OUT a_n19642_100980# 0.26783f
C138 x1.MINUS a_n20373_104694# 0.00255f
C139 S0Pn a_n20373_104694# 1.48987f
C140 VDDP a_n5860_103083# 2.60287f
C141 VDDP a_n19098_103044# 0.58237f
C142 x1.OUT a_n20338_99700# 0.0013f
C143 S0P a_n24144_103727# 0
C144 S0Pn a_n28928_103407# 0.00839f
C145 VDDP a_n28976_104552# 10.4906f
C146 PD VSSP 28.09287f
C147 PU VSSP 57.49297f
C148 SAFE VSSP 52.2123f
C149 S0P VSSP 12.8859f
C150 S1P VSSP 43.8271f
C151 VDDP VSSP 0.22209p
C152 a_n15885_102546# VSSP 1.09609f
C153 a_n19642_100980# VSSP 1.43933f
C154 a_n27774_102835# VSSP 2.0345f
C155 a_n26508_103319# VSSP 2.60737f
C156 a_n3812_103083# VSSP 2.87477f
C157 a_n5860_103083# VSSP 2.23456f
C158 x1.OUT VSSP 9.63666f
C159 a_n15109_103917# VSSP 0.20618f
C160 x1.schmitt_0.Y VSSP 3.23342f
C161 x1.schmitt_0.A VSSP 1.6191f
C162 a_n18030_103324# VSSP 1.43737f
C163 a_n19098_103044# VSSP 1.89097f
C164 x1.MINUS VSSP 2.51402f
C165 a_n24144_103727# VSSP 2.35674f
C166 a_n28896_102835# VSSP 1.60123f
C167 a_n20338_99700# VSSP 1.75423f
C168 a_n21034_99300# VSSP 1.60931f
C169 x2.VREF VSSP 1.41355f
C170 a_n21730_97160# VSSP 3.3298f
C171 a_n28928_103407# VSSP 3.22207f
C172 a_n28976_104552# VSSP 1.36873f
C173 S0Pn VSSP 0.85938f
C174 S1Pn VSSP 0.61433f
C175 a_n20373_104694# VSSP 0.06412f
C176 S1P.n0 VSSP 23.2875f
C177 S1P.t2 VSSP 0.66452f
C178 S1P.t1 VSSP 0.08987f
C179 S1P.t0 VSSP 0.11749f
C180 SAFE.t0 VSSP 0.90972f
C181 SAFE.t1 VSSP 31.8642f
C182 PU.t0 VSSP 13.684f
C183 PD.t0 VSSP 21.7242f
C184 PD.n0 VSSP 29.7667f
C185 PD.n1 VSSP 20.9271f
.ends
