* NGSPICE file created from overdischarge_prot_f.ext - technology: gf180mcuD

.subckt overdischarge_prot_f VDDP VSSP S0P S1P SAFE PD PU
X0 SAFE x1.OUT VDDP VDDP pfet_06v0 ad=3.52p pd=16.88u as=3.52p ps=16.88u w=8u l=0.55u
X1 a_n28896_102835# a_n27774_102835# VSSP.t20 ppolyf_u_1k_6p0 r_width=1u r_length=5u
X2 x1.MINUS a_n20338_99700# VSSP.t7 ppolyf_u_1k_6p0 r_width=1u r_length=17u
X3 S1Pn S1P VDDP VDDP pfet_06v0 ad=0.44p pd=2.88u as=0.44p ps=2.88u w=1u l=0.55u
D0 a_n24144_103727# VSSP.t30 diode_pd2nw_06v0 pj=12u area=5p
X4 VDDP x1.schmitt_0.Y a_n15885_102546# VSSP.t1 nfet_06v0 ad=0.88p pd=4.88u as=0.88p ps=4.88u w=2u l=0.7u
X5 x1.OUT x1.schmitt_0.Y VSSP.t0 VSSP.t0 nfet_06v0 ad=3.52p pd=16.88u as=2.08p ps=8.52u w=8u l=0.7u
X6 S1Pn S1P VSSP.t28 VSSP.t27 nfet_06v0 ad=0.44p pd=2.88u as=0.44p ps=2.88u w=1u l=0.7u
X7 VSSP.t0 x1.schmitt_0.Y a_n15109_103917# VDDP pfet_06v0 ad=0.88p pd=4.88u as=0.88p ps=4.88u w=2u l=0.55u
X8 SAFE x1.OUT VSSP.t9 VSSP.t8 nfet_06v0 ad=3.52p pd=16.88u as=3.52p ps=16.88u w=8u l=0.7u
X9 a_n3812_103083# a_n3812_103083# VSSP.t12 VSSP.t12 nfet_06v0 ad=2.08p pd=8.52u as=3.52p ps=16.88u w=8u l=0.7u
X10 a_n19642_100980# VSSP.t0 VSSP.t5 ppolyf_u_1k_6p0 r_width=1u r_length=2u
X11 a_n28928_103407# a_n28928_103407# a_n26508_103319# VSSP.t17 nfet_06v0 ad=4.4p pd=20.88u as=4.4p ps=20.88u w=10u l=2.5u
X12 VSSP.t0 x1.OUT a_n19642_100980# VSSP.t10 nfet_06v0 ad=0.88p pd=4.88u as=0.88p ps=4.88u w=2u l=0.7u
X13 VDDP a_n28976_104552# a_n28976_104552# VDDP pfet_06v0 ad=4.4p pd=20.88u as=4.4p ps=20.88u w=10u l=5u
X14 x1.OUT x1.schmitt_0.Y VDDP VDDP pfet_06v0 ad=2.08p pd=8.52u as=2.08p ps=8.52u w=8u l=0.55u
X15 VDDP a_n3812_103083# PU VDDP pfet_06v0 ad=3.52p pd=16.88u as=2.08p ps=8.52u w=8u l=0.55u
X16 VDDP x1.MINUS a_n19098_103044# VDDP pfet_06v0 ad=1.32p pd=6.88u as=1.32p ps=6.88u w=3u l=1.1u
X17 x1.MINUS a_n19642_100980# VSSP.t5 ppolyf_u_1k_6p0 r_width=1u r_length=8u
X18 VSSP.t0 x1.schmitt_0.Y x1.OUT VSSP.t0 nfet_06v0 ad=2.08p pd=8.52u as=2.08p ps=8.52u w=8u l=0.7u
X19 VDDP a_n5860_103083# a_n5860_103083# VDDP pfet_06v0 ad=3.52p pd=16.88u as=2.08p ps=8.52u w=8u l=0.55u
D1 a_n27774_102835# VSSP.t18 diode_pd2nw_06v0 pj=12u area=5p
X20 a_n15915_103917# x1.schmitt_0.A VDDP VDDP pfet_06v0 ad=1.76p pd=8.88u as=1.76p ps=8.88u w=4u l=0.55u
X21 x1.MINUS a_n21730_97160# VSSP.t6 ppolyf_u_1k_6p0 r_width=1u r_length=29.7u
X22 a_n18030_103324# a_n19098_103044# VSSP.t0 VSSP.t32 nfet_06v0 ad=1.32p pd=6.88u as=1.32p ps=6.88u w=3u l=1.4u
X23 x1.schmitt_0.A a_n18030_103324# VSSP.t0 VSSP.t21 nfet_06v0 ad=1.32p pd=6.88u as=1.32p ps=6.88u w=3u l=1.4u
X24 a_n15885_102546# x1.schmitt_0.A VSSP.t0 VSSP.t22 nfet_06v0 ad=1.76p pd=8.88u as=1.76p ps=8.88u w=4u l=0.7u
X25 S0Pn S0P VDDP VDDP pfet_06v0 ad=0.44p pd=2.88u as=0.44p ps=2.88u w=1u l=0.55u
X26 VDDP S1P a_n20373_104694# VDDP pfet_06v0 ad=3.52p pd=16.88u as=3.52p ps=16.88u w=8u l=0.55u
X27 VSSP.t12 a_n3812_103083# a_n3812_103083# VSSP.t12 nfet_06v0 ad=3.52p pd=16.88u as=2.08p ps=8.52u w=8u l=0.7u
X28 VDDP a_n28976_104552# x2.VREF VDDP pfet_06v0 ad=4.4p pd=20.88u as=4.4p ps=20.88u w=10u l=5u
X29 a_n24144_103727# x2.VREF VSSP.t29 ppolyf_u_1k_6p0 r_width=1u r_length=5u
X30 x1.schmitt_0.Y x1.schmitt_0.A a_n15915_103917# VDDP pfet_06v0 ad=1.76p pd=8.88u as=1.76p ps=8.88u w=4u l=0.55u
X31 PD.t0 a_n5860_103083# VSSP.t12 VSSP.t11 nfet_06v0 ad=2.08p pd=8.52u as=3.52p ps=16.88u w=8u l=0.7u
X32 VDDP a_n28976_104552# a_n28928_103407# VDDP pfet_06v0 ad=4.4p pd=20.88u as=4.4p ps=20.88u w=10u l=5u
X33 a_n21034_99300# S0P a_n20373_104694# VDDP pfet_06v0 ad=3.52p pd=16.88u as=3.52p ps=16.88u w=8u l=0.55u
X34 a_n20338_99700# S0Pn a_n20373_104694# VDDP pfet_06v0 ad=3.52p pd=16.88u as=3.52p ps=16.88u w=8u l=0.55u
X35 VDDP x1.schmitt_0.Y x1.OUT VDDP pfet_06v0 ad=3.52p pd=16.88u as=2.08p ps=8.52u w=8u l=0.55u
X36 x1.MINUS a_n21034_99300# VSSP.t24 ppolyf_u_1k_6p0 r_width=1u r_length=19u
X37 a_n28976_104552# a_n28928_103407# a_n28896_102835# VSSP.t16 nfet_06v0 ad=4.4p pd=20.88u as=4.4p ps=20.88u w=10u l=2.5u
X38 a_n19098_103044# a_n19098_103044# VSSP.t0 VSSP.t33 nfet_06v0 ad=1.32p pd=6.88u as=1.32p ps=6.88u w=3u l=1.4u
X39 S0Pn S0P VSSP.t26 VSSP.t25 nfet_06v0 ad=0.44p pd=2.88u as=0.44p ps=2.88u w=1u l=0.7u
X40 VDDP x1.schmitt_0.Y x1.OUT VDDP pfet_06v0 ad=2.08p pd=8.52u as=3.52p ps=16.88u w=8u l=0.55u
X41 PU a_n3812_103083# VDDP VDDP pfet_06v0 ad=2.08p pd=8.52u as=3.52p ps=16.88u w=8u l=0.55u
X42 VSSP.t12 a_n5860_103083# PD.t0 VSSP.t11 nfet_06v0 ad=3.52p pd=16.88u as=2.08p ps=8.52u w=8u l=0.7u
X43 a_n21730_97160# S1Pn VDDP VDDP pfet_06v0 ad=3.52p pd=16.88u as=3.52p ps=16.88u w=8u l=0.55u
X44 a_n5860_103083# a_n5860_103083# VDDP VDDP pfet_06v0 ad=2.08p pd=8.52u as=3.52p ps=16.88u w=8u l=0.55u
X45 VDDP a_n18030_103324# x1.schmitt_0.A VDDP pfet_06v0 ad=1.32p pd=6.88u as=1.32p ps=6.88u w=3u l=1.1u
X46 x1.schmitt_0.Y x1.schmitt_0.A a_n15885_102546# VSSP.t23 nfet_06v0 ad=1.76p pd=8.88u as=1.76p ps=8.88u w=4u l=0.7u
X47 VDDP x2.VREF a_n18030_103324# VDDP pfet_06v0 ad=1.32p pd=6.88u as=1.32p ps=6.88u w=3u l=1.1u
D2 a_n26508_103319# VSSP.t34 diode_pd2nw_06v0 pj=12u area=5p
X48 x1.OUT x1.schmitt_0.Y VSSP.t0 VSSP.t0 nfet_06v0 ad=2.08p pd=8.52u as=3.52p ps=16.88u w=8u l=0.7u
R0 PD PD.t0 23.1872
R1 VSSP.n68 VSSP.n34 489938
R2 VSSP.n39 VSSP.n34 402458
R3 VSSP.t0 VSSP.n16 118721
R4 VSSP.n55 VSSP.n16 11155.7
R5 VSSP.n69 VSSP.n34 10612.4
R6 VSSP.t28 VSSP.n39 8421.61
R7 VSSP.n38 VSSP.n36 8341.47
R8 VSSP.n38 VSSP.t28 8330.44
R9 VSSP.n16 VSSP.n15 4990.98
R10 VSSP.n59 VSSP.n37 4152.78
R11 VSSP.n28 VSSP.n37 4152.78
R12 VSSP.n58 VSSP.n42 4152.78
R13 VSSP.n42 VSSP.n28 4152.78
R14 VSSP.t0 VSSP.n8 0.743535
R15 VSSP.n4 VSSP.t9 0.0266627
R16 VSSP.t32 VSSP.t33 2578.86
R17 VSSP.t32 VSSP.t21 2578.86
R18 VSSP.n39 VSSP.t33 2322.56
R19 VSSP.n51 VSSP.t21 1408.33
R20 VSSP.t23 VSSP.t22 1405.69
R21 VSSP.n55 VSSP.n17 1046.34
R22 VSSP.n60 VSSP.t20 991.649
R23 VSSP.t22 VSSP.n51 702.846
R24 VSSP.n52 VSSP.t23 702.846
R25 VSSP.n52 VSSP.t1 702.846
R26 VSSP.n8 VSSP.t1 703.59
R27 VSSP.n65 VSSP.n60 582.684
R28 VSSP.t28 VSSP.n57 570.111
R29 VSSP.n61 VSSP.t27 482.647
R30 VSSP.n64 VSSP.t27 481.348
R31 VSSP.t25 VSSP.n64 481.348
R32 VSSP.n65 VSSP.t25 481.348
R33 VSSP.t28 VSSP.n24 374.889
R34 VSSP.t12 VSSP.n15 0.929015
R35 VSSP.t16 VSSP.t20 180.722
R36 VSSP.n7 VSSP.t8 209.817
R37 VSSP.n13 VSSP.n22 197.189
R38 VSSP.t28 VSSP.n11 0.731575
R39 VSSP.t28 VSSP.n27 14.956
R40 VSSP.n21 VSSP.n25 186.279
R41 VSSP.n40 VSSP.n14 178.112
R42 VSSP.t28 VSSP.n28 165.107
R43 VSSP.n40 VSSP.n11 180.965
R44 VSSP.n27 VSSP.n41 107.752
R45 VSSP.t28 VSSP.n13 40.154
R46 VSSP.n38 VSSP.n18 30.1613
R47 VSSP.n56 VSSP.t0 131.778
R48 VSSP.t29 VSSP.n68 115.865
R49 VSSP.t16 VSSP.n18 43.6966
R50 VSSP.t16 VSSP.n67 112.001
R51 VSSP.n4 VSSP.t0 0.859062
R52 VSSP.n70 VSSP.n69 111.013
R53 VSSP.n49 VSSP.n48 107.334
R54 VSSP.n50 VSSP.n49 105.389
R55 VSSP.n2 VSSP.n47 96.2116
R56 VSSP.n47 VSSP.n46 96.2116
R57 VSSP.n60 VSSP.n59 92.4579
R58 VSSP.n17 VSSP.n4 97.2705
R59 VSSP.n26 VSSP.n38 90.2005
R60 VSSP.n69 VSSP.t29 89.0714
R61 VSSP.n54 VSSP.n44 85.9449
R62 VSSP.n54 VSSP.n45 85.9449
R63 VSSP.n49 VSSP.n45 83.6116
R64 VSSP.n57 VSSP.n56 83.2227
R65 VSSP.n48 VSSP.n47 82.2505
R66 VSSP.n18 VSSP.n70 144.823
R67 VSSP.t20 VSSP.n14 77.5838
R68 VSSP.n58 VSSP.t28 77.2281
R69 VSSP.n62 VSSP.n61 76.2227
R70 VSSP.n61 VSSP.n35 76.2227
R71 VSSP.n9 VSSP.n24 70.0653
R72 VSSP.n20 VSSP.n23 64.7505
R73 VSSP.n33 VSSP.n31 58.3338
R74 VSSP.n32 VSSP.n30 58.3338
R75 VSSP.n56 VSSP.n20 58.269
R76 VSSP.n24 VSSP.n23 57.1672
R77 VSSP.n53 VSSP.n44 53.6672
R78 VSSP.n48 VSSP.n44 51.7227
R79 VSSP.n59 VSSP.n58 49.7511
R80 VSSP.n67 VSSP.n35 48.2227
R81 VSSP.n62 VSSP.n36 48.2227
R82 VSSP.n6 VSSP.n31 47.4449
R83 VSSP.n1 VSSP.n31 47.4449
R84 VSSP.n1 VSSP.n30 47.4449
R85 VSSP.n2 VSSP.n30 47.4449
R86 VSSP.n73 VSSP.n33 47.4449
R87 VSSP.n75 VSSP.n33 47.4449
R88 VSSP.n75 VSSP.n32 47.4449
R89 VSSP.n46 VSSP.n32 47.4449
R90 VSSP.n71 VSSP.n23 46.6672
R91 VSSP.n72 VSSP.n71 46.6672
R92 VSSP.n5 VSSP.n72 53.4458
R93 VSSP.n73 VSSP.n72 43.9449
R94 VSSP.t17 VSSP.n13 37.6565
R95 VSSP.n57 VSSP.n9 36.5561
R96 VSSP.n71 VSSP.t0 35.5838
R97 VSSP.n10 VSSP.n40 33.8338
R98 VSSP.n10 VSSP.n25 33.8338
R99 VSSP.n27 VSSP.n26 11.3499
R100 VSSP.n63 VSSP.n62 24.5005
R101 VSSP.n63 VSSP.n35 24.5005
R102 VSSP.n50 VSSP.n47 23.1394
R103 VSSP.t8 VSSP.n55 21.0049
R104 VSSP.n53 VSSP.n45 14.7783
R105 VSSP.n66 VSSP.n36 14.0005
R106 VSSP.n67 VSSP.n66 14.0005
R107 VSSP.n26 VSSP.n25 11.1816
R108 VSSP.t28 VSSP.t6 8.75761
R109 VSSP.n9 VSSP.t6 8.75761
R110 VSSP.n9 VSSP.t24 8.75761
R111 VSSP.t24 VSSP.n20 8.75761
R112 VSSP.t7 VSSP.n20 8.98251
R113 VSSP.t0 VSSP.t7 8.75761
R114 VSSP.t0 VSSP.t5 4.24694
R115 VSSP.t0 VSSP.n7 0.840238
R116 VSSP.t10 VSSP.n7 3.94664
R117 VSSP.n68 VSSP.t17 7.24203
R118 VSSP.n43 VSSP.t28 4.68393
R119 VSSP.t12 VSSP.t0 1.0333
R120 VSSP.t16 VSSP.n22 1.69089
R121 VSSP.t20 VSSP.t28 1.59732
R122 VSSP.t0 VSSP.n0 1.49898
R123 VSSP.n50 VSSP.t0 1.41108
R124 VSSP.n29 VSSP.n9 1.40776
R125 VSSP.n22 VSSP.n21 0.0034791
R126 VSSP.n12 VSSP.t28 0.235989
R127 VSSP.n12 VSSP.t16 0.567594
R128 VSSP.n61 VSSP.t28 1.3005
R129 VSSP.n64 VSSP.n63 1.3005
R130 VSSP.n63 VSSP.t26 1.3005
R131 VSSP.n66 VSSP.n65 1.3005
R132 VSSP.n66 VSSP.t28 1.3005
R133 VSSP.n74 VSSP.n3 0.641288
R134 VSSP.n21 VSSP.n14 1.16717
R135 VSSP.t0 VSSP.n3 0.353735
R136 VSSP.n70 VSSP.n12 0.870624
R137 VSSP.n15 VSSP.t11 0.127745
R138 VSSP.n9 VSSP.n43 1.08549
R139 VSSP.n20 VSSP.n29 1.01146
R140 VSSP.n29 VSSP.t0 0.958387
R141 VSSP.t28 VSSP.n21 0.941084
R142 VSSP.n29 VSSP.t28 0.926593
R143 VSSP.n10 VSSP.n37 0.867167
R144 VSSP.t28 VSSP.n10 0.867167
R145 VSSP.n42 VSSP.n41 0.867167
R146 VSSP.n41 VSSP.n11 0.133693
R147 VSSP.n74 VSSP.n0 0.837071
R148 VSSP.t12 VSSP.t28 0.751647
R149 VSSP.n54 VSSP.n8 0.00116095
R150 VSSP.n53 VSSP.t0 1.27143
R151 VSSP VSSP.t12 0.601586
R152 VSSP.n6 VSSP.t33 0.578278
R153 VSSP.n5 VSSP.n6 0.301636
R154 VSSP.n1 VSSP.t32 0.578278
R155 VSSP.t0 VSSP.n1 0.578278
R156 VSSP.n2 VSSP.t21 0.578278
R157 VSSP.t0 VSSP.n2 0.578278
R158 VSSP.n46 VSSP.t21 0.578278
R159 VSSP.t32 VSSP.n75 0.578278
R160 VSSP.n75 VSSP.n74 0.578278
R161 VSSP.n73 VSSP.t33 0.578278
R162 VSSP.n0 VSSP.n73 0.578278
R163 VSSP.t28 VSSP.t34 0.45337
R164 VSSP.t30 VSSP.t28 0.419233
R165 VSSP.n51 VSSP.n50 0.473227
R166 VSSP.n53 VSSP.n52 0.473227
R167 VSSP.n43 VSSP.n19 0.434214
R168 VSSP.n19 VSSP.t0 0.597984
R169 VSSP.n46 VSSP.n3 0.699243
R170 VSSP.t26 VSSP.t28 0.462823
R171 VSSP.n20 VSSP.n19 1.25818
R172 VSSP.t12 VSSP.n17 1.11043
R173 VSSP.t28 VSSP.t18 1.08945
R174 VSSP.t0 VSSP.n5 1.03254
C0 S1Pn a_n21034_99300# 0
C1 S1P PD 0.09898f
C2 x1.MINUS S0Pn 0.00481f
C3 a_n21730_97160# S0Pn 0.01254f
C4 a_n20373_104694# S0Pn 0.8094f
C5 PU a_n5860_103083# 0.01482f
C6 x1.schmitt_0.Y a_n18030_103324# 0.00767f
C7 S1P S0Pn 0.02328f
C8 a_n15885_102546# VDDP 0.06257f
C9 a_n28928_103407# S0Pn 0.00839f
C10 VDDP a_n20338_99700# 0.79487f
C11 S0Pn x2.VREF 0.0788f
C12 a_n15915_103917# a_n18030_103324# 0.00245f
C13 S1Pn x1.MINUS 0
C14 a_n15109_103917# a_n18030_103324# 0
C15 a_n21034_99300# x1.MINUS 0.15245f
C16 a_n24144_103727# a_n28976_104552# 0.00576f
C17 S0P a_n20338_99700# 0
C18 a_n21730_97160# S1Pn 0.79787f
C19 a_n26508_103319# a_n28928_103407# 0.41894f
C20 a_n20373_104694# S1Pn 0.00285f
C21 a_n21730_97160# a_n21034_99300# 0.17141f
C22 a_n28928_103407# a_n27774_102835# 0.0341f
C23 S1Pn S1P 2.60268f
C24 a_n20373_104694# a_n21034_99300# 0.03706f
C25 a_n19098_103044# a_n20338_99700# 0.01226f
C26 PD VDDP 0.12674f
C27 a_n28928_103407# S1Pn 0
C28 S1Pn x2.VREF 0
C29 x1.OUT VDDP 3.12185f
C30 a_n21034_99300# x2.VREF 0.17287f
C31 S0P PD 0.09833f
C32 S0Pn VDDP 2.38839f
C33 a_n28896_102835# a_n28976_104552# 0.08972f
C34 a_n3812_103083# PD 0.40679f
C35 x1.schmitt_0.Y VDDP 2.54876f
C36 a_n19642_100980# a_n20338_99700# 0.02104f
C37 VDDP a_n5860_103083# 1.99148f
C38 a_n21730_97160# x1.MINUS 0.04709f
C39 a_n20373_104694# x1.MINUS 0.00255f
C40 x1.MINUS a_n18030_103324# 0.00112f
C41 S0P S0Pn 2.56444f
C42 a_n26508_103319# VDDP 0.00134f
C43 a_n15915_103917# VDDP 0.48973f
C44 a_n27774_102835# VDDP 0.00404f
C45 a_n21730_97160# a_n20373_104694# 0.00146f
C46 a_n15109_103917# VDDP 0.42756f
C47 PU S1P 0.10354f
C48 x1.MINUS x2.VREF 0.11869f
C49 a_n21730_97160# S1P 0.00976f
C50 a_n3812_103083# a_n5860_103083# 0.12523f
C51 a_n20373_104694# S1P 0.76016f
C52 S1Pn VDDP 4.40978f
C53 S0P a_n27774_102835# 0
C54 a_n21730_97160# x2.VREF 0.07832f
C55 a_n21034_99300# VDDP 0.77827f
C56 a_n20373_104694# x2.VREF 0.1232f
C57 x2.VREF a_n18030_103324# 0.09169f
C58 a_n19642_100980# x1.OUT 0.1503f
C59 a_n28928_103407# S1P 0
C60 S1P x2.VREF 0.00162f
C61 x1.schmitt_0.A a_n15885_102546# 0.20611f
C62 S1Pn S0P 0.10036f
C63 S0P a_n21034_99300# 0.80729f
C64 a_n28928_103407# x2.VREF 0
C65 x1.MINUS VDDP 0.61515f
C66 PD SAFE 20.2599f
C67 PU VDDP 1.46912f
C68 a_n21730_97160# VDDP 0.82539f
C69 x1.OUT SAFE 1.67273f
C70 a_n20373_104694# VDDP 2.05479f
C71 VDDP a_n18030_103324# 0.98856f
C72 S0P x1.MINUS 0.00118f
C73 x1.schmitt_0.A x1.OUT 0.00296f
C74 a_n26508_103319# a_n24144_103727# 0.02238f
C75 a_n19642_100980# a_n21034_99300# 0.00143f
C76 S1P VDDP 5.70113f
C77 S0P PU 0.1029f
C78 x1.schmitt_0.Y SAFE 0.01545f
C79 a_n21730_97160# S0P 0.01792f
C80 a_n19098_103044# x1.MINUS 0.09127f
C81 a_n3812_103083# PU 1.29134f
C82 a_n28928_103407# VDDP 0.96467f
C83 x2.VREF VDDP 3.51365f
C84 a_n20373_104694# S0P 0.79762f
C85 x1.schmitt_0.Y x1.schmitt_0.A 0.25565f
C86 SAFE a_n5860_103083# 0.03974f
C87 S0P S1P 13.0487f
C88 S0Pn a_n28976_104552# 0.23758f
C89 a_n19098_103044# a_n18030_103324# 0.13891f
C90 a_n28928_103407# S0P 0.06215f
C91 S0P x2.VREF 0.13004f
C92 a_n15915_103917# x1.schmitt_0.A 0.13556f
C93 a_n15109_103917# x1.schmitt_0.A 0.03504f
C94 a_n26508_103319# a_n28896_102835# 0
C95 a_n19098_103044# x2.VREF 0.02332f
C96 a_n26508_103319# a_n28976_104552# 0.00182f
C97 a_n28896_102835# a_n27774_102835# 0.01486f
C98 a_n27774_102835# a_n28976_104552# 0.00342f
C99 S1Pn a_n28976_104552# 0.21533f
C100 a_n15885_102546# x1.OUT 0.01803f
C101 a_n21730_97160# a_n24144_103727# 0
C102 x1.OUT a_n20338_99700# 0.0013f
C103 S0P VDDP 1.3912f
C104 x1.schmitt_0.Y a_n15885_102546# 0.22179f
C105 a_n3812_103083# VDDP 1.48907f
C106 S0Pn a_n20338_99700# 0.80614f
C107 a_n19098_103044# VDDP 0.38226f
C108 a_n28928_103407# a_n24144_103727# 0.04349f
C109 a_n24144_103727# x2.VREF 0.0059f
C110 PU SAFE 0.30871f
C111 S1P SAFE 2.52016f
C112 x1.schmitt_0.A a_n18030_103324# 0.21422f
C113 a_n21730_97160# a_n28976_104552# 0.04355f
C114 a_n28896_102835# S1P 0.00178f
C115 S1P a_n28976_104552# 0
C116 PD a_n5860_103083# 1.46696f
C117 a_n28928_103407# a_n28896_102835# 0.33107f
C118 x1.schmitt_0.Y x1.OUT 1.13055f
C119 a_n21034_99300# a_n20338_99700# 0.24787f
C120 a_n28928_103407# a_n28976_104552# 0.76728f
C121 x2.VREF a_n28976_104552# 0.44251f
C122 a_n24144_103727# VDDP 0.01082f
C123 a_n15109_103917# x1.OUT 0
C124 S0P a_n24144_103727# 0
C125 x1.schmitt_0.Y a_n15915_103917# 0.16321f
C126 VDDP SAFE 1.05457f
C127 x1.schmitt_0.Y a_n15109_103917# 0.13002f
C128 x1.MINUS a_n20338_99700# 0.19793f
C129 x1.schmitt_0.A VDDP 1.20763f
C130 S1Pn S0Pn 0.1047f
C131 a_n15885_102546# a_n18030_103324# 0.00302f
C132 a_n28896_102835# VDDP 0.00179f
C133 a_n21730_97160# a_n20338_99700# 0
C134 a_n21034_99300# S0Pn 0.02639f
C135 a_n26508_103319# a_n27774_102835# 0.00796f
C136 VDDP a_n28976_104552# 8.19381f
C137 a_n20373_104694# a_n20338_99700# 0.0303f
C138 a_n18030_103324# a_n20338_99700# 0
C139 S0P SAFE 5.97432f
C140 a_n15915_103917# a_n15109_103917# 0.13792f
C141 a_n3812_103083# SAFE 0.02437f
C142 a_n28896_102835# S0P 0.01937f
C143 x2.VREF a_n20338_99700# 0.17179f
C144 S0P a_n28976_104552# 0.85382f
C145 PU PD 21.1492f
C146 PD VSSP 47.25999f
C147 PU VSSP 24.345f
C148 SAFE VSSP 26.10128f
C149 VDDP VSSP 0.24583p
C150 a_n15885_102546# VSSP 2.77721f
C151 a_n19642_100980# VSSP 1.24296f
C152 a_n27774_102835# VSSP 1.44472f
C153 a_n26508_103319# VSSP 2.78735f
C154 a_n15109_103917# VSSP 0.12873f
C155 a_n15915_103917# VSSP 0.66626f
C156 a_n18030_103324# VSSP 0.68842f
C157 a_n24144_103727# VSSP 1.74707f
C158 a_n28896_102835# VSSP 1.08895f
C159 a_n20338_99700# VSSP 5.27637f
C160 a_n21034_99300# VSSP 1.56356f
C161 a_n21730_97160# VSSP 8.95879f
C162 a_n20373_104694# VSSP 3.63117f
C163 VSSP.t0 VSSP 3.20622f
C164 VSSP.t12 VSSP 1.14624f
C165 PD.t0 VSSP 11.1479f
.ends
