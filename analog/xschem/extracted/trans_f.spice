* NGSPICE file created from trans.ext - technology: gf180mcuD

.subckt trans_f VDD VSS EN A B
X0 a_1776_n69# EN VSS.t1 VSS.t0 nfet_06v0 ad=0.44p pd=2.88u as=0.44p ps=2.88u w=1u l=0.7u
X1 B EN A VDD.t2 pfet_06v0 ad=1.76p pd=8.88u as=1.76p ps=8.88u w=4u l=0.55u
X2 a_1776_n69# EN VDD.t1 VDD.t0 pfet_06v0 ad=0.44p pd=2.88u as=0.44p ps=2.88u w=1u l=0.55u
X3 B a_1776_n69# A VSS.t2 nfet_06v0 ad=1.76p pd=8.88u as=1.76p ps=8.88u w=4u l=0.7u
R0 VDD.n2 VDD.t0 192.887
R1 VDD.n3 VDD.t2 191.885
R2 VDD.n1 VDD.t0 191.311
R3 VDD.t2 VDD.n1 191.311
R4 VDD.n3 VDD.n0 57.0877
R5 VDD.n2 VDD.n0 31.5415
R6 VDD.n1 VDD.n0 8.67647
R7 VDD VDD.t1 4.4205
R8 VDD VDD.n2 1.5755
R9 VDD.n1 VDD 1.37166
R10 VDD.n3 VDD 1.06798
R11 VSS.t0 VSS.n2 638.367
R12 VSS.n3 VSS.t2 637.54
R13 VSS.n1 VSS.t0 637.067
R14 VSS.t2 VSS.n1 637.067
R15 VSS.n3 VSS.n0 64.9175
R16 VSS.n2 VSS.n0 36.5223
R17 VSS.n1 VSS.n0 9.7131
R18 VSS.n2 VSS.t1 1.3005
R19 VSS.n1 VSS.t1 1.12891
R20 VSS.t1 VSS.n3 1.10638
C0 EN A 0.24239f
C1 B A 0.56518f
C2 a_1776_n69# EN 0.48395f
C3 B a_1776_n69# 0.07826f
C4 VDD A 0.84894f
C5 VDD a_1776_n69# 0.26733f
C6 B EN 0.09694f
C7 VDD EN 0.99395f
C8 VDD B 0.6438f
C9 a_1776_n69# A 0.2302f
C10 B 0 0.67829f
C11 A 0 0.60064f
C12 EN 0 1.13623f
C13 VDD 0 7.48749f
C14 a_1776_n69# 0 1.05174f
C15 VDD.n0 0 0.05617f
C16 VDD.n1 0 0.43276f
C17 VDD.t0 0 0.32801f
C18 VDD.n2 0 0.36018f
C19 VDD.t1 0 0.01235f
C20 VDD.t2 0 0.32651f
C21 VDD.n3 0 0.47587f
.ends
