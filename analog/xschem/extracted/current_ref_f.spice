* NGSPICE file created from flattened.ext - technology: gf180mcuD

.subckt current_ref_f VDD VSS PROG DISABLE CONTROL
X0 VDD.t9 x1.OUT PROG VDD.t16 pfet_06v0 ad=0.52p pd=2.52u as=0.52p ps=2.52u w=2u l=1u
X1 x1.OUT a_9446_2979# VDD.t33 VDD.t38 pfet_06v0 ad=4.16p pd=16.52u as=4.16p ps=16.52u w=16u l=1.1u
X2 x1.OUT a_11307_1943# VSS.t3 VSS.t2 nfet_06v0 ad=4.16p pd=16.52u as=4.16p ps=16.52u w=16u l=1.4u
X3 VDD.t35 a_9446_2979# a_10131_2251# VDD.t34 pfet_06v0 ad=3.52p pd=16.88u as=3.52p ps=16.88u w=8u l=1.1u
X4 x1.OUT DISABLE CONTROL VDD.t2 pfet_06v0 ad=7.04p pd=32.88u as=4.16p ps=16.52u w=16u l=0.55u
X5 a_11307_1943# x1.OUT cap_mim_2f0_m4m5_noshield c_width=5u c_length=5u
X6 PROG x1.OUT VDD.t18 VDD.t20 pfet_06v0 ad=0.52p pd=2.52u as=0.52p ps=2.52u w=2u l=1u
X7 x1.OUT a_9446_2979# VDD.t33 VDD.t39 pfet_06v0 ad=4.16p pd=16.52u as=7.04p ps=32.88u w=16u l=1.1u
X8 VDD.t9 x1.OUT PROG VDD.t12 pfet_06v0 ad=0.52p pd=2.52u as=0.52p ps=2.52u w=2u l=1u
X9 a_2182_2045# a_2230_900# a_2262_328# VSS.t22 nfet_06v0 ad=4.4p pd=20.88u as=4.4p ps=20.88u w=10u l=2.5u
X10 x1.OUT a_17709_651.t3 CONTROL VSS.t7 nfet_06v0 ad=4.16p pd=16.52u as=4.16p ps=16.52u w=16u l=0.7u
X11 VDD x1.OUT PROG VDD.t29 pfet_06v0 ad=0.52p pd=2.52u as=0.52p ps=2.52u w=2u l=1u
X12 PROG x1.OUT VDD.t18 VDD.t22 pfet_06v0 ad=0.52p pd=2.52u as=0.52p ps=2.52u w=2u l=1u
X13 VDD.t33 a_9446_2979# x1.OUT VDD.t32 pfet_06v0 ad=4.16p pd=16.52u as=4.16p ps=16.52u w=16u l=1.1u
X14 VDD x1.OUT PROG VDD.t31 pfet_06v0 ad=0.52p pd=2.52u as=0.88p ps=4.88u w=2u l=1u
X15 VDD.t18 x1.OUT PROG VDD.t25 pfet_06v0 ad=0.52p pd=2.52u as=0.52p ps=2.52u w=2u l=1u
X16 VDD.t35 a_2182_2045# a_2230_900# VDD.t45 pfet_06v0 ad=4.4p pd=20.88u as=4.4p ps=20.88u w=10u l=5u
X17 VDD.t35 a_9446_2979# a_9446_2979# VDD.t34 pfet_06v0 ad=1.76p pd=8.88u as=1.76p ps=8.88u w=4u l=1.1u
X18 PROG x1.OUT VDD.t18 VDD.t17 pfet_06v0 ad=0.52p pd=2.52u as=0.52p ps=2.52u w=2u l=1u
X19 a_2230_900# a_2230_900# a_4650_812# VSS.t23 nfet_06v0 ad=4.4p pd=20.88u as=4.4p ps=20.88u w=10u l=2.5u
X20 VSS.t3 a_11307_1943# x1.OUT VSS.t4 nfet_06v0 ad=4.16p pd=16.52u as=4.16p ps=16.52u w=16u l=1.4u
X21 VDD.t9 x1.OUT PROG VDD.t10 pfet_06v0 ad=0.52p pd=2.52u as=0.52p ps=2.52u w=2u l=1u
X22 a_10131_1943# a_10131_1943# VSS.t20 VSS.t18 nfet_06v0 ad=1.32p pd=6.88u as=1.32p ps=6.88u w=3u l=1.4u
X23 CONTROL a_17709_651.t4 x1.OUT VSS.t7 nfet_06v0 ad=4.16p pd=16.52u as=4.16p ps=16.52u w=16u l=0.7u
X24 VDD.t42 a_17709_651.t9 CONTROL VDD.t41 pfet_06v0 ad=7.04p pd=32.88u as=4.16p ps=16.52u w=16u l=1u
X25 VDD x1.OUT PROG VDD.t27 pfet_06v0 ad=0.52p pd=2.52u as=0.52p ps=2.52u w=2u l=1u
X26 VDD.t18 x1.OUT PROG VDD.t23 pfet_06v0 ad=0.52p pd=2.52u as=0.52p ps=2.52u w=2u l=1u
X27 VDD.t4 a_17709_651.t7 CONTROL VDD.t3 pfet_06v0 ad=4.16p pd=16.52u as=4.16p ps=16.52u w=16u l=1u
X28 a_17709_651.t0 DISABLE VSS.t12 VSS.t11 nfet_06v0 ad=1.76p pd=8.88u as=1.76p ps=8.88u w=4u l=0.7u
X29 PROG x1.OUT VDD.t9 VDD.t15 pfet_06v0 ad=0.52p pd=2.52u as=0.52p ps=2.52u w=2u l=1u
X30 a_7014_1220# MINUS VSS.t21 ppolyf_u_1k_6p0 r_width=1u r_length=5u
X31 a_2262_328# a_3384_328# VSS.t15 ppolyf_u_1k_6p0 r_width=1u r_length=5u
X32 a_9446_2979# VSS.t6 VSS.t10 ppolyf_u_1k_6p0 r_width=1u r_length=11u
X33 VDD.t7 x1.OUT PROG VDD.t6 pfet_06v0 ad=0.88p pd=4.88u as=0.52p ps=2.52u w=2u l=1u
X34 PROG x1.OUT VDD VDD.t28 pfet_06v0 ad=0.52p pd=2.52u as=0.52p ps=2.52u w=2u l=1u
X35 a_11307_1943# a_10131_1943# VSS.t19 VSS.t18 nfet_06v0 ad=1.32p pd=6.88u as=1.32p ps=6.88u w=3u l=1.4u
X36 VSS.t1 a_11307_1943# x1.OUT VSS.t0 nfet_06v0 ad=7.04p pd=32.88u as=4.16p ps=16.52u w=16u l=1.4u
X37 CONTROL DISABLE x1.OUT VDD.t2 pfet_06v0 ad=4.16p pd=16.52u as=4.16p ps=16.52u w=16u l=0.55u
X38 VDD.t18 x1.OUT PROG VDD.t21 pfet_06v0 ad=0.52p pd=2.52u as=0.52p ps=2.52u w=2u l=1u
X39 PROG x1.OUT VDD VDD.t30 pfet_06v0 ad=0.52p pd=2.52u as=0.52p ps=2.52u w=2u l=1u
X40 CONTROL DISABLE x1.OUT VDD.t2 pfet_06v0 ad=4.16p pd=16.52u as=7.04p ps=32.88u w=16u l=0.55u
X41 PROG x1.OUT VDD.t9 VDD.t13 pfet_06v0 ad=0.52p pd=2.52u as=0.52p ps=2.52u w=2u l=1u
D0 a_3384_328# VSS.t8 diode_pd2nw_06v0 pj=12u area=5p
X42 x1.OUT a_11307_1943# VSS.t6 VSS.t5 nfet_06v0 ad=4.16p pd=16.52u as=7.04p ps=32.88u w=16u l=1.4u
X43 PROG x1.OUT VDD.t9 VDD.t8 pfet_06v0 ad=0.52p pd=2.52u as=0.52p ps=2.52u w=2u l=1u
X44 VDD.t35 a_2182_2045# a_2182_2045# VDD.t44 pfet_06v0 ad=4.4p pd=20.88u as=4.4p ps=20.88u w=10u l=5u
X45 VDD.t35 a_2182_2045# MINUS VDD.t43 pfet_06v0 ad=4.4p pd=20.88u as=4.4p ps=20.88u w=10u l=5u
X46 a_10131_2251# PROG a_11307_1943# VDD.t0 pfet_06v0 ad=1.76p pd=8.88u as=1.76p ps=8.88u w=4u l=1.1u
D1 a_4650_812# VSS.t16 diode_pd2nw_06v0 pj=12u area=5p
X47 VDD.t18 x1.OUT PROG VDD.t19 pfet_06v0 ad=0.52p pd=2.52u as=0.52p ps=2.52u w=2u l=1u
X48 PROG x1.OUT VDD VDD.t26 pfet_06v0 ad=0.52p pd=2.52u as=0.52p ps=2.52u w=2u l=1u
X49 PROG x1.OUT VDD.t9 VDD.t11 pfet_06v0 ad=0.52p pd=2.52u as=0.52p ps=2.52u w=2u l=1u
X50 VDD.t35 a_9446_2979# x1.OUT VDD.t34 pfet_06v0 ad=7.04p pd=32.88u as=4.16p ps=16.52u w=16u l=1.1u
X51 CONTROL a_17709_651.t2 x1.OUT VSS.t7 nfet_06v0 ad=4.16p pd=16.52u as=7.04p ps=32.88u w=16u l=0.7u
X52 VDD.t9 x1.OUT PROG VDD.t14 pfet_06v0 ad=0.52p pd=2.52u as=0.52p ps=2.52u w=2u l=1u
X53 x1.OUT DISABLE CONTROL VDD.t2 pfet_06v0 ad=4.16p pd=16.52u as=4.16p ps=16.52u w=16u l=0.55u
D2 a_7014_1220# VSS.t13 diode_pd2nw_06v0 pj=12u area=5p
X54 x1.OUT a_17709_651.t5 CONTROL VSS.t7 nfet_06v0 ad=7.04p pd=32.88u as=4.16p ps=16.52u w=16u l=0.7u
X55 CONTROL a_17709_651.t8 VDD.t4 VDD.t40 pfet_06v0 ad=4.16p pd=16.52u as=4.16p ps=16.52u w=16u l=1u
X56 CONTROL a_17709_651.t6 VDD.t4 VDD.t5 pfet_06v0 ad=4.16p pd=16.52u as=7.04p ps=32.88u w=16u l=1u
X57 a_17709_651.t1 DISABLE VDD VDD.t1 pfet_06v0 ad=1.76p pd=8.88u as=1.76p ps=8.88u w=4u l=0.55u
X58 PROG x1.OUT VDD.t18 VDD.t24 pfet_06v0 ad=0.52p pd=2.52u as=0.52p ps=2.52u w=2u l=1u
X59 a_10131_2251# MINUS a_10131_1943# VDD.t0 pfet_06v0 ad=1.76p pd=8.88u as=1.76p ps=8.88u w=4u l=1.1u
R0 VDD.t35 VDD.n19 44400.3
R1 VDD.n22 VDD.t2 1397.87
R2 VDD.t44 VDD.t35 1.09463
R3 VDD.t45 VDD.t43 1363.17
R4 VDD.t2 VDD.n21 1346.04
R5 VDD.n16 VDD.t43 720.597
R6 VDD.n28 VDD.n20 698.601
R7 VDD.n30 VDD.n20 526.487
R8 VDD.n9 VDD.t4 0.805911
R9 VDD.t29 VDD.t28 358.491
R10 VDD.t28 VDD.t27 358.491
R11 VDD.t27 VDD.t26 358.491
R12 VDD.t26 VDD.t25 358.491
R13 VDD.t25 VDD.t24 358.491
R14 VDD.t24 VDD.t23 358.491
R15 VDD.t23 VDD.t22 358.491
R16 VDD.t22 VDD.t21 358.491
R17 VDD.t21 VDD.t20 358.491
R18 VDD.t20 VDD.t19 358.491
R19 VDD.t19 VDD.t17 358.491
R20 VDD.t15 VDD.t16 358.491
R21 VDD.t14 VDD.t15 358.491
R22 VDD.t13 VDD.t14 358.491
R23 VDD.t12 VDD.t13 358.491
R24 VDD.t11 VDD.t12 358.491
R25 VDD.t10 VDD.t11 358.491
R26 VDD.t8 VDD.t10 358.491
R27 VDD.t6 VDD.t8 358.491
R28 VDD.n28 VDD.t31 349.957
R29 VDD.n20 VDD.t6 349.957
R30 VDD.t31 VDD.n27 344.341
R31 VDD.t17 VDD.n19 304.245
R32 VDD.t30 VDD.n26 233.492
R33 VDD.n27 VDD.n25 208.079
R34 VDD.n18 VDD.t33 196.875
R35 VDD.n25 VDD.t1 191.311
R36 VDD.n22 VDD.t1 191.311
R37 VDD.t42 VDD 0.521465
R38 VDD.t35 VDD.n30 153.3
R39 VDD.n29 VDD.t33 153.3
R40 VDD.t4 VDD.n3 0.97774
R41 VDD.t2 VDD.n10 153.3
R42 VDD VDD.n3 204.891
R43 VDD.n26 VDD.t29 125.001
R44 VDD.n32 VDD.n15 122.433
R45 VDD.n31 VDD.n14 115.501
R46 VDD VDD.n11 106.132
R47 VDD.t45 VDD.t35 0.446821
R48 VDD.t45 VDD.n14 103.951
R49 VDD.n7 VDD.n14 103.951
R50 VDD.n0 VDD.n2 167.828
R51 VDD.n31 VDD.n0 103.951
R52 VDD.n32 VDD.n31 103.951
R53 VDD.n7 VDD.t35 0.688868
R54 VDD.n8 VDD.n18 12.6894
R55 VDD.n24 VDD.n11 89.9297
R56 VDD.n24 VDD.n10 89.0755
R57 VDD.t40 VDD.t3 81.8971
R58 VDD.t41 VDD.t40 81.8971
R59 VDD.t4 VDD.t5 79.9169
R60 VDD.t42 VDD.t41 79.9169
R61 VDD.t5 VDD.n21 78.6643
R62 VDD.n30 VDD.n29 69.3005
R63 VDD.n37 VDD.t35 41.953
R64 VDD.n33 VDD.n18 57.0066
R65 VDD.t16 VDD.n19 54.2458
R66 VDD.n17 VDD.n15 52.8573
R67 VDD.n33 VDD.t35 0.862643
R68 VDD.n35 VDD.t34 43.7148
R69 VDD.t35 VDD.t34 43.7148
R70 VDD.t32 VDD.t0 42.8576
R71 VDD.t39 VDD.n34 40.2862
R72 VDD.n37 VDD.n15 33.9093
R73 VDD.n23 VDD.n10 31.3937
R74 VDD.n29 VDD.n28 31.1068
R75 VDD.n23 VDD.n11 30.5395
R76 VDD.n26 VDD.t38 24.1434
R77 VDD.n13 VDD.n16 20.5719
R78 VDD.n37 VDD.n36 20.3791
R79 VDD.n27 VDD.t30 14.1514
R80 VDD.t35 VDD 13.8526
R81 VDD.t35 VDD 10.3588
R82 VDD.n8 VDD.n13 0.623042
R83 VDD.t35 VDD 8.49413
R84 VDD.n5 VDD.n12 8.44682
R85 VDD.t35 VDD 8.22709
R86 VDD.t35 VDD 7.27468
R87 VDD.t35 VDD 5.79073
R88 VDD.t42 VDD 4.33731
R89 VDD.t35 VDD 4.1405
R90 VDD.n34 VDD.t33 3.60407
R91 VDD.t0 VDD.t39 3.42907
R92 VDD.t35 VDD 3.33165
R93 VDD.t3 VDD.n21 3.23326
R94 VDD.t7 VDD.t35 3.21516
R95 VDD.t35 VDD.n8 0.389318
R96 VDD.t35 VDD 2.88127
R97 VDD.n12 VDD.n15 2.83313
R98 VDD.t35 VDD.n39 2.63398
R99 VDD.t35 VDD.n6 0.725745
R100 VDD.t35 VDD 2.57413
R101 VDD.n35 VDD.t38 2.57193
R102 VDD.n38 VDD 2.0535
R103 VDD.t42 VDD 1.74803
R104 VDD.n3 VDD.t2 0.97774
R105 VDD.t35 VDD 1.70132
R106 VDD.n36 VDD.n12 1.59208
R107 VDD.n9 VDD.t42 0.198727
R108 VDD.t35 VDD.n17 0.902069
R109 VDD.t18 VDD.t9 1.27306
R110 VDD.t35 VDD 1.15963
R111 VDD.t33 VDD.n1 0.200553
R112 VDD VDD.t18 1.02604
R113 VDD.t35 VDD 0.995568
R114 VDD.t9 VDD.t7 0.964634
R115 VDD VDD.n1 1.31938
R116 VDD.n28 VDD 0.9005
R117 VDD.t7 VDD.n20 0.9005
R118 VDD.n13 VDD.t32 0.857643
R119 VDD VDD.t35 0.8285
R120 VDD.n26 VDD.n16 0.714786
R121 VDD.n39 VDD.n38 0.708579
R122 VDD.n39 VDD.n0 0.708579
R123 VDD.n6 VDD.n0 1.11354
R124 VDD.t35 VDD 0.609909
R125 VDD.n9 VDD 7.98307
R126 VDD.t2 VDD 1.42606
R127 VDD.n5 VDD.t35 1.28056
R128 VDD.t45 VDD.n0 1.23186
R129 VDD VDD.t35 1.19543
R130 VDD.t35 VDD.n1 1.03342
R131 VDD.n25 VDD.n24 0.573227
R132 VDD.n24 VDD 0.573227
R133 VDD.n36 VDD.n4 0.223078
R134 VDD.n5 VDD.n13 0.573227
R135 VDD.n34 VDD.n17 0.573227
R136 VDD.n34 VDD.n33 0.573227
R137 VDD.n23 VDD.n22 0.573227
R138 VDD.n23 VDD 0.878095
R139 VDD.n35 VDD.n4 0.129571
R140 VDD.n2 VDD.t44 0.263787
R141 VDD.n38 VDD.n2 0.263
R142 VDD.n32 VDD.t43 0.263
R143 VDD.n7 VDD.t43 0.263
R144 VDD.n6 VDD.n32 0.458367
R145 VDD.n4 VDD.t35 1.01932
R146 VSS.n52 VSS.n51 26006.4
R147 VSS.n53 VSS.n52 24824.9
R148 VSS.n53 VSS.n22 24824.9
R149 VSS.n54 VSS.n53 5491.9
R150 VSS.n52 VSS.n21 5491.9
R151 VSS.n55 VSS.n54 4152.78
R152 VSS.n55 VSS.n21 4152.78
R153 VSS.n30 VSS.t7 3005.8
R154 VSS.n31 VSS.n23 1788.07
R155 VSS.n51 VSS.n23 1722.11
R156 VSS.n23 VSS.n22 1184.76
R157 VSS.t22 VSS.n18 672.073
R158 VSS.t22 VSS.t15 642.423
R159 VSS.n31 VSS.t11 435.957
R160 VSS.t11 VSS.n30 435.957
R161 VSS.n39 VSS.n38 316.971
R162 VSS.n49 VSS.t21 200.083
R163 VSS.n4 VSS.n8 0.117179
R164 VSS.n50 VSS.n28 186.279
R165 VSS.t5 VSS.t4 178.286
R166 VSS.n27 VSS.n26 178.112
R167 VSS.n22 VSS.n18 177.903
R168 VSS.n11 VSS.n10 177.524
R169 VSS.t7 VSS.n13 170.333
R170 VSS.n50 VSS.n24 169.587
R171 VSS VSS.n55 165.107
R172 VSS.t6 VSS.t5 156.144
R173 VSS.t18 VSS.n43 156
R174 VSS.n28 VSS.n27 152.445
R175 VSS.n49 VSS.n48 147.879
R176 VSS.n36 VSS.t6 142.042
R177 VSS.n44 VSS.t0 136.5
R178 VSS.n46 VSS.n20 129.624
R179 VSS.n25 VSS.n8 196.617
R180 VSS.t21 VSS.t23 123.106
R181 VSS.n36 VSS.t1 116.96
R182 VSS VSS.n20 116.59
R183 VSS.t22 VSS.n17 115.501
R184 VSS.n49 VSS.n17 115.501
R185 VSS.n15 VSS.n13 101.889
R186 VSS.n15 VSS.n10 101.889
R187 VSS.t2 VSS.n23 86.8219
R188 VSS.n57 VSS.n17 79.7227
R189 VSS.n26 VSS.n25 77.5838
R190 VSS.n6 VSS.n32 73.1116
R191 VSS.n38 VSS.n34 72.2631
R192 VSS VSS.n16 68.2505
R193 VSS VSS.t13 0.420052
R194 VSS.n16 VSS.t8 64.2445
R195 VSS.n2 VSS 1.08861
R196 VSS.n37 VSS.n36 64.1437
R197 VSS.n41 VSS.n33 58.3338
R198 VSS.n48 VSS.n47 53.1767
R199 VSS.t4 VSS.t10 52.9291
R200 VSS.n38 VSS.n35 48.8582
R201 VSS.n41 VSS.n35 47.4449
R202 VSS.n42 VSS.n41 47.4449
R203 VSS.n34 VSS.n33 47.4449
R204 VSS.n6 VSS.n33 47.4449
R205 VSS VSS.n19 42.5838
R206 VSS.n42 VSS.n40 41.8061
R207 VSS.n46 VSS.n22 39.1048
R208 VSS.t10 VSS.n23 38.5362
R209 VSS.t23 VSS.n22 37.6565
R210 VSS.n8 VSS.n58 37.4797
R211 VSS.n40 VSS.n32 35.348
R212 VSS.n29 VSS.n10 34.8819
R213 VSS.n29 VSS.n13 34.8819
R214 VSS.n3 VSS.n28 33.8338
R215 VSS.n3 VSS.n19 33.8338
R216 VSS.n58 VSS.n5 33.8338
R217 VSS.n27 VSS.n1 33.8338
R218 VSS.n56 VSS.n1 33.8338
R219 VSS.n57 VSS.n56 28.7297
R220 VSS.n58 VSS.n57 28.438
R221 VSS.n48 VSS.n45 22.5691
R222 VSS.n40 VSS.n39 20.5537
R223 VSS.n44 VSS.t1 19.6449
R224 VSS.t0 VSS.t18 19.5005
R225 VSS.n56 VSS 14.5838
R226 VSS.n14 VSS 13.8536
R227 VSS.n45 VSS.n24 12.1533
R228 VSS.t6 VSS 10.5275
R229 VSS.n39 VSS.n37 7.08484
R230 VSS.n37 VSS.n32 6.57881
R231 VSS.t6 VSS 4.14088
R232 VSS.n43 VSS.t2 2.78621
R233 VSS.t7 VSS.n12 2.92311
R234 VSS.t7 VSS.n9 0.444538
R235 VSS.n45 VSS.n20 2.6005
R236 VSS VSS.n45 2.6005
R237 VSS.t12 VSS 2.20654
R238 VSS VSS.n16 2.1005
R239 VSS VSS.t16 0.48775
R240 VSS.n4 VSS.t22 0.348596
R241 VSS.t12 VSS 1.87345
R242 VSS.n0 VSS.t22 1.45275
R243 VSS.n7 VSS.t6 0.439231
R244 VSS.n26 VSS.n5 1.16717
R245 VSS.n7 VSS 1.15238
R246 VSS.n2 VSS.t8 0.0102777
R247 VSS.n49 VSS.n0 0.606848
R248 VSS.t19 VSS.t20 1.02629
R249 VSS VSS.n0 0.615538
R250 VSS.t1 VSS.t12 0.963719
R251 VSS.n7 VSS.n34 0.718011
R252 VSS.n3 VSS.n21 0.867167
R253 VSS VSS.n3 0.867167
R254 VSS.n51 VSS.n50 0.867167
R255 VSS.n50 VSS 0.867167
R256 VSS.n54 VSS.n1 0.867167
R257 VSS VSS.n1 0.867167
R258 VSS.n5 VSS.n18 0.867167
R259 VSS VSS.n5 0.867167
R260 VSS.t3 VSS.t6 0.791743
R261 VSS VSS.n4 0.659483
R262 VSS.n24 VSS.n19 0.729667
R263 VSS.t12 VSS 0.662149
R264 VSS.n14 VSS.t6 0.6125
R265 VSS VSS.n2 0.588095
R266 VSS.n29 VSS.n12 0.645007
R267 VSS.t3 VSS.t1 0.636176
R268 VSS.n11 VSS.n9 0.0411977
R269 VSS.n6 VSS.n44 0.578278
R270 VSS.t6 VSS.n6 0.578278
R271 VSS.n44 VSS.n34 0.578278
R272 VSS.n43 VSS.n42 0.578278
R273 VSS.n42 VSS.t19 0.578278
R274 VSS.n43 VSS.n35 0.578278
R275 VSS.t20 VSS.n35 0.578278
R276 VSS.n12 VSS.t12 0.21952
R277 VSS.n15 VSS.n31 0.473227
R278 VSS.t12 VSS.n15 0.473227
R279 VSS.n30 VSS.n29 0.473227
R280 VSS.t20 VSS 0.468397
R281 VSS.t19 VSS.t6 0.425354
R282 VSS.n47 VSS.n46 0.347167
R283 VSS.n47 VSS 0.347167
R284 VSS.n25 VSS.t15 0.347167
R285 VSS.n25 VSS 0.347167
R286 VSS.t12 VSS.n14 0.292307
R287 VSS.t12 VSS.n11 0.244509
R288 VSS.n9 VSS 1.09754
R289 a_17709_651.n4 a_17709_651.n1 3.11239
R290 a_17709_651.n4 a_17709_651.t4 45.6196
R291 a_17709_651.t3 a_17709_651.n5 45.6301
R292 a_17709_651.t6 a_17709_651.n2 65.0393
R293 a_17709_651.n2 a_17709_651.t9 65.0393
R294 a_17709_651.n6 a_17709_651.t9 65.0393
R295 a_17709_651.n2 a_17709_651.t7 65.0393
R296 a_17709_651.n3 a_17709_651.t6 64.5456
R297 a_17709_651.t7 a_17709_651.n3 64.4445
R298 a_17709_651.n2 a_17709_651.t8 64.4445
R299 a_17709_651.t8 a_17709_651.n6 64.4445
R300 a_17709_651.n1 a_17709_651.n3 8.75032
R301 a_17709_651.n4 a_17709_651.n0 3.11239
R302 a_17709_651.n0 a_17709_651.n5 3.09135
R303 a_17709_651.t1 a_17709_651.t0 4.32289
R304 a_17709_651.n1 a_17709_651.n5 3.73365
R305 a_17709_651.n0 a_17709_651.t2 3.51349
R306 a_17709_651.n1 a_17709_651.t5 3.5037
R307 a_17709_651.t0 a_17709_651.n0 3.49051
R308 a_17709_651.n0 a_17709_651.t5 3.27682
R309 a_17709_651.t2 a_17709_651.n1 3.26005
R310 a_17709_651.n6 a_17709_651.n3 1.00368
C0 a_10131_2251# MINUS 0.09876f
C1 a_2230_900# MINUS 0
C2 a_4650_812# a_2182_2045# 0.00182f
C3 a_7014_1220# a_4650_812# 0.03516f
C4 x1.OUT a_10131_1943# 0.00262f
C5 a_2262_328# a_2230_900# 0.33125f
C6 a_10131_2251# PROG 0.39529f
C7 a_10131_2251# a_11307_1943# 0.13602f
C8 a_10131_2251# a_9446_2979# 0.87704f
C9 a_10131_2251# VDD 2.90546f
C10 VDD a_2230_900# 1.44482f
C11 a_3384_328# a_2182_2045# 0.00342f
C12 MINUS a_2182_2045# 0.45077f
C13 x1.OUT PROG 3.93071f
C14 a_11307_1943# x1.OUT 3.36766f
C15 a_7014_1220# MINUS 0.00957f
C16 a_9446_2979# x1.OUT 2.57866f
C17 x1.OUT CONTROL 2.99032f
C18 VDD x1.OUT 20.8169f
C19 a_3384_328# a_4650_812# 0.01245f
C20 x1.OUT DISABLE 12.7819f
C21 a_2262_328# a_2182_2045# 0.16355f
C22 PROG a_2182_2045# 0.08523f
C23 a_9446_2979# a_2182_2045# 0.00381f
C24 VDD a_2182_2045# 10.3895f
C25 a_7014_1220# VDD 0.01091f
C26 a_2262_328# a_4650_812# 0
C27 a_10131_2251# x1.OUT 0.00116f
C28 a_10131_1943# MINUS 0.09304f
C29 VDD a_4650_812# 0.00129f
C30 a_10131_2251# a_2182_2045# 0
C31 a_10131_1943# PROG 0.05935f
C32 a_11307_1943# a_10131_1943# 0.19212f
C33 a_2262_328# a_3384_328# 0.01906f
C34 a_9446_2979# a_10131_1943# 0.03677f
C35 a_2230_900# a_2182_2045# 0.86805f
C36 VDD a_10131_1943# 0.60506f
C37 a_7014_1220# a_2230_900# 0.04671f
C38 a_3384_328# VDD 0.00387f
C39 MINUS PROG 0.30802f
C40 a_9446_2979# MINUS 0.09759f
C41 VDD MINUS 2.57857f
C42 a_4650_812# a_2230_900# 0.49277f
C43 a_2262_328# VDD 0.00175f
C44 a_11307_1943# PROG 0.10906f
C45 a_9446_2979# PROG 0.42735f
C46 a_11307_1943# a_9446_2979# 0.1225f
C47 VDD PROG 8.16466f
C48 a_11307_1943# VDD 1.29718f
C49 a_10131_2251# a_10131_1943# 0.13302f
C50 a_9446_2979# VDD 9.7751f
C51 VDD CONTROL 7.91246f
C52 DISABLE PROG 0.11699f
C53 a_11307_1943# DISABLE 0
C54 a_7014_1220# a_2182_2045# 0.00755f
C55 a_9446_2979# DISABLE 0
C56 DISABLE CONTROL 12.588f
C57 VDD DISABLE 3.72157f
C58 a_3384_328# a_2230_900# 0.0341f
C59 CONTROL VSS 6.43101f
C60 DISABLE VSS 1.34471f
C61 PROG VSS 2.64423f
C62 VDD VSS 0.14429p
C63 a_3384_328# VSS 2.05066f
C64 a_4650_812# VSS 2.61081f
C65 a_7014_1220# VSS 2.36459f
C66 a_2262_328# VSS 1.60049f
C67 a_11307_1943# VSS 8.03487f
C68 a_10131_1943# VSS 1.91537f
C69 MINUS VSS 0.99228f
C70 a_10131_2251# VSS 0.01856f
C71 a_9446_2979# VSS 1.01219f
C72 a_2230_900# VSS 3.21605f
C73 a_2182_2045# VSS 1.53275f
C74 x1.OUT VSS 12.6302f
C75 a_17709_651.n0 VSS 4.1815f
C76 a_17709_651.t5 VSS 1.5592f
C77 a_17709_651.n1 VSS 4.51259f
C78 a_17709_651.n2 VSS 3.83213f
C79 a_17709_651.n3 VSS 2.28241f
C80 a_17709_651.t9 VSS 1.9589f
C81 a_17709_651.n6 VSS 1.91607f
C82 a_17709_651.t8 VSS 1.94142f
C83 a_17709_651.t7 VSS 1.94142f
C84 a_17709_651.t6 VSS 1.95162f
C85 a_17709_651.t2 VSS 1.57258f
C86 a_17709_651.t3 VSS 1.38926f
C87 a_17709_651.t4 VSS 1.38926f
C88 a_17709_651.t0 VSS 1.11092f
C89 a_17709_651.t1 VSS 0.56468f
C90 VDD.t35 VSS 23.4421f
C91 VDD.n0 VSS 0.46f
C92 VDD.n1 VSS 0.16458f
C93 VDD.n2 VSS 0.25052f
C94 VDD.t2 VSS 2.74843f
C95 VDD.n3 VSS 0.20808f
C96 VDD.t33 VSS 2.61477f
C97 VDD.t45 VSS 4.42093f
C98 VDD.n5 VSS 0.29056f
C99 VDD.n6 VSS 0.28035f
C100 VDD.n7 VSS 0.08735f
C101 VDD.n8 VSS 0.30015f
C102 VDD.t4 VSS 3.54231f
C103 VDD.n9 VSS 0.68378f
C104 VDD.t42 VSS 4.45109f
C105 VDD.t34 VSS 2.19266f
C106 VDD.n10 VSS 0.14338f
C107 VDD.n11 VSS 0.17262f
C108 VDD.n12 VSS 0.27318f
C109 VDD.n13 VSS 0.55208f
C110 VDD.t44 VSS 4.36064f
C111 VDD.t43 VSS 3.24015f
C112 VDD.n14 VSS 0.1362f
C113 VDD.n15 VSS 0.60537f
C114 VDD.t38 VSS 0.66998f
C115 VDD.n16 VSS 1.65432f
C116 VDD.n17 VSS 0.12152f
C117 VDD.n18 VSS 0.61377f
C118 VDD.n19 VSS 0.41127f
C119 VDD.t16 VSS 0.15191f
C120 VDD.t15 VSS 0.26389f
C121 VDD.t14 VSS 0.26389f
C122 VDD.t13 VSS 0.26389f
C123 VDD.t12 VSS 0.26389f
C124 VDD.t11 VSS 0.26389f
C125 VDD.t10 VSS 0.26389f
C126 VDD.t8 VSS 0.26389f
C127 VDD.t6 VSS 0.2609f
C128 VDD.n20 VSS 0.70812f
C129 VDD.t1 VSS 0.3371f
C130 VDD.t18 VSS 0.63742f
C131 VDD.t7 VSS 0.74689f
C132 VDD.t9 VSS 0.59001f
C133 VDD.n21 VSS 1.76346f
C134 VDD.t5 VSS 1.11894f
C135 VDD.t3 VSS 0.60037f
C136 VDD.t40 VSS 1.15514f
C137 VDD.t41 VSS 1.14173f
C138 VDD.n22 VSS 1.40011f
C139 VDD.n23 VSS 0.10554f
C140 VDD.n24 VSS 0.07788f
C141 VDD.n25 VSS 0.35187f
C142 VDD.t17 VSS 0.24392f
C143 VDD.t19 VSS 0.26389f
C144 VDD.t20 VSS 0.26389f
C145 VDD.t21 VSS 0.26389f
C146 VDD.t22 VSS 0.26389f
C147 VDD.t23 VSS 0.26389f
C148 VDD.t24 VSS 0.26389f
C149 VDD.t25 VSS 0.26389f
C150 VDD.t26 VSS 0.26389f
C151 VDD.t27 VSS 0.26389f
C152 VDD.t28 VSS 0.26389f
C153 VDD.t29 VSS 0.17795f
C154 VDD.n26 VSS 0.75535f
C155 VDD.t30 VSS 0.09115f
C156 VDD.n27 VSS 0.31527f
C157 VDD.t31 VSS 0.25569f
C158 VDD.n28 VSS 0.49705f
C159 VDD.n29 VSS 0.20036f
C160 VDD.n30 VSS 0.40719f
C161 VDD.n31 VSS 0.1362f
C162 VDD.n32 VSS 0.20706f
C163 VDD.n33 VSS 0.11133f
C164 VDD.n34 VSS 1.13287f
C165 VDD.t39 VSS 1.09633f
C166 VDD.t0 VSS 1.16082f
C167 VDD.t32 VSS 1.09633f
C168 VDD.n35 VSS 1.16082f
C169 VDD.n36 VSS 0.08978f
C170 VDD.n37 VSS 0.17302f
C171 VDD.n38 VSS 0.29126f
C172 VDD.n39 VSS 0.21532f
.ends
