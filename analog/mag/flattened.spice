* NGSPICE file created from flattened.ext - technology: gf180mcuD

.subckt flattened VDD VSS CTRL DISABLE CONTROL PROG
X0 PROG x1.OUT VDD.t75 VDD.t74 pfet_06v0 ad=0.52p pd=2.52u as=0.52p ps=2.52u w=2u l=1u
X1 x3.PLUS CTRL VSS.t41 ppolyf_u_1k_6p0 r_width=1u r_length=10u
X2 x3.OUT a_24139_n3109# CONTROL VSS nfet_06v0 ad=2.08p pd=8.52u as=3.52p ps=16.88u w=8u l=0.7u
X3 x3.MINUS x3.OUT VSS ppolyf_u_1k_6p0 r_width=1u r_length=10u
X4 PROG x1.OUT VDD.t63 VDD.t62 pfet_06v0 ad=0.52p pd=2.52u as=0.52p ps=2.52u w=2u l=1u
X5 x3.OUT DISABLE CONTROL VDD.t7 pfet_06v0 ad=3.52p pd=16.88u as=2.08p ps=8.52u w=8u l=0.7u
X6 x1.OUT x3.PLUS VSS ppolyf_u_1k_6p0 r_width=1u r_length=10u
X7 a_8033_n1509# PROG a_9209_n1817# VDD.t0 pfet_06v0 ad=1.76p pd=8.88u as=1.76p ps=8.88u w=4u l=1.1u
X8 a_164_n3434# a_1286_n3434# VSS ppolyf_u_1k_6p0 r_width=1u r_length=5u
X9 VSS a_18851_n1817# x3.OUT VSS nfet_06v0 ad=7.04p pd=32.88u as=4.16p ps=16.52u w=16u l=1.4u
X10 VDD.t45 x1.OUT PROG VDD.t44 pfet_06v0 ad=0.52p pd=2.52u as=0.52p ps=2.52u w=2u l=1u
X11 x3.OUT a_18851_n1817# VSS VSS nfet_06v0 ad=4.16p pd=16.52u as=4.16p ps=16.52u w=16u l=1.4u
X12 VSS a_9209_n1817# x1.OUT VSS nfet_06v0 ad=4.16p pd=16.52u as=4.16p ps=16.52u w=16u l=1.4u
X13 a_16990_n781# VSS.t5 VSS.t4 ppolyf_u_1k_6p0 r_width=1u r_length=11u
X14 VDD.t37 x1.OUT PROG VDD.t36 pfet_06v0 ad=0.52p pd=2.52u as=0.52p ps=2.52u w=2u l=1u
X15 VDD.t12 a_7348_n781# x1.OUT VDD.t9 pfet_06v0 ad=7.04p pd=32.88u as=4.16p ps=16.52u w=16u l=1.1u
X16 VDD.t69 x1.OUT PROG VDD.t68 pfet_06v0 ad=0.52p pd=2.52u as=0.52p ps=2.52u w=2u l=1u
X17 VDD.t3 a_24139_n3109# CONTROL VDD.t1 pfet_06v0 ad=2.08p pd=8.52u as=2.08p ps=8.52u w=8u l=0.7u
X18 a_18851_n1817# x3.OUT cap_mim_2f0_m4m5_noshield c_width=5u c_length=5u
X19 PROG x1.OUT VDD.t59 VDD.t58 pfet_06v0 ad=0.52p pd=2.52u as=0.52p ps=2.52u w=2u l=1u
X20 a_17675_n1509# x3.MINUS a_17675_n1817# VDD.t8 pfet_06v0 ad=1.76p pd=8.88u as=1.76p ps=8.88u w=4u l=1.1u
X21 a_9209_n1817# a_8033_n1817# VSS VSS.t27 nfet_06v0 ad=1.32p pd=6.88u as=1.32p ps=6.88u w=3u l=1.4u
X22 VDD a_84_n1717# a_84_n1717# VDD.t29 pfet_06v0 ad=4.4p pd=20.88u as=4.4p ps=20.88u w=10u l=5u
X23 VDD.t23 a_16990_n781# x3.OUT VDD.t24 pfet_06v0 ad=4.16p pd=16.52u as=4.16p ps=16.52u w=16u l=1.1u
D0 a_4916_n2542# VSS.t39 diode_pd2nw_06v0 pj=12u area=5p
X24 PROG x1.OUT VDD.t47 VDD.t46 pfet_06v0 ad=0.52p pd=2.52u as=0.52p ps=2.52u w=2u l=1u
X25 a_8033_n1509# MINUS a_8033_n1817# VDD.t0 pfet_06v0 ad=1.76p pd=8.88u as=1.76p ps=8.88u w=4u l=1.1u
X26 a_8033_n1817# a_8033_n1817# VSS VSS nfet_06v0 ad=1.32p pd=6.88u as=1.32p ps=6.88u w=3u l=1.4u
X27 VSS a_9209_n1817# x1.OUT VSS nfet_06v0 ad=7.04p pd=32.88u as=4.16p ps=16.52u w=16u l=1.4u
X28 VDD.t33 x1.OUT PROG VDD.t32 pfet_06v0 ad=0.88p pd=4.88u as=0.52p ps=2.52u w=2u l=1u
X29 VDD a_24139_n3109# CONTROL VDD.t1 pfet_06v0 ad=3.52p pd=16.88u as=2.08p ps=8.52u w=8u l=0.7u
X30 x1.OUT a_9209_n1817# VSS VSS nfet_06v0 ad=4.16p pd=16.52u as=4.16p ps=16.52u w=16u l=1.4u
X31 CONTROL a_24139_n3109# x3.OUT VSS nfet_06v0 ad=3.52p pd=16.88u as=2.08p ps=8.52u w=8u l=0.7u
X32 PROG x1.OUT VDD.t51 VDD.t50 pfet_06v0 ad=0.52p pd=2.52u as=0.52p ps=2.52u w=2u l=1u
X33 x3.OUT a_16990_n781# VDD.t26 VDD.t25 pfet_06v0 ad=4.16p pd=16.52u as=7.04p ps=32.88u w=16u l=1.1u
X34 a_7348_n781# VSS VSS.t32 ppolyf_u_1k_6p0 r_width=1u r_length=11u
X35 a_4916_n2542# MINUS VSS.t33 ppolyf_u_1k_6p0 r_width=1u r_length=5u
X36 VDD.t28 a_84_n1717# a_132_n2862# VDD.t27 pfet_06v0 ad=4.4p pd=20.88u as=4.4p ps=20.88u w=10u l=5u
X37 x3.OUT a_16990_n781# VDD.t23 VDD.t22 pfet_06v0 ad=4.16p pd=16.52u as=4.16p ps=16.52u w=16u l=1.1u
X38 a_17675_n1817# a_17675_n1817# VSS VSS nfet_06v0 ad=1.32p pd=6.88u as=1.32p ps=6.88u w=3u l=1.4u
X39 CONTROL a_24139_n3109# x3.OUT VSS nfet_06v0 ad=2.08p pd=8.52u as=2.08p ps=8.52u w=8u l=0.7u
X40 PROG x1.OUT VDD.t55 VDD.t54 pfet_06v0 ad=0.52p pd=2.52u as=0.52p ps=2.52u w=2u l=1u
X41 VDD.t61 x1.OUT PROG VDD.t60 pfet_06v0 ad=0.52p pd=2.52u as=0.52p ps=2.52u w=2u l=1u
X42 VDD.t14 a_7348_n781# x1.OUT VDD.t15 pfet_06v0 ad=4.16p pd=16.52u as=4.16p ps=16.52u w=16u l=1.1u
X43 PROG x1.OUT VDD.t43 VDD.t42 pfet_06v0 ad=0.52p pd=2.52u as=0.52p ps=2.52u w=2u l=1u
X44 CONTROL DISABLE x3.OUT VDD.t7 pfet_06v0 ad=2.08p pd=8.52u as=2.08p ps=8.52u w=8u l=0.7u
X45 VDD.t10 a_7348_n781# a_8033_n1509# VDD.t9 pfet_06v0 ad=3.52p pd=16.88u as=3.52p ps=16.88u w=8u l=1.1u
X46 VDD.t73 x1.OUT PROG VDD.t72 pfet_06v0 ad=0.52p pd=2.52u as=0.52p ps=2.52u w=2u l=1u
D1 a_2552_n2950# VSS diode_pd2nw_06v0 pj=12u area=5p
X47 x1.OUT a_7348_n781# VDD.t17 VDD.t16 pfet_06v0 ad=4.16p pd=16.52u as=7.04p ps=32.88u w=16u l=1.1u
X48 CONTROL DISABLE x3.OUT VDD.t7 pfet_06v0 ad=2.08p pd=8.52u as=3.52p ps=16.88u w=8u l=0.7u
X49 x3.OUT a_18851_n1817# VSS VSS nfet_06v0 ad=4.16p pd=16.52u as=7.04p ps=32.88u w=16u l=1.4u
X50 VDD.t19 a_16990_n781# x3.OUT VDD.t18 pfet_06v0 ad=7.04p pd=32.88u as=4.16p ps=16.52u w=16u l=1.1u
X51 a_84_n1717# a_132_n2862# a_164_n3434# VSS.t37 nfet_06v0 ad=4.4p pd=20.88u as=4.4p ps=20.88u w=10u l=2.5u
X52 x3.PLUS VSS cap_mim_2f0_m4m5_noshield c_width=5u c_length=5u
X53 x1.OUT a_7348_n781# VDD.t14 VDD.t13 pfet_06v0 ad=4.16p pd=16.52u as=4.16p ps=16.52u w=16u l=1.1u
X54 a_17675_n1509# x3.PLUS a_18851_n1817# VDD.t8 pfet_06v0 ad=1.76p pd=8.88u as=1.76p ps=8.88u w=4u l=1.1u
X55 PROG x1.OUT VDD.t39 VDD.t38 pfet_06v0 ad=0.52p pd=2.52u as=0.52p ps=2.52u w=2u l=1u
X56 PROG x1.OUT VDD.t67 VDD.t66 pfet_06v0 ad=0.52p pd=2.52u as=0.52p ps=2.52u w=2u l=1u
X57 VDD.t77 x1.OUT PROG VDD.t76 pfet_06v0 ad=0.52p pd=2.52u as=0.88p ps=4.88u w=2u l=1u
X58 a_24139_n3109# DISABLE VDD.t6 VDD.t5 pfet_06v0 ad=1.76p pd=8.88u as=1.76p ps=8.88u w=4u l=0.7u
X59 x3.MINUS VSS VSS ppolyf_u_1k_6p0 r_width=1u r_length=10u
X60 a_9209_n1817# x1.OUT cap_mim_2f0_m4m5_noshield c_width=5u c_length=5u
X61 VDD.t57 x1.OUT PROG VDD.t56 pfet_06v0 ad=0.52p pd=2.52u as=0.52p ps=2.52u w=2u l=1u
X62 VDD.t21 a_16990_n781# a_17675_n1509# VDD.t18 pfet_06v0 ad=3.52p pd=16.88u as=3.52p ps=16.88u w=8u l=1.1u
X63 VDD.t11 a_7348_n781# a_7348_n781# VDD.t9 pfet_06v0 ad=1.76p pd=8.88u as=1.76p ps=8.88u w=4u l=1.1u
X64 x3.OUT DISABLE CONTROL VDD.t7 pfet_06v0 ad=2.08p pd=8.52u as=2.08p ps=8.52u w=8u l=0.7u
X65 VDD.t65 x1.OUT PROG VDD.t64 pfet_06v0 ad=0.52p pd=2.52u as=0.52p ps=2.52u w=2u l=1u
X66 a_132_n2862# a_132_n2862# a_2552_n2950# VSS.t38 nfet_06v0 ad=4.4p pd=20.88u as=4.4p ps=20.88u w=10u l=2.5u
X67 a_18851_n1817# a_17675_n1817# VSS.t5 VSS.t5 nfet_06v0 ad=1.32p pd=6.88u as=1.32p ps=6.88u w=3u l=1.4u
X68 VDD.t49 x1.OUT PROG VDD.t48 pfet_06v0 ad=0.52p pd=2.52u as=0.52p ps=2.52u w=2u l=1u
X69 PROG x1.OUT VDD.t71 VDD.t70 pfet_06v0 ad=0.52p pd=2.52u as=0.52p ps=2.52u w=2u l=1u
X70 CONTROL a_24139_n3109# VDD.t2 VDD.t1 pfet_06v0 ad=2.08p pd=8.52u as=2.08p ps=8.52u w=8u l=0.7u
X71 x1.OUT a_9209_n1817# VSS VSS nfet_06v0 ad=4.16p pd=16.52u as=7.04p ps=32.88u w=16u l=1.4u
X72 VSS a_18851_n1817# x3.OUT VSS nfet_06v0 ad=4.16p pd=16.52u as=4.16p ps=16.52u w=16u l=1.4u
X73 PROG x1.OUT VDD.t35 VDD.t34 pfet_06v0 ad=0.52p pd=2.52u as=0.52p ps=2.52u w=2u l=1u
X74 VDD.t53 x1.OUT PROG VDD.t52 pfet_06v0 ad=0.52p pd=2.52u as=0.52p ps=2.52u w=2u l=1u
X75 a_24139_n3109# DISABLE VSS VSS.t16 nfet_06v0 ad=1.76p pd=8.88u as=1.76p ps=8.88u w=4u l=0.7u
X76 x3.OUT a_24139_n3109# CONTROL VSS nfet_06v0 ad=2.08p pd=8.52u as=2.08p ps=8.52u w=8u l=0.7u
X77 VDD.t41 x1.OUT PROG VDD.t40 pfet_06v0 ad=0.52p pd=2.52u as=0.52p ps=2.52u w=2u l=1u
D2 a_1286_n3434# VSS diode_pd2nw_06v0 pj=12u area=5p
X78 VDD.t31 a_84_n1717# MINUS VDD.t30 pfet_06v0 ad=4.4p pd=20.88u as=4.4p ps=20.88u w=10u l=5u
X79 VDD.t20 a_16990_n781# a_16990_n781# VDD.t18 pfet_06v0 ad=1.76p pd=8.88u as=1.76p ps=8.88u w=4u l=1.1u
X80 CONTROL a_24139_n3109# VDD.t4 VDD.t1 pfet_06v0 ad=2.08p pd=8.52u as=3.52p ps=16.88u w=8u l=0.7u
R0 VDD.t29 VDD.t27 1495.28
R1 VDD.t27 VDD.t30 1495.28
R2 VDD.t7 VDD.t1 1190.7
R3 VDD.n71 VDD.n17 1006.4
R4 VDD.n73 VDD.t30 790.434
R5 VDD.n8 VDD.n44 698.601
R6 VDD.n56 VDD.t7 616.279
R7 VDD.n8 VDD.n35 527.14
R8 VDD.t76 VDD.t74 333.334
R9 VDD.t70 VDD.t72 333.334
R10 VDD.t68 VDD.t70 333.334
R11 VDD.t66 VDD.t68 333.334
R12 VDD.t64 VDD.t66 333.334
R13 VDD.t62 VDD.t64 333.334
R14 VDD.t60 VDD.t62 333.334
R15 VDD.t58 VDD.t60 333.334
R16 VDD.t56 VDD.t58 333.334
R17 VDD.t54 VDD.t56 333.334
R18 VDD.t52 VDD.t54 333.334
R19 VDD.t50 VDD.t52 333.334
R20 VDD.t48 VDD.t50 333.334
R21 VDD.t46 VDD.t48 333.334
R22 VDD.t44 VDD.t46 333.334
R23 VDD.t42 VDD.t44 333.334
R24 VDD.t40 VDD.t42 333.334
R25 VDD.t38 VDD.t40 333.334
R26 VDD.t36 VDD.t38 333.334
R27 VDD.t34 VDD.t36 333.334
R28 VDD.t32 VDD.t34 333.334
R29 VDD.n44 VDD.t76 325.462
R30 VDD.n8 VDD.t32 325.462
R31 VDD.n71 VDD.t74 209.43
R32 VDD.t26 VDD.n46 196.875
R33 VDD.t17 VDD.n37 196.875
R34 VDD.n47 VDD 187.608
R35 VDD.t12 VDD.n39 75.5554
R36 VDD.n56 VDD.t5 154.651
R37 VDD.t26 VDD.n45 153.3
R38 VDD.t17 VDD.n36 153.3
R39 VDD.t12 VDD.n35 153.3
R40 VDD.t5 VDD.n17 148.256
R41 VDD.n72 VDD.t72 122.808
R42 VDD.n83 VDD.n82 122.48
R43 VDD.n34 VDD.n15 115.501
R44 VDD.n31 VDD.n29 115.501
R45 VDD VDD.n84 109.695
R46 VDD.n31 VDD 103.951
R47 VDD VDD.n31 103.951
R48 VDD VDD.n15 103.951
R49 VDD VDD.n15 103.951
R50 VDD.n85 VDD.n29 103.951
R51 VDD.n30 VDD.n29 103.951
R52 VDD.n34 VDD.n30 103.951
R53 VDD.n82 VDD.n34 103.951
R54 VDD.n19 VDD 99.2862
R55 VDD VDD.n42 75.6211
R56 VDD.n55 VDD.n49 89.4255
R57 VDD.n11 VDD.n10 83.3005
R58 VDD.n54 VDD.n53 83.3005
R59 VDD.n55 VDD.n54 83.3005
R60 VDD.n51 VDD.n50 83.3005
R61 VDD.n10 VDD.n51 83.3005
R62 VDD.n84 VDD.n2 78.7505
R63 VDD.n66 VDD.n46 57.0066
R64 VDD.n79 VDD.n37 57.0066
R65 VDD.n61 VDD.n21 55.69
R66 VDD.n54 VDD.n10 55.3005
R67 VDD.n83 VDD.n33 52.8479
R68 VDD.n63 VDD.n61 51.4505
R69 VDD.n66 VDD.n63 51.4505
R70 VDD.n22 VDD.n2 51.4505
R71 VDD.n38 VDD.n33 51.4505
R72 VDD.n79 VDD.n38 51.4505
R73 VDD.n36 VDD.n35 47.9774
R74 VDD.n63 VDD.n62 47.2505
R75 VDD VDD.n18 79.3575
R76 VDD.n24 VDD.n22 47.2505
R77 VDD.n74 VDD.n38 47.2505
R78 VDD.n68 VDD.t18 43.7148
R79 VDD.t18 VDD 43.7148
R80 VDD.n41 VDD.t9 43.7148
R81 VDD.t12 VDD.t9 43.7148
R82 VDD.t15 VDD.t0 42.8576
R83 VDD.n67 VDD.t25 40.2862
R84 VDD.n80 VDD.t16 40.2862
R85 VDD.n49 VDD.n47 40.2505
R86 VDD.n50 VDD.n45 40.2505
R87 VDD.t8 VDD.n60 36.8576
R88 VDD.n84 VDD.n83 33.9093
R89 VDD.n44 VDD.n36 30.8005
R90 VDD.n59 VDD.n45 28.7168
R91 VDD.n59 VDD.n47 28.7168
R92 VDD.n57 VDD.n50 25.7255
R93 VDD.n57 VDD.n49 25.7255
R94 VDD.t22 VDD.n17 23.1434
R95 VDD.n72 VDD.t13 23.1434
R96 VDD.n17 VDD.n70 22.2862
R97 VDD.n84 VDD.n5 20.2916
R98 VDD.n73 VDD.n72 13.0005
R99 VDD.n69 VDD.n42 9.58547
R100 VDD.n76 VDD.n39 9.58547
R101 VDD.n75 VDD.n73 9.28621
R102 VDD.n62 VDD.n18 9.07991
R103 VDD.n24 VDD.n74 9.07991
R104 VDD.n18 VDD.n21 8.44682
R105 VDD.n24 VDD.n23 8.44682
R106 VDD.n62 VDD.n43 6.09976
R107 VDD.n74 VDD.n40 6.09976
R108 VDD.n60 VDD.t24 6.0005
R109 VDD.n46 VDD.n42 4.22775
R110 VDD.n39 VDD.n37 4.22775
R111 VDD.t26 VDD.n67 3.60407
R112 VDD.t17 VDD.n80 3.60407
R113 VDD.t25 VDD.t8 3.42907
R114 VDD.t0 VDD.t16 3.42907
R115 VDD.n69 VDD.n26 0.440396
R116 VDD.n76 VDD.n3 0.440396
R117 VDD.n83 VDD.n23 2.84261
R118 VDD VDD.n87 2.63398
R119 VDD VDD.n32 2.63398
R120 VDD.n68 VDD.t22 2.57193
R121 VDD.t13 VDD.n41 2.57193
R122 VDD.n12 VDD.t14 2.37275
R123 VDD.n6 VDD.t23 2.37275
R124 VDD.n11 VDD.t2 2.3699
R125 VDD VDD.t33 2.238
R126 VDD.n86 VDD 2.23417
R127 VDD VDD.t67 2.00485
R128 VDD VDD.t71 2.00485
R129 VDD VDD.t75 2.00485
R130 VDD VDD.t35 2.00485
R131 VDD VDD.t39 2.00485
R132 VDD VDD.t43 2.00485
R133 VDD VDD.t47 2.00485
R134 VDD VDD.t51 2.00485
R135 VDD VDD.t55 2.00485
R136 VDD VDD.t59 2.00485
R137 VDD VDD.t63 2.00485
R138 VDD.n16 VDD 0.494934
R139 VDD.n19 VDD.n21 1.59208
R140 VDD.n23 VDD.n5 1.59208
R141 VDD.n52 VDD.n48 1.47253
R142 VDD.n78 VDD.n4 1.27568
R143 VDD.n65 VDD.n64 1.27568
R144 VDD.t12 VDD.n12 1.26277
R145 VDD VDD.t20 1.1055
R146 VDD.n58 VDD.t6 1.1055
R147 VDD VDD.t11 1.1055
R148 VDD.n72 VDD.n71 1.09699
R149 VDD.n0 VDD 1.06657
R150 VDD.n27 VDD.t17 0.963719
R151 VDD.t26 VDD.n13 0.963719
R152 VDD.n16 VDD.n52 1.65374
R153 VDD.t67 VDD.t69 0.9105
R154 VDD.t71 VDD.t73 0.9105
R155 VDD.t75 VDD.t77 0.9105
R156 VDD.t35 VDD.t37 0.9105
R157 VDD.t39 VDD.t41 0.9105
R158 VDD.t43 VDD.t45 0.9105
R159 VDD.t47 VDD.t49 0.9105
R160 VDD.t51 VDD.t53 0.9105
R161 VDD.t55 VDD.t57 0.9105
R162 VDD.t59 VDD.t61 0.9105
R163 VDD.t63 VDD.t65 0.9105
R164 VDD VDD.n8 0.9005
R165 VDD.n44 VDD.n7 0.9005
R166 VDD.n70 VDD.t24 0.857643
R167 VDD.n75 VDD.t15 0.857643
R168 VDD.n0 VDD.n27 0.804296
R169 VDD.n87 VDD.n86 0.775283
R170 VDD.n87 VDD.n28 0.775283
R171 VDD.n32 VDD.n28 0.775283
R172 VDD.n81 VDD.n32 0.775283
R173 VDD.n48 VDD.n13 0.741856
R174 VDD VDD.n9 0.733137
R175 VDD.n64 VDD.n20 0.703201
R176 VDD.n24 VDD 0.650433
R177 VDD.n20 VDD.n18 0.650433
R178 VDD.n78 VDD.n77 0.613151
R179 VDD.n65 VDD.n14 0.613151
R180 VDD.n58 VDD 0.600306
R181 VDD VDD.n7 0.578697
R182 VDD VDD.n2 0.229048
R183 VDD.n76 VDD.n75 0.573227
R184 VDD.n75 VDD.n24 0.573227
R185 VDD.n41 VDD.n5 0.573227
R186 VDD VDD.n5 0.573227
R187 VDD.n80 VDD.n33 0.573227
R188 VDD.n4 VDD.n33 0.573227
R189 VDD.n80 VDD.n79 0.573227
R190 VDD.n79 VDD.n78 0.573227
R191 VDD.n19 VDD.n68 0.573227
R192 VDD.n20 VDD.n19 0.573227
R193 VDD.n70 VDD.n18 0.573227
R194 VDD.n70 VDD.n69 0.573227
R195 VDD.n26 VDD.n25 0.0498883
R196 VDD.n60 VDD.n59 0.573227
R197 VDD.n59 VDD.n58 0.573227
R198 VDD.n57 VDD.n56 0.573227
R199 VDD.n9 VDD.n57 0.573227
R200 VDD.n67 VDD.n61 0.573227
R201 VDD.n64 VDD.n61 0.573227
R202 VDD.n67 VDD.n66 0.573227
R203 VDD.n66 VDD.n65 0.573227
R204 VDD VDD.n6 0.570265
R205 VDD.n6 VDD.t26 0.568352
R206 VDD.t17 VDD.n12 0.568352
R207 VDD.n27 VDD.n7 0.55728
R208 VDD.n11 VDD.t4 0.533882
R209 VDD VDD.t21 0.533882
R210 VDD VDD.t10 0.533882
R211 VDD.n9 VDD.n48 0.454314
R212 VDD VDD.t31 0.430119
R213 VDD VDD.t28 0.430119
R214 VDD.n11 VDD.t1 0.332683
R215 VDD.n41 VDD.n40 0.332079
R216 VDD.n40 VDD.n3 0.255387
R217 VDD.n68 VDD.n43 0.332079
R218 VDD.n26 VDD.n43 0.255387
R219 VDD.t7 VDD.n51 0.332079
R220 VDD.n52 VDD.n51 0.332079
R221 VDD.t7 VDD.n55 0.332079
R222 VDD VDD.n1 0.174085
R223 VDD.n53 VDD.t1 0.331788
R224 VDD.n77 VDD 0.318474
R225 VDD.n25 VDD.n14 0.318474
R226 VDD.n58 VDD.n13 0.317656
R227 VDD.t12 VDD.n0 0.312292
R228 VDD VDD.n4 0.696985
R229 VDD.n25 VDD.n20 0.277568
R230 VDD.n85 VDD.t29 0.263787
R231 VDD.n86 VDD.n85 0.263
R232 VDD.t27 VDD.n30 0.263
R233 VDD.n30 VDD.n28 0.263
R234 VDD.n82 VDD.t30 0.263
R235 VDD.n82 VDD.n81 0.263
R236 VDD.t2 VDD.t3 0.228
R237 VDD.n81 VDD 1.32975
R238 VDD.t26 VDD.n14 0.966495
R239 VDD.n77 VDD.t17 0.966495
R240 VDD.n55 VDD 0.879638
R241 VDD.n16 VDD.n11 0.838081
R242 VDD.n53 VDD 0.836512
R243 VDD.n20 VDD 0.814664
R244 VDD.t29 VDD 0.805539
R245 VDD.t27 VDD 0.805464
R246 VDD VDD.t30 0.752605
R247 VDD VDD.t19 0.735521
R248 VDD.t12 VDD.n1 0.174397
R249 VDD VDD.n3 0.641816
R250 VDD.n22 VDD.n1 86.5303
R251 VSS.n4 VSS.n28 4152.78
R252 VSS VSS.n4 2.50008
R253 VSS.n27 VSS.n2 4152.78
R254 VSS VSS.n2 4311.48
R255 VSS.n28 VSS.n14 4014.61
R256 VSS.n28 VSS.n27 2682.11
R257 VSS.n27 VSS.n26 2497.37
R258 VSS.n5 VSS.n11 25.1139
R259 VSS VSS.n3 1.72576
R260 VSS.t37 VSS.n14 671.354
R261 VSS VSS.t4 35.2066
R262 VSS.t41 VSS.n19 242.696
R263 VSS VSS.t41 242.696
R264 VSS.t16 VSS.n9 232.466
R265 VSS.n5 VSS.t16 232.331
R266 VSS VSS.n10 231.988
R267 VSS.n18 VSS.t33 200.083
R268 VSS.n26 VSS.n3 195.435
R269 VSS.t37 VSS.n12 0.543999
R270 VSS VSS.n22 186.279
R271 VSS.n21 VSS.n20 178.112
R272 VSS VSS.n8 1.06407
R273 VSS VSS.n7 169.587
R274 VSS.n22 VSS.n21 152.445
R275 VSS.n18 VSS.n16 147.879
R276 VSS VSS.n13 129.624
R277 VSS.t33 VSS.t38 123.106
R278 VSS VSS.n24 122.695
R279 VSS.n23 VSS.n19 118.213
R280 VSS VSS.n13 116.59
R281 VSS.n12 VSS 196.617
R282 VSS.t37 VSS.n15 115.501
R283 VSS.n18 VSS.n15 115.501
R284 VSS VSS.n11 87.2981
R285 VSS.n26 VSS 94.968
R286 VSS.n24 VSS 81.3755
R287 VSS.n30 VSS.n15 79.7227
R288 VSS.n20 VSS 77.5838
R289 VSS VSS.n0 77.1623
R290 VSS VSS.n16 53.1767
R291 VSS.n0 VSS 1.89167
R292 VSS VSS.t27 1.36732
R293 VSS.n11 VSS.n10 47.4184
R294 VSS.n25 VSS.n8 73.6996
R295 VSS.n1 VSS.n7 18.6433
R296 VSS.n24 VSS.n23 41.3199
R297 VSS.n26 VSS 39.1048
R298 VSS VSS.t32 36.933
R299 VSS.n26 VSS.t38 37.6565
R300 VSS VSS.n31 37.4797
R301 VSS.n9 VSS.n10 35.18
R302 VSS VSS.n14 34.3825
R303 VSS.n22 VSS.n2 33.8338
R304 VSS.n31 VSS.n3 33.8338
R305 VSS.n21 VSS.n4 33.8338
R306 VSS.n29 VSS.n4 33.8338
R307 VSS.n30 VSS.n29 28.7297
R308 VSS.n5 VSS.n25 28.5838
R309 VSS.n31 VSS.n30 28.438
R310 VSS.n23 VSS 95.3496
R311 VSS.n6 VSS.n16 22.5691
R312 VSS.n29 VSS 14.5838
R313 VSS.n6 VSS.n13 2.6005
R314 VSS VSS.n6 2.6005
R315 VSS VSS.t37 1.92997
R316 VSS VSS.n17 1.65572
R317 VSS VSS.n25 92.787
R318 VSS.n7 VSS.n6 12.8824
R319 VSS.n0 VSS.t5 0.425021
R320 VSS.n20 VSS.n3 2.03383
R321 VSS VSS.t5 1.77665
R322 VSS.n18 VSS 1.54404
R323 VSS.t37 VSS.n17 1.05911
R324 VSS.n8 VSS.n9 0.220563
R325 VSS.n18 VSS.n17 1.27578
R326 VSS VSS.n5 1.70671
R327 VSS.n19 VSS 1.62307
R328 VSS.n2 VSS.n1 1.24708
R329 VSS.n1 VSS 1.21965
R330 VSS.t39 VSS 1.16868
R331 VSS.n12 VSS 1.10473
C0 a_84_n1717# a_132_n2862# 0.86805f
C1 a_8033_n1509# a_7348_n781# 0.87704f
C2 a_17675_n1817# VDD 0.60505f
C3 a_8033_n1509# MINUS 0.09876f
C4 a_9209_n1817# a_8033_n1509# 0.13602f
C5 a_18851_n1817# CONTROL 0
C6 PROG a_7348_n781# 0.31768f
C7 a_18851_n1817# a_24139_n3109# 0.0053f
C8 x3.PLUS x1.OUT 0.04626f
C9 a_8033_n1509# VDD 2.91374f
C10 a_18851_n1817# a_16990_n781# 0.1225f
C11 x3.PLUS x3.MINUS 0.59633f
C12 a_8033_n1817# a_7348_n781# 0.03677f
C13 PROG MINUS 0.30791f
C14 a_9209_n1817# PROG 0.1017f
C15 a_164_n3434# a_132_n2862# 0.33125f
C16 PROG VDD 10.2263f
C17 x3.OUT x3.PLUS 0.00332f
C18 a_8033_n1817# MINUS 0.09313f
C19 a_9209_n1817# a_8033_n1817# 0.19212f
C20 a_2552_n2950# VDD 0.00134f
C21 a_18851_n1817# VDD 1.30554f
C22 x1.OUT a_7348_n781# 2.52611f
C23 a_18851_n1817# DISABLE 0.03942f
C24 a_8033_n1817# VDD 0.60505f
C25 x3.MINUS a_16990_n781# 0.23109f
C26 a_8033_n1509# a_84_n1717# 0
C27 x3.OUT CONTROL 6.00622f
C28 a_9209_n1817# x1.OUT 3.22121f
C29 x3.OUT a_24139_n3109# 1.49503f
C30 x3.OUT a_16990_n781# 2.56912f
C31 x1.OUT VDD 16.7694f
C32 x3.PLUS a_16990_n781# 0.06348f
C33 a_2552_n2950# a_4916_n2542# 0.03516f
C34 x3.MINUS VDD 0.81912f
C35 a_84_n1717# PROG 0.08501f
C36 a_2552_n2950# a_84_n1717# 0.00182f
C37 a_24139_n3109# CONTROL 3.22628f
C38 a_9209_n1817# x3.PLUS 0.0179f
C39 CONTROL a_16990_n781# 0
C40 x3.OUT VDD 8.28565f
C41 a_1286_n3434# VDD 0.00404f
C42 x3.PLUS VDD 1.2777f
C43 x3.OUT DISABLE 1.87068f
C44 a_24139_n3109# a_16990_n781# 0.00122f
C45 CONTROL VDD 6.05081f
C46 a_7348_n781# MINUS 0.10613f
C47 a_9209_n1817# a_7348_n781# 0.1225f
C48 DISABLE CONTROL 1.15569f
C49 a_24139_n3109# VDD 4.01192f
C50 DISABLE a_24139_n3109# 1.38826f
C51 a_2552_n2950# a_164_n3434# 0
C52 a_7348_n781# VDD 9.79245f
C53 a_16990_n781# VDD 9.8486f
C54 DISABLE a_16990_n781# 0.0207f
C55 a_17675_n1509# a_17675_n1817# 0.13302f
C56 a_84_n1717# a_1286_n3434# 0.00342f
C57 VDD MINUS 2.57658f
C58 a_9209_n1817# VDD 1.30554f
C59 a_2552_n2950# a_132_n2862# 0.49277f
C60 DISABLE VDD 3.06101f
C61 a_84_n1717# a_7348_n781# 0.00375f
C62 a_18851_n1817# a_17675_n1509# 0.13602f
C63 a_4916_n2542# MINUS 0.00957f
C64 a_164_n3434# a_1286_n3434# 0.01906f
C65 a_84_n1717# MINUS 0.45182f
C66 a_4916_n2542# VDD 0.01082f
C67 a_84_n1717# VDD 10.3888f
C68 a_18851_n1817# a_17675_n1817# 0.19212f
C69 a_1286_n3434# a_132_n2862# 0.0341f
C70 a_17675_n1509# x3.MINUS 0.09876f
C71 a_8033_n1509# PROG 0.37836f
C72 a_8033_n1509# a_8033_n1817# 0.13302f
C73 a_84_n1717# a_4916_n2542# 0.00755f
C74 x3.OUT a_17675_n1509# 0.00116f
C75 x3.PLUS a_17675_n1509# 0.33888f
C76 a_17675_n1817# x3.MINUS 0.09306f
C77 a_164_n3434# VDD 0.00179f
C78 a_8033_n1817# PROG 0.05935f
C79 a_8033_n1509# x1.OUT 0.00116f
C80 x3.OUT a_17675_n1817# 0.00262f
C81 a_132_n2862# MINUS 0
C82 x3.PLUS a_17675_n1817# 0.05966f
C83 a_132_n2862# VDD 1.44136f
C84 a_17675_n1509# a_16990_n781# 0.87704f
C85 x1.OUT PROG 4.15782f
C86 x1.OUT a_8033_n1817# 0.00262f
C87 a_164_n3434# a_84_n1717# 0.16355f
C88 a_17675_n1817# a_16990_n781# 0.03677f
C89 a_17675_n1509# VDD 2.91656f
C90 x3.PLUS PROG 0.01609f
C91 a_2552_n2950# a_1286_n3434# 0.01245f
C92 x3.OUT a_18851_n1817# 3.4497f
C93 a_4916_n2542# a_132_n2862# 0.04671f
C94 a_18851_n1817# x3.PLUS 0.10026f
C95 CTRL VSS 1.15902f
C96 CONTROL VSS 2.29254f
C97 DISABLE VSS 2.21478f
C98 PROG VSS 2.09056f
C99 VDD VSS 0.21894p
C100 a_1286_n3434# VSS 2.03486f
C101 a_2552_n2950# VSS 2.60738f
C102 a_4916_n2542# VSS 2.35673f
C103 a_164_n3434# VSS 1.59894f
C104 a_24139_n3109# VSS 4.77808f
C105 a_18851_n1817# VSS 7.97712f
C106 x3.PLUS VSS 4.32966f
C107 a_17675_n1817# VSS 1.91353f
C108 x3.MINUS VSS 2.29902f
C109 x3.OUT VSS 6.85238f
C110 a_17675_n1509# VSS 0.05492f
C111 a_16990_n781# VSS 0.95207f
C112 a_9209_n1817# VSS 8.0017f
C113 a_8033_n1817# VSS 1.91573f
C114 MINUS VSS 1.00753f
C115 a_8033_n1509# VSS 0.01762f
C116 a_7348_n781# VSS 1.01125f
C117 a_132_n2862# VSS 3.21535f
C118 a_84_n1717# VSS 1.5293f
C119 x1.OUT VSS 5.27976f
C120 VDD.n0 VSS 1.83579f
C121 VDD.n1 VSS 0.06712f
C122 VDD.t12 VSS 2.78723f
C123 VDD.n2 VSS 0.04731f
C124 VDD.t10 VSS 0.08555f
C125 VDD.t30 VSS 2.50638f
C126 VDD.n4 VSS 0.08035f
C127 VDD.t28 VSS 0.10724f
C128 VDD.t31 VSS 0.10724f
C129 VDD.n5 VSS 0.07615f
C130 VDD.t21 VSS 0.08555f
C131 VDD.n6 VSS 1.11901f
C132 VDD.t19 VSS 0.17109f
C133 VDD.n7 VSS 0.03305f
C134 VDD.n8 VSS 0.61302f
C135 VDD.n9 VSS 0.07787f
C136 VDD.t1 VSS 3.10741f
C137 VDD.n10 VSS 0.14309f
C138 VDD.t4 VSS 0.08555f
C139 VDD.n11 VSS 0.7344f
C140 VDD.n12 VSS 1.21164f
C141 VDD.t17 VSS 1.4574f
C142 VDD.n13 VSS 0.15846f
C143 VDD.n14 VSS 0.31787f
C144 VDD.t26 VSS 1.4574f
C145 VDD.n15 VSS 0.11557f
C146 VDD.n16 VSS 0.12269f
C147 VDD.n17 VSS 2.45176f
C148 VDD.n18 VSS 0.24655f
C149 VDD.n19 VSS 0.10573f
C150 VDD.n20 VSS 0.74958f
C151 VDD.t23 VSS 0.40093f
C152 VDD.t14 VSS 0.40093f
C153 VDD.n21 VSS 0.59909f
C154 VDD.n22 VSS 0.06623f
C155 VDD.n23 VSS 0.23208f
C156 VDD.n24 VSS 0.21977f
C157 VDD.n25 VSS 0.49133f
C158 VDD.n27 VSS 0.25584f
C159 VDD.t29 VSS 3.37313f
C160 VDD.n28 VSS 0.1424f
C161 VDD.n29 VSS 0.11557f
C162 VDD.n30 VSS 0.07429f
C163 VDD.n31 VSS 0.11557f
C164 VDD.n32 VSS 0.16929f
C165 VDD.n33 VSS 0.05085f
C166 VDD.n34 VSS 0.11557f
C167 VDD.t9 VSS 1.86049f
C168 VDD.n35 VSS 0.39211f
C169 VDD.n36 VSS 0.21538f
C170 VDD.n37 VSS 0.29735f
C171 VDD.t16 VSS 0.93024f
C172 VDD.n38 VSS 0.05366f
C173 VDD.n39 VSS 0.3351f
C174 VDD.n40 VSS 0.10419f
C175 VDD.n41 VSS 0.98496f
C176 VDD.t13 VSS 0.5472f
C177 VDD.t72 VSS 0.16477f
C178 VDD.t74 VSS 0.19605f
C179 VDD.t24 VSS 0.14592f
C180 VDD.n42 VSS 0.33513f
C181 VDD.n43 VSS 0.10419f
C182 VDD.t20 VSS 0.04341f
C183 VDD.t63 VSS 0.03232f
C184 VDD.t65 VSS 0.00903f
C185 VDD.t59 VSS 0.03232f
C186 VDD.t61 VSS 0.00903f
C187 VDD.t55 VSS 0.03232f
C188 VDD.t57 VSS 0.00903f
C189 VDD.t51 VSS 0.03232f
C190 VDD.t53 VSS 0.00903f
C191 VDD.t47 VSS 0.03232f
C192 VDD.t49 VSS 0.00903f
C193 VDD.t43 VSS 0.03232f
C194 VDD.t45 VSS 0.00903f
C195 VDD.t39 VSS 0.03232f
C196 VDD.t41 VSS 0.00903f
C197 VDD.t35 VSS 0.03232f
C198 VDD.t37 VSS 0.00903f
C199 VDD.t33 VSS 0.02217f
C200 VDD.t76 VSS 0.23812f
C201 VDD.n44 VSS 0.43354f
C202 VDD.t70 VSS 0.24081f
C203 VDD.t68 VSS 0.24081f
C204 VDD.t66 VSS 0.24081f
C205 VDD.t64 VSS 0.24081f
C206 VDD.t62 VSS 0.24081f
C207 VDD.t60 VSS 0.24081f
C208 VDD.t58 VSS 0.24081f
C209 VDD.t56 VSS 0.24081f
C210 VDD.t54 VSS 0.24081f
C211 VDD.t52 VSS 0.24081f
C212 VDD.t50 VSS 0.24081f
C213 VDD.t48 VSS 0.24081f
C214 VDD.t46 VSS 0.24081f
C215 VDD.t44 VSS 0.24081f
C216 VDD.t42 VSS 0.24081f
C217 VDD.t40 VSS 0.24081f
C218 VDD.t38 VSS 0.24081f
C219 VDD.t36 VSS 0.24081f
C220 VDD.t34 VSS 0.24081f
C221 VDD.t32 VSS 0.23812f
C222 VDD.t67 VSS 0.03232f
C223 VDD.t69 VSS 0.00903f
C224 VDD.t71 VSS 0.03232f
C225 VDD.t73 VSS 0.00903f
C226 VDD.t75 VSS 0.03232f
C227 VDD.t77 VSS 0.00903f
C228 VDD.n45 VSS 0.10614f
C229 VDD.n46 VSS 0.29735f
C230 VDD.n47 VSS 0.11901f
C231 VDD.n48 VSS 0.07064f
C232 VDD.n49 VSS 0.08864f
C233 VDD.n50 VSS 0.08543f
C234 VDD.n51 VSS 0.05954f
C235 VDD.t2 VSS 0.26724f
C236 VDD.t3 VSS 0.03613f
C237 VDD.n52 VSS 0.06455f
C238 VDD.n53 VSS 0.13108f
C239 VDD.n54 VSS 0.14309f
C240 VDD.n55 VSS 0.06183f
C241 VDD.t7 VSS 2.3216f
C242 VDD.t5 VSS 0.38917f
C243 VDD.n56 VSS 0.99049f
C244 VDD.n57 VSS 0.07354f
C245 VDD.t6 VSS 0.04341f
C246 VDD.n58 VSS 0.18091f
C247 VDD.n59 VSS 0.06588f
C248 VDD.n60 VSS 0.912f
C249 VDD.t8 VSS 0.85728f
C250 VDD.t25 VSS 0.93024f
C251 VDD.n61 VSS 0.07059f
C252 VDD.n62 VSS 0.19106f
C253 VDD.n63 VSS 0.05366f
C254 VDD.n64 VSS 0.08059f
C255 VDD.n65 VSS 0.06276f
C256 VDD.n66 VSS 0.0507f
C257 VDD.n67 VSS 0.96125f
C258 VDD.t18 VSS 1.86049f
C259 VDD.t22 VSS 0.5472f
C260 VDD.n68 VSS 0.98496f
C261 VDD.n69 VSS 0.1555f
C262 VDD.n70 VSS 0.48944f
C263 VDD.n71 VSS 1.36756f
C264 VDD.n72 VSS 0.81388f
C265 VDD.n73 VSS 1.34099f
C266 VDD.n74 VSS 0.19106f
C267 VDD.t0 VSS 0.98496f
C268 VDD.t15 VSS 0.93024f
C269 VDD.n75 VSS 0.21584f
C270 VDD.n76 VSS 0.1555f
C271 VDD.n77 VSS 0.31787f
C272 VDD.n78 VSS 0.06276f
C273 VDD.n79 VSS 0.0507f
C274 VDD.n80 VSS 0.96125f
C275 VDD.t11 VSS 0.04341f
C276 VDD.n81 VSS 0.19277f
C277 VDD.n82 VSS 0.08519f
C278 VDD.n83 VSS 0.51351f
C279 VDD.n84 VSS 0.13904f
C280 VDD.t27 VSS 3.27927f
C281 VDD.n85 VSS 0.15497f
C282 VDD.n86 VSS 0.23307f
C283 VDD.n87 VSS 0.16929f
.ends
